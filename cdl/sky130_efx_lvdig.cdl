* Copyright (c) 2026 Eric Fogleman
* SPDX-License-Identifier: Apache-2.0
* Derived from SkyWater sky130_fd_sc_hd (Apache-2.0); see NOTICE
*
* sky130_efx_lvdig standard cells: schematic (source) netlist, one .subckt per
* cell from the xschem schematics in xschem/ (generated by `make libcdl`; don't
* edit). The reference side of LVS, as the PDK's cdl/. Layout-extracted
* netlists: spice/sky130_efx_lvdig{,_c,_rc}.spice (make libspice PEX=none|c|rc).
*
* Cell topologies and device sizes are derived from SkyWater's sky130_fd_sc_hd
* (Apache-2.0; see NOTICE). Layouts are independent.
*
* Not interchangeable with the PDK's sky130_fd_sc_hd netlists:
*  - device widths are on the efx lambda grid (L = 0.18 um; e.g. 0.42 -> 0.45,
*    0.65 -> 0.63, 1.00 -> 1.08), conb_1's resistors W 0.45 x L 0.54
*  - ports: logic pins, then VGND VNB VPB VPWR (hd: power pins in between),
*    so instantiate by the .subckt lines below, not by hd's pin order
* Devices are sky130_fd_pr models; include the PDK model library first, e.g.
*   .lib $PDK_ROOT/sky130A/libs.tech/ngspice/sky130.lib.spice tt

.subckt sky130_efx_lvdig__a21o_1 A1 A2 B1 X VGND VNB VPB VPWR
*.PININFO X:O A1:I A2:I B1:I VGND:B VNB:B VPB:B VPWR:B
XM0 net1 B1 net2 VPB sky130_fd_pr__pfet_01v8_hvt L=0.15 W=1.08 nf=1 ad=0.3132 as=0.3132 pd=2.74 ps=2.74 nrd=0.268518518518518
+ nrs=0.268518518518518 sa=0 sb=0 sd=0 mult=1 m=1
XM1 net2 A1 VPWR VPB sky130_fd_pr__pfet_01v8_hvt L=0.15 W=1.08 nf=1 ad=0.3132 as=0.3132 pd=2.74 ps=2.74 nrd=0.268518518518518
+ nrs=0.268518518518518 sa=0 sb=0 sd=0 mult=1 m=1
XM2 net2 A2 VPWR VPB sky130_fd_pr__pfet_01v8_hvt L=0.15 W=1.08 nf=1 ad=0.3132 as=0.3132 pd=2.74 ps=2.74 nrd=0.268518518518518
+ nrs=0.268518518518518 sa=0 sb=0 sd=0 mult=1 m=1
XM3 net1 A1 net3 VNB sky130_fd_pr__nfet_01v8 L=0.15 W=0.63 nf=1 ad=0.1827 as=0.1827 pd=1.84 ps=1.84 nrd=0.46031746031746
+ nrs=0.46031746031746 sa=0 sb=0 sd=0 mult=1 m=1
XM4 net3 A2 VGND VNB sky130_fd_pr__nfet_01v8 L=0.15 W=0.63 nf=1 ad=0.1827 as=0.1827 pd=1.84 ps=1.84 nrd=0.46031746031746
+ nrs=0.46031746031746 sa=0 sb=0 sd=0 mult=1 m=1
XM5 net1 B1 VGND VNB sky130_fd_pr__nfet_01v8 L=0.15 W=0.63 nf=1 ad=0.1827 as=0.1827 pd=1.84 ps=1.84 nrd=0.46031746031746
+ nrs=0.46031746031746 sa=0 sb=0 sd=0 mult=1 m=1
XM6 X net1 VPWR VPB sky130_fd_pr__pfet_01v8_hvt L=0.15 W=1.08 nf=1 ad=0.3132 as=0.3132 pd=2.74 ps=2.74 nrd=0.268518518518518
+ nrs=0.268518518518518 sa=0 sb=0 sd=0 mult=1 m=1
XM7 X net1 VGND VNB sky130_fd_pr__nfet_01v8 L=0.15 W=0.63 nf=1 ad=0.1827 as=0.1827 pd=1.84 ps=1.84 nrd=0.46031746031746
+ nrs=0.46031746031746 sa=0 sb=0 sd=0 mult=1 m=1
.ends

.subckt sky130_efx_lvdig__a22o_1 A1 A2 B1 B2 X VGND VNB VPB VPWR
*.PININFO X:O A1:I A2:I B1:I B2:I VGND:B VNB:B VPB:B VPWR:B
XM0 net1 B1 net2 VPB sky130_fd_pr__pfet_01v8_hvt L=0.15 W=1.08 nf=1 ad=0.3132 as=0.3132 pd=2.74 ps=2.74 nrd=0.268518518518518
+ nrs=0.268518518518518 sa=0 sb=0 sd=0 mult=1 m=1
XM1 net1 B2 net2 VPB sky130_fd_pr__pfet_01v8_hvt L=0.15 W=1.08 nf=1 ad=0.3132 as=0.3132 pd=2.74 ps=2.74 nrd=0.268518518518518
+ nrs=0.268518518518518 sa=0 sb=0 sd=0 mult=1 m=1
XM2 net2 A1 VPWR VPB sky130_fd_pr__pfet_01v8_hvt L=0.15 W=1.08 nf=1 ad=0.3132 as=0.3132 pd=2.74 ps=2.74 nrd=0.268518518518518
+ nrs=0.268518518518518 sa=0 sb=0 sd=0 mult=1 m=1
XM3 net2 A2 VPWR VPB sky130_fd_pr__pfet_01v8_hvt L=0.15 W=1.08 nf=1 ad=0.3132 as=0.3132 pd=2.74 ps=2.74 nrd=0.268518518518518
+ nrs=0.268518518518518 sa=0 sb=0 sd=0 mult=1 m=1
XM4 net1 A1 net3 VNB sky130_fd_pr__nfet_01v8 L=0.15 W=0.63 nf=1 ad=0.1827 as=0.1827 pd=1.84 ps=1.84 nrd=0.46031746031746
+ nrs=0.46031746031746 sa=0 sb=0 sd=0 mult=1 m=1
XM5 net3 A2 VGND VNB sky130_fd_pr__nfet_01v8 L=0.15 W=0.63 nf=1 ad=0.1827 as=0.1827 pd=1.84 ps=1.84 nrd=0.46031746031746
+ nrs=0.46031746031746 sa=0 sb=0 sd=0 mult=1 m=1
XM6 net1 B1 net4 VNB sky130_fd_pr__nfet_01v8 L=0.15 W=0.63 nf=1 ad=0.1827 as=0.1827 pd=1.84 ps=1.84 nrd=0.46031746031746
+ nrs=0.46031746031746 sa=0 sb=0 sd=0 mult=1 m=1
XM7 net4 B2 VGND VNB sky130_fd_pr__nfet_01v8 L=0.15 W=0.63 nf=1 ad=0.1827 as=0.1827 pd=1.84 ps=1.84 nrd=0.46031746031746
+ nrs=0.46031746031746 sa=0 sb=0 sd=0 mult=1 m=1
XM8 X net1 VPWR VPB sky130_fd_pr__pfet_01v8_hvt L=0.15 W=1.08 nf=1 ad=0.3132 as=0.3132 pd=2.74 ps=2.74 nrd=0.268518518518518
+ nrs=0.268518518518518 sa=0 sb=0 sd=0 mult=1 m=1
XM9 X net1 VGND VNB sky130_fd_pr__nfet_01v8 L=0.15 W=0.63 nf=1 ad=0.1827 as=0.1827 pd=1.84 ps=1.84 nrd=0.46031746031746
+ nrs=0.46031746031746 sa=0 sb=0 sd=0 mult=1 m=1
.ends

.subckt sky130_efx_lvdig__and2_1 A B X VGND VNB VPB VPWR
*.PININFO X:O A:I B:I VGND:B VNB:B VPB:B VPWR:B
XM0 net1 A VPWR VPB sky130_fd_pr__pfet_01v8_hvt L=0.15 W=0.45 nf=1 ad=0.1305 as=0.1305 pd=1.48 ps=1.48 nrd=0.644444444444444
+ nrs=0.644444444444444 sa=0 sb=0 sd=0 mult=1 m=1
XM1 net1 B VPWR VPB sky130_fd_pr__pfet_01v8_hvt L=0.15 W=0.45 nf=1 ad=0.1305 as=0.1305 pd=1.48 ps=1.48 nrd=0.644444444444444
+ nrs=0.644444444444444 sa=0 sb=0 sd=0 mult=1 m=1
XM2 net1 A net2 VNB sky130_fd_pr__nfet_01v8 L=0.15 W=0.45 nf=1 ad=0.1305 as=0.1305 pd=1.48 ps=1.48 nrd=0.644444444444444
+ nrs=0.644444444444444 sa=0 sb=0 sd=0 mult=1 m=1
XM3 net2 B VGND VNB sky130_fd_pr__nfet_01v8 L=0.15 W=0.45 nf=1 ad=0.1305 as=0.1305 pd=1.48 ps=1.48 nrd=0.644444444444444
+ nrs=0.644444444444444 sa=0 sb=0 sd=0 mult=1 m=1
XM4 X net1 VPWR VPB sky130_fd_pr__pfet_01v8_hvt L=0.15 W=1.08 nf=1 ad=0.3132 as=0.3132 pd=2.74 ps=2.74 nrd=0.268518518518518
+ nrs=0.268518518518518 sa=0 sb=0 sd=0 mult=1 m=1
XM5 X net1 VGND VNB sky130_fd_pr__nfet_01v8 L=0.15 W=0.63 nf=1 ad=0.1827 as=0.1827 pd=1.84 ps=1.84 nrd=0.46031746031746
+ nrs=0.46031746031746 sa=0 sb=0 sd=0 mult=1 m=1
.ends

.subckt sky130_efx_lvdig__and2_2 A B X VGND VNB VPB VPWR
*.PININFO X:O A:I B:I VGND:B VNB:B VPB:B VPWR:B
XM0 net1 A VPWR VPB sky130_fd_pr__pfet_01v8_hvt L=0.15 W=0.45 nf=1 ad=0.1305 as=0.1305 pd=1.48 ps=1.48 nrd=0.644444444444444
+ nrs=0.644444444444444 sa=0 sb=0 sd=0 mult=1 m=1
XM1 net1 B VPWR VPB sky130_fd_pr__pfet_01v8_hvt L=0.15 W=0.45 nf=1 ad=0.1305 as=0.1305 pd=1.48 ps=1.48 nrd=0.644444444444444
+ nrs=0.644444444444444 sa=0 sb=0 sd=0 mult=1 m=1
XM2 net1 A net2 VNB sky130_fd_pr__nfet_01v8 L=0.15 W=0.45 nf=1 ad=0.1305 as=0.1305 pd=1.48 ps=1.48 nrd=0.644444444444444
+ nrs=0.644444444444444 sa=0 sb=0 sd=0 mult=1 m=1
XM3 net2 B VGND VNB sky130_fd_pr__nfet_01v8 L=0.15 W=0.45 nf=1 ad=0.1305 as=0.1305 pd=1.48 ps=1.48 nrd=0.644444444444444
+ nrs=0.644444444444444 sa=0 sb=0 sd=0 mult=1 m=1
XM4 X net1 VPWR VPB sky130_fd_pr__pfet_01v8_hvt L=0.15 W=1.08 nf=1 ad=0.3132 as=0.3132 pd=2.74 ps=2.74 nrd=0.268518518518518
+ nrs=0.268518518518518 sa=0 sb=0 sd=0 mult=2 m=2
XM5 X net1 VGND VNB sky130_fd_pr__nfet_01v8 L=0.15 W=0.63 nf=1 ad=0.1827 as=0.1827 pd=1.84 ps=1.84 nrd=0.46031746031746
+ nrs=0.46031746031746 sa=0 sb=0 sd=0 mult=2 m=2
.ends

.subckt sky130_efx_lvdig__and2_4 A B X VGND VNB VPB VPWR
*.PININFO X:O A:I B:I VGND:B VNB:B VPB:B VPWR:B
XM0 net1 A VPWR VPB sky130_fd_pr__pfet_01v8_hvt L=0.15 W=1.08 nf=1 ad=0.3132 as=0.3132 pd=2.74 ps=2.74 nrd=0.268518518518518
+ nrs=0.268518518518518 sa=0 sb=0 sd=0 mult=1 m=1
XM1 net1 B VPWR VPB sky130_fd_pr__pfet_01v8_hvt L=0.15 W=1.08 nf=1 ad=0.3132 as=0.3132 pd=2.74 ps=2.74 nrd=0.268518518518518
+ nrs=0.268518518518518 sa=0 sb=0 sd=0 mult=1 m=1
XM2 net1 A net2 VNB sky130_fd_pr__nfet_01v8 L=0.15 W=0.63 nf=1 ad=0.1827 as=0.1827 pd=1.84 ps=1.84 nrd=0.46031746031746
+ nrs=0.46031746031746 sa=0 sb=0 sd=0 mult=1 m=1
XM3 net2 B VGND VNB sky130_fd_pr__nfet_01v8 L=0.15 W=0.63 nf=1 ad=0.1827 as=0.1827 pd=1.84 ps=1.84 nrd=0.46031746031746
+ nrs=0.46031746031746 sa=0 sb=0 sd=0 mult=1 m=1
XM4 X net1 VPWR VPB sky130_fd_pr__pfet_01v8_hvt L=0.15 W=1.08 nf=1 ad=0.3132 as=0.3132 pd=2.74 ps=2.74 nrd=0.268518518518518
+ nrs=0.268518518518518 sa=0 sb=0 sd=0 mult=4 m=4
XM5 X net1 VGND VNB sky130_fd_pr__nfet_01v8 L=0.15 W=0.63 nf=1 ad=0.1827 as=0.1827 pd=1.84 ps=1.84 nrd=0.46031746031746
+ nrs=0.46031746031746 sa=0 sb=0 sd=0 mult=4 m=4
.ends

.subckt sky130_efx_lvdig__and3_1 A B C X VGND VNB VPB VPWR
*.PININFO X:O A:I B:I C:I VGND:B VNB:B VPB:B VPWR:B
XM0 net1 A VPWR VPB sky130_fd_pr__pfet_01v8_hvt L=0.15 W=0.45 nf=1 ad=0.1305 as=0.1305 pd=1.48 ps=1.48 nrd=0.644444444444444
+ nrs=0.644444444444444 sa=0 sb=0 sd=0 mult=1 m=1
XM1 net1 B VPWR VPB sky130_fd_pr__pfet_01v8_hvt L=0.15 W=0.45 nf=1 ad=0.1305 as=0.1305 pd=1.48 ps=1.48 nrd=0.644444444444444
+ nrs=0.644444444444444 sa=0 sb=0 sd=0 mult=1 m=1
XM2 net1 C VPWR VPB sky130_fd_pr__pfet_01v8_hvt L=0.15 W=0.45 nf=1 ad=0.1305 as=0.1305 pd=1.48 ps=1.48 nrd=0.644444444444444
+ nrs=0.644444444444444 sa=0 sb=0 sd=0 mult=1 m=1
XM3 net1 A net2 VNB sky130_fd_pr__nfet_01v8 L=0.15 W=0.45 nf=1 ad=0.1305 as=0.1305 pd=1.48 ps=1.48 nrd=0.644444444444444
+ nrs=0.644444444444444 sa=0 sb=0 sd=0 mult=1 m=1
XM4 net2 B net3 VNB sky130_fd_pr__nfet_01v8 L=0.15 W=0.45 nf=1 ad=0.1305 as=0.1305 pd=1.48 ps=1.48 nrd=0.644444444444444
+ nrs=0.644444444444444 sa=0 sb=0 sd=0 mult=1 m=1
XM5 net3 C VGND VNB sky130_fd_pr__nfet_01v8 L=0.15 W=0.45 nf=1 ad=0.1305 as=0.1305 pd=1.48 ps=1.48 nrd=0.644444444444444
+ nrs=0.644444444444444 sa=0 sb=0 sd=0 mult=1 m=1
XM6 X net1 VPWR VPB sky130_fd_pr__pfet_01v8_hvt L=0.15 W=1.08 nf=1 ad=0.3132 as=0.3132 pd=2.74 ps=2.74 nrd=0.268518518518518
+ nrs=0.268518518518518 sa=0 sb=0 sd=0 mult=1 m=1
XM7 X net1 VGND VNB sky130_fd_pr__nfet_01v8 L=0.15 W=0.63 nf=1 ad=0.1827 as=0.1827 pd=1.84 ps=1.84 nrd=0.46031746031746
+ nrs=0.46031746031746 sa=0 sb=0 sd=0 mult=1 m=1
.ends

.subckt sky130_efx_lvdig__and4_2 A B C D X VGND VNB VPB VPWR
*.PININFO X:O A:I B:I C:I D:I VGND:B VNB:B VPB:B VPWR:B
XM0 net1 A VPWR VPB sky130_fd_pr__pfet_01v8_hvt L=0.15 W=0.45 nf=1 ad=0.1305 as=0.1305 pd=1.48 ps=1.48 nrd=0.644444444444444
+ nrs=0.644444444444444 sa=0 sb=0 sd=0 mult=1 m=1
XM1 net1 B VPWR VPB sky130_fd_pr__pfet_01v8_hvt L=0.15 W=0.45 nf=1 ad=0.1305 as=0.1305 pd=1.48 ps=1.48 nrd=0.644444444444444
+ nrs=0.644444444444444 sa=0 sb=0 sd=0 mult=1 m=1
XM2 net1 C VPWR VPB sky130_fd_pr__pfet_01v8_hvt L=0.15 W=0.45 nf=1 ad=0.1305 as=0.1305 pd=1.48 ps=1.48 nrd=0.644444444444444
+ nrs=0.644444444444444 sa=0 sb=0 sd=0 mult=1 m=1
XM3 net1 D VPWR VPB sky130_fd_pr__pfet_01v8_hvt L=0.15 W=0.45 nf=1 ad=0.1305 as=0.1305 pd=1.48 ps=1.48 nrd=0.644444444444444
+ nrs=0.644444444444444 sa=0 sb=0 sd=0 mult=1 m=1
XM4 net1 A net2 VNB sky130_fd_pr__nfet_01v8 L=0.15 W=0.45 nf=1 ad=0.1305 as=0.1305 pd=1.48 ps=1.48 nrd=0.644444444444444
+ nrs=0.644444444444444 sa=0 sb=0 sd=0 mult=1 m=1
XM5 net2 B net3 VNB sky130_fd_pr__nfet_01v8 L=0.15 W=0.45 nf=1 ad=0.1305 as=0.1305 pd=1.48 ps=1.48 nrd=0.644444444444444
+ nrs=0.644444444444444 sa=0 sb=0 sd=0 mult=1 m=1
XM6 net3 C net4 VNB sky130_fd_pr__nfet_01v8 L=0.15 W=0.45 nf=1 ad=0.1305 as=0.1305 pd=1.48 ps=1.48 nrd=0.644444444444444
+ nrs=0.644444444444444 sa=0 sb=0 sd=0 mult=1 m=1
XM7 net4 D VGND VNB sky130_fd_pr__nfet_01v8 L=0.15 W=0.45 nf=1 ad=0.1305 as=0.1305 pd=1.48 ps=1.48 nrd=0.644444444444444
+ nrs=0.644444444444444 sa=0 sb=0 sd=0 mult=1 m=1
XM8 X net1 VPWR VPB sky130_fd_pr__pfet_01v8_hvt L=0.15 W=1.08 nf=1 ad=0.3132 as=0.3132 pd=2.74 ps=2.74 nrd=0.268518518518518
+ nrs=0.268518518518518 sa=0 sb=0 sd=0 mult=2 m=2
XM9 X net1 VGND VNB sky130_fd_pr__nfet_01v8 L=0.15 W=0.63 nf=1 ad=0.1827 as=0.1827 pd=1.84 ps=1.84 nrd=0.46031746031746
+ nrs=0.46031746031746 sa=0 sb=0 sd=0 mult=2 m=2
.ends

.subckt sky130_efx_lvdig__buf_1 A X VGND VNB VPB VPWR
*.PININFO A:I X:O VGND:B VNB:B VPB:B VPWR:B
XM0 net1 A VPWR VPB sky130_fd_pr__pfet_01v8_hvt L=0.15 W=0.81 nf=1 ad=0.2349 as=0.2349 pd=2.2 ps=2.2 nrd=0.358024691358025
+ nrs=0.358024691358025 sa=0 sb=0 sd=0 mult=1 m=1
XM1 net1 A VGND VNB sky130_fd_pr__nfet_01v8 L=0.15 W=0.54 nf=1 ad=0.1566 as=0.1566 pd=1.66 ps=1.66 nrd=0.537037037037037
+ nrs=0.537037037037037 sa=0 sb=0 sd=0 mult=1 m=1
XM2 X net1 VPWR VPB sky130_fd_pr__pfet_01v8_hvt L=0.15 W=0.81 nf=1 ad=0.2349 as=0.2349 pd=2.2 ps=2.2 nrd=0.358024691358025
+ nrs=0.358024691358025 sa=0 sb=0 sd=0 mult=1 m=1
XM3 X net1 VGND VNB sky130_fd_pr__nfet_01v8 L=0.15 W=0.54 nf=1 ad=0.1566 as=0.1566 pd=1.66 ps=1.66 nrd=0.537037037037037
+ nrs=0.537037037037037 sa=0 sb=0 sd=0 mult=1 m=1
.ends

.subckt sky130_efx_lvdig__buf_2 A X VGND VNB VPB VPWR
*.PININFO A:I X:O VGND:B VNB:B VPB:B VPWR:B
XM0 net1 A VPWR VPB sky130_fd_pr__pfet_01v8_hvt L=0.15 W=0.63 nf=1 ad=0.1827 as=0.1827 pd=1.84 ps=1.84 nrd=0.46031746031746
+ nrs=0.46031746031746 sa=0 sb=0 sd=0 mult=1 m=1
XM1 net1 A VGND VNB sky130_fd_pr__nfet_01v8 L=0.15 W=0.45 nf=1 ad=0.1305 as=0.1305 pd=1.48 ps=1.48 nrd=0.644444444444444
+ nrs=0.644444444444444 sa=0 sb=0 sd=0 mult=1 m=1
XM2 X net1 VPWR VPB sky130_fd_pr__pfet_01v8_hvt L=0.15 W=1.08 nf=1 ad=0.3132 as=0.3132 pd=2.74 ps=2.74 nrd=0.268518518518518
+ nrs=0.268518518518518 sa=0 sb=0 sd=0 mult=2 m=2
XM3 X net1 VGND VNB sky130_fd_pr__nfet_01v8 L=0.15 W=0.63 nf=1 ad=0.1827 as=0.1827 pd=1.84 ps=1.84 nrd=0.46031746031746
+ nrs=0.46031746031746 sa=0 sb=0 sd=0 mult=2 m=2
.ends

.subckt sky130_efx_lvdig__buf_4 A X VGND VNB VPB VPWR
*.PININFO A:I X:O VGND:B VNB:B VPB:B VPWR:B
XM0 net1 A VPWR VPB sky130_fd_pr__pfet_01v8_hvt L=0.15 W=1.08 nf=1 ad=0.3132 as=0.3132 pd=2.74 ps=2.74 nrd=0.268518518518518
+ nrs=0.268518518518518 sa=0 sb=0 sd=0 mult=1 m=1
XM1 net1 A VGND VNB sky130_fd_pr__nfet_01v8 L=0.15 W=0.63 nf=1 ad=0.1827 as=0.1827 pd=1.84 ps=1.84 nrd=0.46031746031746
+ nrs=0.46031746031746 sa=0 sb=0 sd=0 mult=1 m=1
XM2 X net1 VPWR VPB sky130_fd_pr__pfet_01v8_hvt L=0.15 W=1.08 nf=1 ad=0.3132 as=0.3132 pd=2.74 ps=2.74 nrd=0.268518518518518
+ nrs=0.268518518518518 sa=0 sb=0 sd=0 mult=4 m=4
XM3 X net1 VGND VNB sky130_fd_pr__nfet_01v8 L=0.15 W=0.63 nf=1 ad=0.1827 as=0.1827 pd=1.84 ps=1.84 nrd=0.46031746031746
+ nrs=0.46031746031746 sa=0 sb=0 sd=0 mult=4 m=4
.ends

.subckt sky130_efx_lvdig__clkbuf_1 A X VGND VNB VPB VPWR
*.PININFO A:I X:O VGND:B VNB:B VPB:B VPWR:B
XM0 net1 A VPWR VPB sky130_fd_pr__pfet_01v8_hvt L=0.15 W=0.81 nf=1 ad=0.2349 as=0.2349 pd=2.2 ps=2.2 nrd=0.358024691358025
+ nrs=0.358024691358025 sa=0 sb=0 sd=0 mult=1 m=1
XM1 net1 A VGND VNB sky130_fd_pr__nfet_01v8 L=0.15 W=0.54 nf=1 ad=0.1566 as=0.1566 pd=1.66 ps=1.66 nrd=0.537037037037037
+ nrs=0.537037037037037 sa=0 sb=0 sd=0 mult=1 m=1
XM2 X net1 VPWR VPB sky130_fd_pr__pfet_01v8_hvt L=0.15 W=0.81 nf=1 ad=0.2349 as=0.2349 pd=2.2 ps=2.2 nrd=0.358024691358025
+ nrs=0.358024691358025 sa=0 sb=0 sd=0 mult=1 m=1
XM3 X net1 VGND VNB sky130_fd_pr__nfet_01v8 L=0.15 W=0.54 nf=1 ad=0.1566 as=0.1566 pd=1.66 ps=1.66 nrd=0.537037037037037
+ nrs=0.537037037037037 sa=0 sb=0 sd=0 mult=1 m=1
.ends

.subckt sky130_efx_lvdig__clkbuf_2 A X VGND VNB VPB VPWR
*.PININFO A:I X:O VGND:B VNB:B VPB:B VPWR:B
XM0 net1 A VPWR VPB sky130_fd_pr__pfet_01v8_hvt L=0.15 W=1.08 nf=1 ad=0.3132 as=0.3132 pd=2.74 ps=2.74 nrd=0.268518518518518
+ nrs=0.268518518518518 sa=0 sb=0 sd=0 mult=1 m=1
XM1 net1 A VGND VNB sky130_fd_pr__nfet_01v8 L=0.15 W=0.45 nf=1 ad=0.1305 as=0.1305 pd=1.48 ps=1.48 nrd=0.644444444444444
+ nrs=0.644444444444444 sa=0 sb=0 sd=0 mult=1 m=1
XM2 X net1 VPWR VPB sky130_fd_pr__pfet_01v8_hvt L=0.15 W=1.08 nf=1 ad=0.3132 as=0.3132 pd=2.74 ps=2.74 nrd=0.268518518518518
+ nrs=0.268518518518518 sa=0 sb=0 sd=0 mult=2 m=2
XM3 X net1 VGND VNB sky130_fd_pr__nfet_01v8 L=0.15 W=0.45 nf=1 ad=0.1305 as=0.1305 pd=1.48 ps=1.48 nrd=0.644444444444444
+ nrs=0.644444444444444 sa=0 sb=0 sd=0 mult=2 m=2
.ends

.subckt sky130_efx_lvdig__clkbuf_4 A X VGND VNB VPB VPWR
*.PININFO A:I X:O VGND:B VNB:B VPB:B VPWR:B
XM0 net1 A VPWR VPB sky130_fd_pr__pfet_01v8_hvt L=0.15 W=1.08 nf=1 ad=0.3132 as=0.3132 pd=2.74 ps=2.74 nrd=0.268518518518518
+ nrs=0.268518518518518 sa=0 sb=0 sd=0 mult=1 m=1
XM1 net1 A VGND VNB sky130_fd_pr__nfet_01v8 L=0.15 W=0.45 nf=1 ad=0.1305 as=0.1305 pd=1.48 ps=1.48 nrd=0.644444444444444
+ nrs=0.644444444444444 sa=0 sb=0 sd=0 mult=1 m=1
XM2 X net1 VPWR VPB sky130_fd_pr__pfet_01v8_hvt L=0.15 W=1.08 nf=1 ad=0.3132 as=0.3132 pd=2.74 ps=2.74 nrd=0.268518518518518
+ nrs=0.268518518518518 sa=0 sb=0 sd=0 mult=4 m=4
XM3 X net1 VGND VNB sky130_fd_pr__nfet_01v8 L=0.15 W=0.45 nf=1 ad=0.1305 as=0.1305 pd=1.48 ps=1.48 nrd=0.644444444444444
+ nrs=0.644444444444444 sa=0 sb=0 sd=0 mult=4 m=4
.ends

.subckt sky130_efx_lvdig__clkbuf_8 A X VGND VNB VPB VPWR
*.PININFO A:I X:O VGND:B VNB:B VPB:B VPWR:B
XM0 net1 A VPWR VPB sky130_fd_pr__pfet_01v8_hvt L=0.15 W=1.08 nf=1 ad=0.3132 as=0.3132 pd=2.74 ps=2.74 nrd=0.268518518518518
+ nrs=0.268518518518518 sa=0 sb=0 sd=0 mult=2 m=2
XM1 net1 A VGND VNB sky130_fd_pr__nfet_01v8 L=0.15 W=0.45 nf=1 ad=0.1305 as=0.1305 pd=1.48 ps=1.48 nrd=0.644444444444444
+ nrs=0.644444444444444 sa=0 sb=0 sd=0 mult=2 m=2
XM2 X net1 VPWR VPB sky130_fd_pr__pfet_01v8_hvt L=0.15 W=1.08 nf=1 ad=0.3132 as=0.3132 pd=2.74 ps=2.74 nrd=0.268518518518518
+ nrs=0.268518518518518 sa=0 sb=0 sd=0 mult=8 m=8
XM3 X net1 VGND VNB sky130_fd_pr__nfet_01v8 L=0.15 W=0.45 nf=1 ad=0.1305 as=0.1305 pd=1.48 ps=1.48 nrd=0.644444444444444
+ nrs=0.644444444444444 sa=0 sb=0 sd=0 mult=8 m=8
.ends

.subckt sky130_efx_lvdig__clkdlybuf4s50_1 A X VGND VNB VPB VPWR
*.PININFO A:I X:O VGND:B VNB:B VPB:B VPWR:B
XM0 net1 A VPWR VPB sky130_fd_pr__pfet_01v8_hvt L=0.15 W=1.08 nf=1 ad=0.3132 as=0.3132 pd=2.74 ps=2.74 nrd=0.268518518518518
+ nrs=0.268518518518518 sa=0 sb=0 sd=0 mult=1 m=1
XM1 net1 A VGND VNB sky130_fd_pr__nfet_01v8 L=0.15 W=0.45 nf=1 ad=0.1305 as=0.1305 pd=1.48 ps=1.48 nrd=0.644444444444444
+ nrs=0.644444444444444 sa=0 sb=0 sd=0 mult=1 m=1
XM2 net2 net1 VPWR VPB sky130_fd_pr__pfet_01v8_hvt L=0.5 W=0.81 nf=1 ad=0.2349 as=0.2349 pd=2.2 ps=2.2 nrd=0.358024691358025
+ nrs=0.358024691358025 sa=0 sb=0 sd=0 mult=1 m=1
XM3 net2 net1 VGND VNB sky130_fd_pr__nfet_01v8 L=0.5 W=0.63 nf=1 ad=0.1827 as=0.1827 pd=1.84 ps=1.84 nrd=0.46031746031746
+ nrs=0.46031746031746 sa=0 sb=0 sd=0 mult=1 m=1
XM4 net3 net2 VPWR VPB sky130_fd_pr__pfet_01v8_hvt L=0.5 W=0.81 nf=1 ad=0.2349 as=0.2349 pd=2.2 ps=2.2 nrd=0.358024691358025
+ nrs=0.358024691358025 sa=0 sb=0 sd=0 mult=1 m=1
XM5 net3 net2 VGND VNB sky130_fd_pr__nfet_01v8 L=0.5 W=0.63 nf=1 ad=0.1827 as=0.1827 pd=1.84 ps=1.84 nrd=0.46031746031746
+ nrs=0.46031746031746 sa=0 sb=0 sd=0 mult=1 m=1
XM6 X net3 VPWR VPB sky130_fd_pr__pfet_01v8_hvt L=0.15 W=1.08 nf=1 ad=0.3132 as=0.3132 pd=2.74 ps=2.74 nrd=0.268518518518518
+ nrs=0.268518518518518 sa=0 sb=0 sd=0 mult=1 m=1
XM7 X net3 VGND VNB sky130_fd_pr__nfet_01v8 L=0.15 W=0.45 nf=1 ad=0.1305 as=0.1305 pd=1.48 ps=1.48 nrd=0.644444444444444
+ nrs=0.644444444444444 sa=0 sb=0 sd=0 mult=1 m=1
.ends

.subckt sky130_efx_lvdig__clkinv_1 A Y VGND VNB VPB VPWR
*.PININFO A:I Y:O VGND:B VNB:B VPB:B VPWR:B
XM0 Y A VPWR VPB sky130_fd_pr__pfet_01v8_hvt L=0.15 W=0.81 nf=1 ad=0.2349 as=0.2349 pd=2.2 ps=2.2 nrd=0.358024691358025
+ nrs=0.358024691358025 sa=0 sb=0 sd=0 mult=2 m=2
XM1 Y A VGND VNB sky130_fd_pr__nfet_01v8 L=0.15 W=0.45 nf=1 ad=0.1305 as=0.1305 pd=1.48 ps=1.48 nrd=0.644444444444444
+ nrs=0.644444444444444 sa=0 sb=0 sd=0 mult=1 m=1
.ends

.subckt sky130_efx_lvdig__clkinv_2 A Y VGND VNB VPB VPWR
*.PININFO A:I Y:O VGND:B VNB:B VPB:B VPWR:B
XM0 Y A VPWR VPB sky130_fd_pr__pfet_01v8_hvt L=0.15 W=1.08 nf=1 ad=0.3132 as=0.3132 pd=2.74 ps=2.74 nrd=0.268518518518518
+ nrs=0.268518518518518 sa=0 sb=0 sd=0 mult=3 m=3
XM1 Y A VGND VNB sky130_fd_pr__nfet_01v8 L=0.15 W=0.45 nf=1 ad=0.1305 as=0.1305 pd=1.48 ps=1.48 nrd=0.644444444444444
+ nrs=0.644444444444444 sa=0 sb=0 sd=0 mult=2 m=2
.ends

.subckt sky130_efx_lvdig__clkinv_4 A Y VGND VNB VPB VPWR
*.PININFO A:I Y:O VGND:B VNB:B VPB:B VPWR:B
XM0 Y A VPWR VPB sky130_fd_pr__pfet_01v8_hvt L=0.15 W=1.08 nf=1 ad=0.3132 as=0.3132 pd=2.74 ps=2.74 nrd=0.268518518518518
+ nrs=0.268518518518518 sa=0 sb=0 sd=0 mult=6 m=6
XM1 Y A VGND VNB sky130_fd_pr__nfet_01v8 L=0.15 W=0.45 nf=1 ad=0.1305 as=0.1305 pd=1.48 ps=1.48 nrd=0.644444444444444
+ nrs=0.644444444444444 sa=0 sb=0 sd=0 mult=4 m=4
.ends

.subckt sky130_efx_lvdig__clkinv_8 A Y VGND VNB VPB VPWR
*.PININFO A:I Y:O VGND:B VNB:B VPB:B VPWR:B
XM0 Y A VPWR VPB sky130_fd_pr__pfet_01v8_hvt L=0.15 W=1.08 nf=1 ad=0.3132 as=0.3132 pd=2.74 ps=2.74 nrd=0.268518518518518
+ nrs=0.268518518518518 sa=0 sb=0 sd=0 mult=12 m=12
XM1 Y A VGND VNB sky130_fd_pr__nfet_01v8 L=0.15 W=0.45 nf=1 ad=0.1305 as=0.1305 pd=1.48 ps=1.48 nrd=0.644444444444444
+ nrs=0.644444444444444 sa=0 sb=0 sd=0 mult=8 m=8
.ends

.subckt sky130_efx_lvdig__conb_1 HI LO VGND VNB VPB VPWR
*.PININFO VGND:B VNB:B VPB:B VPWR:B HI:O LO:O
XR1 HI VPWR sky130_fd_pr__res_generic_po W=0.45 L=0.54 m=1
XR0 VGND LO sky130_fd_pr__res_generic_po W=0.45 L=0.54 m=1
.ends

.subckt sky130_efx_lvdig__decap10 VGND VNB VPB VPWR
*.PININFO VGND:B VNB:B VPB:B VPWR:B
XM0 VPWR VGND VPWR VPB sky130_fd_pr__pfet_01v8_hvt L=0.72 W=0.90 nf=1 ad=0.261 as=0.261 pd=2.38 ps=2.38 nrd=0.322222222222222
+ nrs=0.322222222222222 sa=0 sb=0 sd=0 mult=1 m=1
XM1 VGND VPWR VGND VNB sky130_fd_pr__nfet_01v8 L=0.72 W=0.63 nf=1 ad=0.1827 as=0.1827 pd=1.84 ps=1.84 nrd=0.46031746031746
+ nrs=0.46031746031746 sa=0 sb=0 sd=0 mult=1 m=1
.ends

.subckt sky130_efx_lvdig__decap20 VGND VNB VPB VPWR
*.PININFO VGND:B VNB:B VPB:B VPWR:B
XM0 VPWR VGND VPWR VPB sky130_fd_pr__pfet_01v8_hvt L=2.52 W=0.90 nf=1 ad=0.261 as=0.261 pd=2.38 ps=2.38 nrd=0.322222222222222
+ nrs=0.322222222222222 sa=0 sb=0 sd=0 mult=1 m=1
XM1 VGND VPWR VGND VNB sky130_fd_pr__nfet_01v8 L=2.52 W=0.63 nf=1 ad=0.1827 as=0.1827 pd=1.84 ps=1.84 nrd=0.46031746031746
+ nrs=0.46031746031746 sa=0 sb=0 sd=0 mult=1 m=1
.ends

.subckt sky130_efx_lvdig__dfbbp_1 CLK D RESET_B SET_B Q Q_N VGND VNB VPB VPWR
*.PININFO D:I Q:O CLK:I RESET_B:I Q_N:O SET_B:I VGND:B VNB:B VPB:B VPWR:B
XM0 D_N D VPWR VPB sky130_fd_pr__pfet_01v8_hvt L=0.15 W=0.45 nf=1 ad=0.1305 as=0.1305 pd=1.48 ps=1.48 nrd=0.644444444444444
+ nrs=0.644444444444444 sa=0 sb=0 sd=0 mult=1 m=1
XM1 D_N D VGND VNB sky130_fd_pr__nfet_01v8 L=0.15 W=0.45 nf=1 ad=0.1305 as=0.1305 pd=1.48 ps=1.48 nrd=0.644444444444444
+ nrs=0.644444444444444 sa=0 sb=0 sd=0 mult=1 m=1
XM2 M_N CLK_N D_N VNB sky130_fd_pr__special_nfet_01v8 L=0.15 W=0.36 nf=1 ad=0.1044 as=0.1044 pd=1.3 ps=1.3 nrd=0.805555555555556
+ nrs=0.805555555555556 sa=0 sb=0 sd=0 mult=1 m=1
XM3 M_N CLK_P D_N VPB sky130_fd_pr__pfet_01v8_hvt L=0.15 W=0.45 nf=1 ad=0.1305 as=0.1305 pd=1.48 ps=1.48 nrd=0.644444444444444
+ nrs=0.644444444444444 sa=0 sb=0 sd=0 mult=1 m=1
XM4 M_N CLK_N net1 VPB sky130_fd_pr__pfet_01v8_hvt L=0.15 W=0.45 nf=1 ad=0.1305 as=0.1305 pd=1.48 ps=1.48 nrd=0.644444444444444
+ nrs=0.644444444444444 sa=0 sb=0 sd=0 mult=1 m=1
XM5 net1 M VPWR VPB sky130_fd_pr__pfet_01v8_hvt L=0.15 W=0.45 nf=1 ad=0.1305 as=0.1305 pd=1.48 ps=1.48 nrd=0.644444444444444
+ nrs=0.644444444444444 sa=0 sb=0 sd=0 mult=1 m=1
XM6 M_N CLK_P net2 VNB sky130_fd_pr__special_nfet_01v8 L=0.15 W=0.36 nf=1 ad=0.1044 as=0.1044 pd=1.3 ps=1.3 nrd=0.805555555555556
+ nrs=0.805555555555556 sa=0 sb=0 sd=0 mult=1 m=1
XM7 net2 M VGND VNB sky130_fd_pr__nfet_01v8 L=0.15 W=0.45 nf=1 ad=0.1305 as=0.1305 pd=1.48 ps=1.48 nrd=0.644444444444444
+ nrs=0.644444444444444 sa=0 sb=0 sd=0 mult=1 m=1
XM8 M SET_B VPWR VPB sky130_fd_pr__pfet_01v8_hvt L=0.15 W=0.45 nf=1 ad=0.1305 as=0.1305 pd=1.48 ps=1.48 nrd=0.644444444444444
+ nrs=0.644444444444444 sa=0 sb=0 sd=0 mult=1 m=1
XM9 M M_N net3 VPB sky130_fd_pr__pfet_01v8_hvt L=0.15 W=0.81 nf=1 ad=0.2349 as=0.2349 pd=2.2 ps=2.2 nrd=0.358024691358025
+ nrs=0.358024691358025 sa=0 sb=0 sd=0 mult=1 m=1
XM10 net3 RB_N VPWR VPB sky130_fd_pr__pfet_01v8_hvt L=0.15 W=0.81 nf=1 ad=0.2349 as=0.2349 pd=2.2 ps=2.2 nrd=0.358024691358025
+ nrs=0.358024691358025 sa=0 sb=0 sd=0 mult=1 m=1
XM11 M M_N net4 VNB sky130_fd_pr__nfet_01v8 L=0.15 W=0.63 nf=1 ad=0.1827 as=0.1827 pd=1.84 ps=1.84 nrd=0.46031746031746
+ nrs=0.46031746031746 sa=0 sb=0 sd=0 mult=1 m=1
XM12 M RB_N net4 VNB sky130_fd_pr__nfet_01v8 L=0.15 W=0.63 nf=1 ad=0.1827 as=0.1827 pd=1.84 ps=1.84 nrd=0.46031746031746
+ nrs=0.46031746031746 sa=0 sb=0 sd=0 mult=1 m=1
XM13 net4 SET_B VGND VNB sky130_fd_pr__nfet_01v8 L=0.15 W=0.45 nf=1 ad=0.1305 as=0.1305 pd=1.48 ps=1.48 nrd=0.644444444444444
+ nrs=0.644444444444444 sa=0 sb=0 sd=0 mult=1 m=1
XM14 S CLK_N net5 VPB sky130_fd_pr__pfet_01v8_hvt L=0.15 W=0.45 nf=1 ad=0.1305 as=0.1305 pd=1.48 ps=1.48 nrd=0.644444444444444
+ nrs=0.644444444444444 sa=0 sb=0 sd=0 mult=1 m=1
XM15 net5 M VPWR VPB sky130_fd_pr__pfet_01v8_hvt L=0.15 W=0.81 nf=1 ad=0.2349 as=0.2349 pd=2.2 ps=2.2 nrd=0.358024691358025
+ nrs=0.358024691358025 sa=0 sb=0 sd=0 mult=1 m=1
XM16 S CLK_P net6 VNB sky130_fd_pr__special_nfet_01v8 L=0.15 W=0.36 nf=1 ad=0.1044 as=0.1044 pd=1.3 ps=1.3 nrd=0.805555555555556
+ nrs=0.805555555555556 sa=0 sb=0 sd=0 mult=1 m=1
XM17 net6 M VGND VNB sky130_fd_pr__nfet_01v8 L=0.15 W=0.63 nf=1 ad=0.1827 as=0.1827 pd=1.84 ps=1.84 nrd=0.46031746031746
+ nrs=0.46031746031746 sa=0 sb=0 sd=0 mult=1 m=1
XM18 S CLK_P net7 VPB sky130_fd_pr__pfet_01v8_hvt L=0.15 W=0.45 nf=1 ad=0.1305 as=0.1305 pd=1.48 ps=1.48 nrd=0.644444444444444
+ nrs=0.644444444444444 sa=0 sb=0 sd=0 mult=1 m=1
XM19 net7 S_N VPWR VPB sky130_fd_pr__pfet_01v8_hvt L=0.15 W=0.45 nf=1 ad=0.1305 as=0.1305 pd=1.48 ps=1.48 nrd=0.644444444444444
+ nrs=0.644444444444444 sa=0 sb=0 sd=0 mult=1 m=1
XM20 S CLK_N net8 VNB sky130_fd_pr__special_nfet_01v8 L=0.15 W=0.36 nf=1 ad=0.1044 as=0.1044 pd=1.3 ps=1.3 nrd=0.805555555555556
+ nrs=0.805555555555556 sa=0 sb=0 sd=0 mult=1 m=1
XM21 net8 S_N VGND VNB sky130_fd_pr__nfet_01v8 L=0.15 W=0.45 nf=1 ad=0.1305 as=0.1305 pd=1.48 ps=1.48 nrd=0.644444444444444
+ nrs=0.644444444444444 sa=0 sb=0 sd=0 mult=1 m=1
XM22 S_N SET_B VPWR VPB sky130_fd_pr__pfet_01v8_hvt L=0.15 W=0.45 nf=1 ad=0.1305 as=0.1305 pd=1.48 ps=1.48 nrd=0.644444444444444
+ nrs=0.644444444444444 sa=0 sb=0 sd=0 mult=1 m=1
XM23 S_N S net9 VPB sky130_fd_pr__pfet_01v8_hvt L=0.15 W=0.81 nf=1 ad=0.2349 as=0.2349 pd=2.2 ps=2.2 nrd=0.358024691358025
+ nrs=0.358024691358025 sa=0 sb=0 sd=0 mult=1 m=1
XM24 net9 RB_N VPWR VPB sky130_fd_pr__pfet_01v8_hvt L=0.15 W=0.81 nf=1 ad=0.2349 as=0.2349 pd=2.2 ps=2.2 nrd=0.358024691358025
+ nrs=0.358024691358025 sa=0 sb=0 sd=0 mult=1 m=1
XM25 S_N S net10 VNB sky130_fd_pr__nfet_01v8 L=0.15 W=0.63 nf=1 ad=0.1827 as=0.1827 pd=1.84 ps=1.84 nrd=0.46031746031746
+ nrs=0.46031746031746 sa=0 sb=0 sd=0 mult=1 m=1
XM26 S_N RB_N net10 VNB sky130_fd_pr__nfet_01v8 L=0.15 W=0.63 nf=1 ad=0.1827 as=0.1827 pd=1.84 ps=1.84 nrd=0.46031746031746
+ nrs=0.46031746031746 sa=0 sb=0 sd=0 mult=1 m=1
XM27 net10 SET_B VGND VNB sky130_fd_pr__nfet_01v8 L=0.15 W=0.45 nf=1 ad=0.1305 as=0.1305 pd=1.48 ps=1.48 nrd=0.644444444444444
+ nrs=0.644444444444444 sa=0 sb=0 sd=0 mult=1 m=1
XM28 net11 S_N VPWR VPB sky130_fd_pr__pfet_01v8_hvt L=0.15 W=0.63 nf=1 ad=0.1827 as=0.1827 pd=1.84 ps=1.84 nrd=0.46031746031746
+ nrs=0.46031746031746 sa=0 sb=0 sd=0 mult=1 m=1
XM29 net11 S_N VGND VNB sky130_fd_pr__nfet_01v8 L=0.15 W=0.45 nf=1 ad=0.1305 as=0.1305 pd=1.48 ps=1.48 nrd=0.644444444444444
+ nrs=0.644444444444444 sa=0 sb=0 sd=0 mult=1 m=1
XM30 Q net11 VPWR VPB sky130_fd_pr__pfet_01v8_hvt L=0.15 W=1.08 nf=1 ad=0.3132 as=0.3132 pd=2.74 ps=2.74 nrd=0.268518518518518
+ nrs=0.268518518518518 sa=0 sb=0 sd=0 mult=1 m=1
XM31 Q net11 VGND VNB sky130_fd_pr__nfet_01v8 L=0.15 W=0.63 nf=1 ad=0.1827 as=0.1827 pd=1.84 ps=1.84 nrd=0.46031746031746
+ nrs=0.46031746031746 sa=0 sb=0 sd=0 mult=1 m=1
XM32 CLK_N CLK VPWR VPB sky130_fd_pr__pfet_01v8_hvt L=0.15 W=0.63 nf=1 ad=0.1827 as=0.1827 pd=1.84 ps=1.84 nrd=0.46031746031746
+ nrs=0.46031746031746 sa=0 sb=0 sd=0 mult=1 m=1
XM33 CLK_N CLK VGND VNB sky130_fd_pr__nfet_01v8 L=0.15 W=0.45 nf=1 ad=0.1305 as=0.1305 pd=1.48 ps=1.48 nrd=0.644444444444444
+ nrs=0.644444444444444 sa=0 sb=0 sd=0 mult=1 m=1
XM34 CLK_P CLK_N VPWR VPB sky130_fd_pr__pfet_01v8_hvt L=0.15 W=0.63 nf=1 ad=0.1827 as=0.1827 pd=1.84 ps=1.84 nrd=0.46031746031746
+ nrs=0.46031746031746 sa=0 sb=0 sd=0 mult=1 m=1
XM35 CLK_P CLK_N VGND VNB sky130_fd_pr__nfet_01v8 L=0.15 W=0.45 nf=1 ad=0.1305 as=0.1305 pd=1.48 ps=1.48 nrd=0.644444444444444
+ nrs=0.644444444444444 sa=0 sb=0 sd=0 mult=1 m=1
XM36 RB_N RESET_B VPWR VPB sky130_fd_pr__pfet_01v8_hvt L=0.15 W=0.63 nf=1 ad=0.1827 as=0.1827 pd=1.84 ps=1.84 nrd=0.46031746031746
+ nrs=0.46031746031746 sa=0 sb=0 sd=0 mult=1 m=1
XM37 RB_N RESET_B VGND VNB sky130_fd_pr__nfet_01v8 L=0.15 W=0.45 nf=1 ad=0.1305 as=0.1305 pd=1.48 ps=1.48 nrd=0.644444444444444
+ nrs=0.644444444444444 sa=0 sb=0 sd=0 mult=1 m=1
XM38 Q_N S_N VPWR VPB sky130_fd_pr__pfet_01v8_hvt L=0.15 W=1.08 nf=1 ad=0.3132 as=0.3132 pd=2.74 ps=2.74 nrd=0.268518518518518
+ nrs=0.268518518518518 sa=0 sb=0 sd=0 mult=1 m=1
XM39 Q_N S_N VGND VNB sky130_fd_pr__nfet_01v8 L=0.15 W=0.63 nf=1 ad=0.1827 as=0.1827 pd=1.84 ps=1.84 nrd=0.46031746031746
+ nrs=0.46031746031746 sa=0 sb=0 sd=0 mult=1 m=1
.ends

.subckt sky130_efx_lvdig__dfrbp_1 CLK D RESET_B Q Q_N VGND VNB VPB VPWR
*.PININFO D:I Q:O CLK:I Q_N:O RESET_B:I VGND:B VNB:B VPB:B VPWR:B
XM0 D_N D VPWR VPB sky130_fd_pr__pfet_01v8_hvt L=0.15 W=0.45 nf=1 ad=0.1305 as=0.1305 pd=1.48 ps=1.48 nrd=0.644444444444444
+ nrs=0.644444444444444 sa=0 sb=0 sd=0 mult=1 m=1
XM1 D_N D VGND VNB sky130_fd_pr__nfet_01v8 L=0.15 W=0.45 nf=1 ad=0.1305 as=0.1305 pd=1.48 ps=1.48 nrd=0.644444444444444
+ nrs=0.644444444444444 sa=0 sb=0 sd=0 mult=1 m=1
XM2 M_N CLK_N D_N VNB sky130_fd_pr__special_nfet_01v8 L=0.15 W=0.36 nf=1 ad=0.1044 as=0.1044 pd=1.3 ps=1.3 nrd=0.805555555555556
+ nrs=0.805555555555556 sa=0 sb=0 sd=0 mult=1 m=1
XM3 M_N CLK_P D_N VPB sky130_fd_pr__pfet_01v8_hvt L=0.15 W=0.45 nf=1 ad=0.1305 as=0.1305 pd=1.48 ps=1.48 nrd=0.644444444444444
+ nrs=0.644444444444444 sa=0 sb=0 sd=0 mult=1 m=1
XM4 M_N CLK_N net1 VPB sky130_fd_pr__pfet_01v8_hvt L=0.15 W=0.45 nf=1 ad=0.1305 as=0.1305 pd=1.48 ps=1.48 nrd=0.644444444444444
+ nrs=0.644444444444444 sa=0 sb=0 sd=0 mult=1 m=1
XM5 net1 RESET_B VPWR VPB sky130_fd_pr__pfet_01v8_hvt L=0.15 W=0.45 nf=1 ad=0.1305 as=0.1305 pd=1.48 ps=1.48 nrd=0.644444444444444
+ nrs=0.644444444444444 sa=0 sb=0 sd=0 mult=1 m=1
XM6 net1 M VPWR VPB sky130_fd_pr__pfet_01v8_hvt L=0.15 W=0.45 nf=1 ad=0.1305 as=0.1305 pd=1.48 ps=1.48 nrd=0.644444444444444
+ nrs=0.644444444444444 sa=0 sb=0 sd=0 mult=1 m=1
XM7 M_N CLK_P net2 VNB sky130_fd_pr__special_nfet_01v8 L=0.15 W=0.36 nf=1 ad=0.1044 as=0.1044 pd=1.3 ps=1.3 nrd=0.805555555555556
+ nrs=0.805555555555556 sa=0 sb=0 sd=0 mult=1 m=1
XM8 net2 M net3 VNB sky130_fd_pr__nfet_01v8 L=0.15 W=0.45 nf=1 ad=0.1305 as=0.1305 pd=1.48 ps=1.48 nrd=0.644444444444444
+ nrs=0.644444444444444 sa=0 sb=0 sd=0 mult=1 m=1
XM9 net3 RESET_B VGND VNB sky130_fd_pr__nfet_01v8 L=0.15 W=0.45 nf=1 ad=0.1305 as=0.1305 pd=1.48 ps=1.48 nrd=0.644444444444444
+ nrs=0.644444444444444 sa=0 sb=0 sd=0 mult=1 m=1
XM10 M M_N VPWR VPB sky130_fd_pr__pfet_01v8_hvt L=0.15 W=0.81 nf=1 ad=0.2349 as=0.2349 pd=2.2 ps=2.2 nrd=0.358024691358025
+ nrs=0.358024691358025 sa=0 sb=0 sd=0 mult=1 m=1
XM11 M M_N VGND VNB sky130_fd_pr__nfet_01v8 L=0.15 W=0.63 nf=1 ad=0.1827 as=0.1827 pd=1.84 ps=1.84 nrd=0.46031746031746
+ nrs=0.46031746031746 sa=0 sb=0 sd=0 mult=1 m=1
XM12 S CLK_P M VNB sky130_fd_pr__special_nfet_01v8 L=0.15 W=0.36 nf=1 ad=0.1044 as=0.1044 pd=1.3 ps=1.3 nrd=0.805555555555556
+ nrs=0.805555555555556 sa=0 sb=0 sd=0 mult=1 m=1
XM13 S CLK_N M VPB sky130_fd_pr__pfet_01v8_hvt L=0.15 W=0.45 nf=1 ad=0.1305 as=0.1305 pd=1.48 ps=1.48 nrd=0.644444444444444
+ nrs=0.644444444444444 sa=0 sb=0 sd=0 mult=1 m=1
XM14 S CLK_P net4 VPB sky130_fd_pr__pfet_01v8_hvt L=0.15 W=0.45 nf=1 ad=0.1305 as=0.1305 pd=1.48 ps=1.48 nrd=0.644444444444444
+ nrs=0.644444444444444 sa=0 sb=0 sd=0 mult=1 m=1
XM15 net4 S_N VPWR VPB sky130_fd_pr__pfet_01v8_hvt L=0.15 W=0.45 nf=1 ad=0.1305 as=0.1305 pd=1.48 ps=1.48 nrd=0.644444444444444
+ nrs=0.644444444444444 sa=0 sb=0 sd=0 mult=1 m=1
XM16 S CLK_N net5 VNB sky130_fd_pr__special_nfet_01v8 L=0.15 W=0.36 nf=1 ad=0.1044 as=0.1044 pd=1.3 ps=1.3 nrd=0.805555555555556
+ nrs=0.805555555555556 sa=0 sb=0 sd=0 mult=1 m=1
XM17 net5 S_N VGND VNB sky130_fd_pr__nfet_01v8 L=0.15 W=0.45 nf=1 ad=0.1305 as=0.1305 pd=1.48 ps=1.48 nrd=0.644444444444444
+ nrs=0.644444444444444 sa=0 sb=0 sd=0 mult=1 m=1
XM18 S_N S VPWR VPB sky130_fd_pr__pfet_01v8_hvt L=0.15 W=0.45 nf=1 ad=0.1305 as=0.1305 pd=1.48 ps=1.48 nrd=0.644444444444444
+ nrs=0.644444444444444 sa=0 sb=0 sd=0 mult=1 m=1
XM19 S_N RESET_B VPWR VPB sky130_fd_pr__pfet_01v8_hvt L=0.15 W=0.45 nf=1 ad=0.1305 as=0.1305 pd=1.48 ps=1.48 nrd=0.644444444444444
+ nrs=0.644444444444444 sa=0 sb=0 sd=0 mult=1 m=1
XM20 S_N S net6 VNB sky130_fd_pr__nfet_01v8 L=0.15 W=0.45 nf=1 ad=0.1305 as=0.1305 pd=1.48 ps=1.48 nrd=0.644444444444444
+ nrs=0.644444444444444 sa=0 sb=0 sd=0 mult=1 m=1
XM21 net6 RESET_B VGND VNB sky130_fd_pr__nfet_01v8 L=0.15 W=0.45 nf=1 ad=0.1305 as=0.1305 pd=1.48 ps=1.48 nrd=0.644444444444444
+ nrs=0.644444444444444 sa=0 sb=0 sd=0 mult=1 m=1
XM22 Q S_N VPWR VPB sky130_fd_pr__pfet_01v8_hvt L=0.15 W=1.08 nf=1 ad=0.3132 as=0.3132 pd=2.74 ps=2.74 nrd=0.268518518518518
+ nrs=0.268518518518518 sa=0 sb=0 sd=0 mult=1 m=1
XM23 Q S_N VGND VNB sky130_fd_pr__nfet_01v8 L=0.15 W=0.63 nf=1 ad=0.1827 as=0.1827 pd=1.84 ps=1.84 nrd=0.46031746031746
+ nrs=0.46031746031746 sa=0 sb=0 sd=0 mult=1 m=1
XM24 CLK_N CLK VPWR VPB sky130_fd_pr__pfet_01v8_hvt L=0.15 W=0.63 nf=1 ad=0.1827 as=0.1827 pd=1.84 ps=1.84 nrd=0.46031746031746
+ nrs=0.46031746031746 sa=0 sb=0 sd=0 mult=1 m=1
XM25 CLK_N CLK VGND VNB sky130_fd_pr__nfet_01v8 L=0.15 W=0.45 nf=1 ad=0.1305 as=0.1305 pd=1.48 ps=1.48 nrd=0.644444444444444
+ nrs=0.644444444444444 sa=0 sb=0 sd=0 mult=1 m=1
XM26 CLK_P CLK_N VPWR VPB sky130_fd_pr__pfet_01v8_hvt L=0.15 W=0.63 nf=1 ad=0.1827 as=0.1827 pd=1.84 ps=1.84 nrd=0.46031746031746
+ nrs=0.46031746031746 sa=0 sb=0 sd=0 mult=1 m=1
XM27 CLK_P CLK_N VGND VNB sky130_fd_pr__nfet_01v8 L=0.15 W=0.45 nf=1 ad=0.1305 as=0.1305 pd=1.48 ps=1.48 nrd=0.644444444444444
+ nrs=0.644444444444444 sa=0 sb=0 sd=0 mult=1 m=1
XM28 net7 S_N VPWR VPB sky130_fd_pr__pfet_01v8_hvt L=0.15 W=0.63 nf=1 ad=0.1827 as=0.1827 pd=1.84 ps=1.84 nrd=0.46031746031746
+ nrs=0.46031746031746 sa=0 sb=0 sd=0 mult=1 m=1
XM29 net7 S_N VGND VNB sky130_fd_pr__nfet_01v8 L=0.15 W=0.45 nf=1 ad=0.1305 as=0.1305 pd=1.48 ps=1.48 nrd=0.644444444444444
+ nrs=0.644444444444444 sa=0 sb=0 sd=0 mult=1 m=1
XM30 Q_N net7 VPWR VPB sky130_fd_pr__pfet_01v8_hvt L=0.15 W=1.08 nf=1 ad=0.3132 as=0.3132 pd=2.74 ps=2.74 nrd=0.268518518518518
+ nrs=0.268518518518518 sa=0 sb=0 sd=0 mult=1 m=1
XM31 Q_N net7 VGND VNB sky130_fd_pr__nfet_01v8 L=0.15 W=0.63 nf=1 ad=0.1827 as=0.1827 pd=1.84 ps=1.84 nrd=0.46031746031746
+ nrs=0.46031746031746 sa=0 sb=0 sd=0 mult=1 m=1
.ends

.subckt sky130_efx_lvdig__dfrbp_2 CLK D RESET_B Q Q_N VGND VNB VPB VPWR
*.PININFO D:I Q:O CLK:I Q_N:O RESET_B:I VGND:B VNB:B VPB:B VPWR:B
XM0 D_N D VPWR VPB sky130_fd_pr__pfet_01v8_hvt L=0.15 W=0.45 nf=1 ad=0.1305 as=0.1305 pd=1.48 ps=1.48 nrd=0.644444444444444
+ nrs=0.644444444444444 sa=0 sb=0 sd=0 mult=1 m=1
XM1 D_N D VGND VNB sky130_fd_pr__nfet_01v8 L=0.15 W=0.45 nf=1 ad=0.1305 as=0.1305 pd=1.48 ps=1.48 nrd=0.644444444444444
+ nrs=0.644444444444444 sa=0 sb=0 sd=0 mult=1 m=1
XM2 M_N CLK_N D_N VNB sky130_fd_pr__special_nfet_01v8 L=0.15 W=0.36 nf=1 ad=0.1044 as=0.1044 pd=1.3 ps=1.3 nrd=0.805555555555556
+ nrs=0.805555555555556 sa=0 sb=0 sd=0 mult=1 m=1
XM3 M_N CLK_P D_N VPB sky130_fd_pr__pfet_01v8_hvt L=0.15 W=0.45 nf=1 ad=0.1305 as=0.1305 pd=1.48 ps=1.48 nrd=0.644444444444444
+ nrs=0.644444444444444 sa=0 sb=0 sd=0 mult=1 m=1
XM4 M_N CLK_N net1 VPB sky130_fd_pr__pfet_01v8_hvt L=0.15 W=0.45 nf=1 ad=0.1305 as=0.1305 pd=1.48 ps=1.48 nrd=0.644444444444444
+ nrs=0.644444444444444 sa=0 sb=0 sd=0 mult=1 m=1
XM5 net1 RESET_B VPWR VPB sky130_fd_pr__pfet_01v8_hvt L=0.15 W=0.45 nf=1 ad=0.1305 as=0.1305 pd=1.48 ps=1.48 nrd=0.644444444444444
+ nrs=0.644444444444444 sa=0 sb=0 sd=0 mult=1 m=1
XM6 net1 M VPWR VPB sky130_fd_pr__pfet_01v8_hvt L=0.15 W=0.45 nf=1 ad=0.1305 as=0.1305 pd=1.48 ps=1.48 nrd=0.644444444444444
+ nrs=0.644444444444444 sa=0 sb=0 sd=0 mult=1 m=1
XM7 M_N CLK_P net2 VNB sky130_fd_pr__special_nfet_01v8 L=0.15 W=0.36 nf=1 ad=0.1044 as=0.1044 pd=1.3 ps=1.3 nrd=0.805555555555556
+ nrs=0.805555555555556 sa=0 sb=0 sd=0 mult=1 m=1
XM8 net2 M net3 VNB sky130_fd_pr__nfet_01v8 L=0.15 W=0.45 nf=1 ad=0.1305 as=0.1305 pd=1.48 ps=1.48 nrd=0.644444444444444
+ nrs=0.644444444444444 sa=0 sb=0 sd=0 mult=1 m=1
XM9 net3 RESET_B VGND VNB sky130_fd_pr__nfet_01v8 L=0.15 W=0.45 nf=1 ad=0.1305 as=0.1305 pd=1.48 ps=1.48 nrd=0.644444444444444
+ nrs=0.644444444444444 sa=0 sb=0 sd=0 mult=1 m=1
XM10 M M_N VPWR VPB sky130_fd_pr__pfet_01v8_hvt L=0.15 W=0.81 nf=1 ad=0.2349 as=0.2349 pd=2.2 ps=2.2 nrd=0.358024691358025
+ nrs=0.358024691358025 sa=0 sb=0 sd=0 mult=1 m=1
XM11 M M_N VGND VNB sky130_fd_pr__nfet_01v8 L=0.15 W=0.63 nf=1 ad=0.1827 as=0.1827 pd=1.84 ps=1.84 nrd=0.46031746031746
+ nrs=0.46031746031746 sa=0 sb=0 sd=0 mult=1 m=1
XM12 S CLK_P M VNB sky130_fd_pr__special_nfet_01v8 L=0.15 W=0.36 nf=1 ad=0.1044 as=0.1044 pd=1.3 ps=1.3 nrd=0.805555555555556
+ nrs=0.805555555555556 sa=0 sb=0 sd=0 mult=1 m=1
XM13 S CLK_N M VPB sky130_fd_pr__pfet_01v8_hvt L=0.15 W=0.45 nf=1 ad=0.1305 as=0.1305 pd=1.48 ps=1.48 nrd=0.644444444444444
+ nrs=0.644444444444444 sa=0 sb=0 sd=0 mult=1 m=1
XM14 S CLK_P net4 VPB sky130_fd_pr__pfet_01v8_hvt L=0.15 W=0.45 nf=1 ad=0.1305 as=0.1305 pd=1.48 ps=1.48 nrd=0.644444444444444
+ nrs=0.644444444444444 sa=0 sb=0 sd=0 mult=1 m=1
XM15 net4 S_N VPWR VPB sky130_fd_pr__pfet_01v8_hvt L=0.15 W=0.45 nf=1 ad=0.1305 as=0.1305 pd=1.48 ps=1.48 nrd=0.644444444444444
+ nrs=0.644444444444444 sa=0 sb=0 sd=0 mult=1 m=1
XM16 S CLK_N net5 VNB sky130_fd_pr__special_nfet_01v8 L=0.15 W=0.36 nf=1 ad=0.1044 as=0.1044 pd=1.3 ps=1.3 nrd=0.805555555555556
+ nrs=0.805555555555556 sa=0 sb=0 sd=0 mult=1 m=1
XM17 net5 S_N VGND VNB sky130_fd_pr__nfet_01v8 L=0.15 W=0.45 nf=1 ad=0.1305 as=0.1305 pd=1.48 ps=1.48 nrd=0.644444444444444
+ nrs=0.644444444444444 sa=0 sb=0 sd=0 mult=1 m=1
XM18 S_N S VPWR VPB sky130_fd_pr__pfet_01v8_hvt L=0.15 W=0.45 nf=1 ad=0.1305 as=0.1305 pd=1.48 ps=1.48 nrd=0.644444444444444
+ nrs=0.644444444444444 sa=0 sb=0 sd=0 mult=1 m=1
XM19 S_N RESET_B VPWR VPB sky130_fd_pr__pfet_01v8_hvt L=0.15 W=0.45 nf=1 ad=0.1305 as=0.1305 pd=1.48 ps=1.48 nrd=0.644444444444444
+ nrs=0.644444444444444 sa=0 sb=0 sd=0 mult=1 m=1
XM20 S_N S net6 VNB sky130_fd_pr__nfet_01v8 L=0.15 W=0.45 nf=1 ad=0.1305 as=0.1305 pd=1.48 ps=1.48 nrd=0.644444444444444
+ nrs=0.644444444444444 sa=0 sb=0 sd=0 mult=1 m=1
XM21 net6 RESET_B VGND VNB sky130_fd_pr__nfet_01v8 L=0.15 W=0.45 nf=1 ad=0.1305 as=0.1305 pd=1.48 ps=1.48 nrd=0.644444444444444
+ nrs=0.644444444444444 sa=0 sb=0 sd=0 mult=1 m=1
XM22 Q S_N VPWR VPB sky130_fd_pr__pfet_01v8_hvt L=0.15 W=1.08 nf=1 ad=0.3132 as=0.3132 pd=2.74 ps=2.74 nrd=0.268518518518518
+ nrs=0.268518518518518 sa=0 sb=0 sd=0 mult=2 m=2
XM23 Q S_N VGND VNB sky130_fd_pr__nfet_01v8 L=0.15 W=0.63 nf=1 ad=0.1827 as=0.1827 pd=1.84 ps=1.84 nrd=0.46031746031746
+ nrs=0.46031746031746 sa=0 sb=0 sd=0 mult=2 m=2
XM24 CLK_N CLK VPWR VPB sky130_fd_pr__pfet_01v8_hvt L=0.15 W=0.63 nf=1 ad=0.1827 as=0.1827 pd=1.84 ps=1.84 nrd=0.46031746031746
+ nrs=0.46031746031746 sa=0 sb=0 sd=0 mult=1 m=1
XM25 CLK_N CLK VGND VNB sky130_fd_pr__nfet_01v8 L=0.15 W=0.45 nf=1 ad=0.1305 as=0.1305 pd=1.48 ps=1.48 nrd=0.644444444444444
+ nrs=0.644444444444444 sa=0 sb=0 sd=0 mult=1 m=1
XM26 CLK_P CLK_N VPWR VPB sky130_fd_pr__pfet_01v8_hvt L=0.15 W=0.63 nf=1 ad=0.1827 as=0.1827 pd=1.84 ps=1.84 nrd=0.46031746031746
+ nrs=0.46031746031746 sa=0 sb=0 sd=0 mult=1 m=1
XM27 CLK_P CLK_N VGND VNB sky130_fd_pr__nfet_01v8 L=0.15 W=0.45 nf=1 ad=0.1305 as=0.1305 pd=1.48 ps=1.48 nrd=0.644444444444444
+ nrs=0.644444444444444 sa=0 sb=0 sd=0 mult=1 m=1
XM28 net7 S_N VPWR VPB sky130_fd_pr__pfet_01v8_hvt L=0.15 W=0.63 nf=1 ad=0.1827 as=0.1827 pd=1.84 ps=1.84 nrd=0.46031746031746
+ nrs=0.46031746031746 sa=0 sb=0 sd=0 mult=1 m=1
XM29 net7 S_N VGND VNB sky130_fd_pr__nfet_01v8 L=0.15 W=0.45 nf=1 ad=0.1305 as=0.1305 pd=1.48 ps=1.48 nrd=0.644444444444444
+ nrs=0.644444444444444 sa=0 sb=0 sd=0 mult=1 m=1
XM30 Q_N net7 VPWR VPB sky130_fd_pr__pfet_01v8_hvt L=0.15 W=1.08 nf=1 ad=0.3132 as=0.3132 pd=2.74 ps=2.74 nrd=0.268518518518518
+ nrs=0.268518518518518 sa=0 sb=0 sd=0 mult=2 m=2
XM31 Q_N net7 VGND VNB sky130_fd_pr__nfet_01v8 L=0.15 W=0.63 nf=1 ad=0.1827 as=0.1827 pd=1.84 ps=1.84 nrd=0.46031746031746
+ nrs=0.46031746031746 sa=0 sb=0 sd=0 mult=2 m=2
.ends

.subckt sky130_efx_lvdig__dfrtp_1 CLK D RESET_B Q VGND VNB VPB VPWR
*.PININFO D:I Q:O CLK:I RESET_B:I VGND:B VNB:B VPB:B VPWR:B
XM0 D_N D VPWR VPB sky130_fd_pr__pfet_01v8_hvt L=0.15 W=0.45 nf=1 ad=0.1305 as=0.1305 pd=1.48 ps=1.48 nrd=0.644444444444444
+ nrs=0.644444444444444 sa=0 sb=0 sd=0 mult=1 m=1
XM1 D_N D VGND VNB sky130_fd_pr__nfet_01v8 L=0.15 W=0.45 nf=1 ad=0.1305 as=0.1305 pd=1.48 ps=1.48 nrd=0.644444444444444
+ nrs=0.644444444444444 sa=0 sb=0 sd=0 mult=1 m=1
XM2 M_N CLK_N D_N VNB sky130_fd_pr__special_nfet_01v8 L=0.15 W=0.36 nf=1 ad=0.1044 as=0.1044 pd=1.3 ps=1.3 nrd=0.805555555555556
+ nrs=0.805555555555556 sa=0 sb=0 sd=0 mult=1 m=1
XM3 M_N CLK_P D_N VPB sky130_fd_pr__pfet_01v8_hvt L=0.15 W=0.45 nf=1 ad=0.1305 as=0.1305 pd=1.48 ps=1.48 nrd=0.644444444444444
+ nrs=0.644444444444444 sa=0 sb=0 sd=0 mult=1 m=1
XM4 M_N CLK_N net1 VPB sky130_fd_pr__pfet_01v8_hvt L=0.15 W=0.45 nf=1 ad=0.1305 as=0.1305 pd=1.48 ps=1.48 nrd=0.644444444444444
+ nrs=0.644444444444444 sa=0 sb=0 sd=0 mult=1 m=1
XM5 net1 RESET_B VPWR VPB sky130_fd_pr__pfet_01v8_hvt L=0.15 W=0.45 nf=1 ad=0.1305 as=0.1305 pd=1.48 ps=1.48 nrd=0.644444444444444
+ nrs=0.644444444444444 sa=0 sb=0 sd=0 mult=1 m=1
XM6 net1 M VPWR VPB sky130_fd_pr__pfet_01v8_hvt L=0.15 W=0.45 nf=1 ad=0.1305 as=0.1305 pd=1.48 ps=1.48 nrd=0.644444444444444
+ nrs=0.644444444444444 sa=0 sb=0 sd=0 mult=1 m=1
XM7 M_N CLK_P net2 VNB sky130_fd_pr__special_nfet_01v8 L=0.15 W=0.36 nf=1 ad=0.1044 as=0.1044 pd=1.3 ps=1.3 nrd=0.805555555555556
+ nrs=0.805555555555556 sa=0 sb=0 sd=0 mult=1 m=1
XM8 net2 M net3 VNB sky130_fd_pr__nfet_01v8 L=0.15 W=0.45 nf=1 ad=0.1305 as=0.1305 pd=1.48 ps=1.48 nrd=0.644444444444444
+ nrs=0.644444444444444 sa=0 sb=0 sd=0 mult=1 m=1
XM9 net3 RESET_B VGND VNB sky130_fd_pr__nfet_01v8 L=0.15 W=0.45 nf=1 ad=0.1305 as=0.1305 pd=1.48 ps=1.48 nrd=0.644444444444444
+ nrs=0.644444444444444 sa=0 sb=0 sd=0 mult=1 m=1
XM10 M M_N VPWR VPB sky130_fd_pr__pfet_01v8_hvt L=0.15 W=0.81 nf=1 ad=0.2349 as=0.2349 pd=2.2 ps=2.2 nrd=0.358024691358025
+ nrs=0.358024691358025 sa=0 sb=0 sd=0 mult=1 m=1
XM11 M M_N VGND VNB sky130_fd_pr__nfet_01v8 L=0.15 W=0.63 nf=1 ad=0.1827 as=0.1827 pd=1.84 ps=1.84 nrd=0.46031746031746
+ nrs=0.46031746031746 sa=0 sb=0 sd=0 mult=1 m=1
XM12 S CLK_P M VNB sky130_fd_pr__special_nfet_01v8 L=0.15 W=0.36 nf=1 ad=0.1044 as=0.1044 pd=1.3 ps=1.3 nrd=0.805555555555556
+ nrs=0.805555555555556 sa=0 sb=0 sd=0 mult=1 m=1
XM13 S CLK_N M VPB sky130_fd_pr__pfet_01v8_hvt L=0.15 W=0.45 nf=1 ad=0.1305 as=0.1305 pd=1.48 ps=1.48 nrd=0.644444444444444
+ nrs=0.644444444444444 sa=0 sb=0 sd=0 mult=1 m=1
XM14 S CLK_P net4 VPB sky130_fd_pr__pfet_01v8_hvt L=0.15 W=0.45 nf=1 ad=0.1305 as=0.1305 pd=1.48 ps=1.48 nrd=0.644444444444444
+ nrs=0.644444444444444 sa=0 sb=0 sd=0 mult=1 m=1
XM15 net4 S_N VPWR VPB sky130_fd_pr__pfet_01v8_hvt L=0.15 W=0.45 nf=1 ad=0.1305 as=0.1305 pd=1.48 ps=1.48 nrd=0.644444444444444
+ nrs=0.644444444444444 sa=0 sb=0 sd=0 mult=1 m=1
XM16 S CLK_N net5 VNB sky130_fd_pr__special_nfet_01v8 L=0.15 W=0.36 nf=1 ad=0.1044 as=0.1044 pd=1.3 ps=1.3 nrd=0.805555555555556
+ nrs=0.805555555555556 sa=0 sb=0 sd=0 mult=1 m=1
XM17 net5 S_N VGND VNB sky130_fd_pr__nfet_01v8 L=0.15 W=0.45 nf=1 ad=0.1305 as=0.1305 pd=1.48 ps=1.48 nrd=0.644444444444444
+ nrs=0.644444444444444 sa=0 sb=0 sd=0 mult=1 m=1
XM18 S_N S VPWR VPB sky130_fd_pr__pfet_01v8_hvt L=0.15 W=0.45 nf=1 ad=0.1305 as=0.1305 pd=1.48 ps=1.48 nrd=0.644444444444444
+ nrs=0.644444444444444 sa=0 sb=0 sd=0 mult=1 m=1
XM19 S_N RESET_B VPWR VPB sky130_fd_pr__pfet_01v8_hvt L=0.15 W=0.45 nf=1 ad=0.1305 as=0.1305 pd=1.48 ps=1.48 nrd=0.644444444444444
+ nrs=0.644444444444444 sa=0 sb=0 sd=0 mult=1 m=1
XM20 S_N S net6 VNB sky130_fd_pr__nfet_01v8 L=0.15 W=0.45 nf=1 ad=0.1305 as=0.1305 pd=1.48 ps=1.48 nrd=0.644444444444444
+ nrs=0.644444444444444 sa=0 sb=0 sd=0 mult=1 m=1
XM21 net6 RESET_B VGND VNB sky130_fd_pr__nfet_01v8 L=0.15 W=0.45 nf=1 ad=0.1305 as=0.1305 pd=1.48 ps=1.48 nrd=0.644444444444444
+ nrs=0.644444444444444 sa=0 sb=0 sd=0 mult=1 m=1
XM22 Q S_N VPWR VPB sky130_fd_pr__pfet_01v8_hvt L=0.15 W=1.08 nf=1 ad=0.3132 as=0.3132 pd=2.74 ps=2.74 nrd=0.268518518518518
+ nrs=0.268518518518518 sa=0 sb=0 sd=0 mult=1 m=1
XM23 Q S_N VGND VNB sky130_fd_pr__nfet_01v8 L=0.15 W=0.63 nf=1 ad=0.1827 as=0.1827 pd=1.84 ps=1.84 nrd=0.46031746031746
+ nrs=0.46031746031746 sa=0 sb=0 sd=0 mult=1 m=1
XM24 CLK_N CLK VPWR VPB sky130_fd_pr__pfet_01v8_hvt L=0.15 W=0.63 nf=1 ad=0.1827 as=0.1827 pd=1.84 ps=1.84 nrd=0.46031746031746
+ nrs=0.46031746031746 sa=0 sb=0 sd=0 mult=1 m=1
XM25 CLK_N CLK VGND VNB sky130_fd_pr__nfet_01v8 L=0.15 W=0.45 nf=1 ad=0.1305 as=0.1305 pd=1.48 ps=1.48 nrd=0.644444444444444
+ nrs=0.644444444444444 sa=0 sb=0 sd=0 mult=1 m=1
XM26 CLK_P CLK_N VPWR VPB sky130_fd_pr__pfet_01v8_hvt L=0.15 W=0.63 nf=1 ad=0.1827 as=0.1827 pd=1.84 ps=1.84 nrd=0.46031746031746
+ nrs=0.46031746031746 sa=0 sb=0 sd=0 mult=1 m=1
XM27 CLK_P CLK_N VGND VNB sky130_fd_pr__nfet_01v8 L=0.15 W=0.45 nf=1 ad=0.1305 as=0.1305 pd=1.48 ps=1.48 nrd=0.644444444444444
+ nrs=0.644444444444444 sa=0 sb=0 sd=0 mult=1 m=1
.ends

.subckt sky130_efx_lvdig__dfrtp_2 CLK D RESET_B Q VGND VNB VPB VPWR
*.PININFO D:I Q:O CLK:I RESET_B:I VGND:B VNB:B VPB:B VPWR:B
XM0 D_N D VPWR VPB sky130_fd_pr__pfet_01v8_hvt L=0.15 W=0.45 nf=1 ad=0.1305 as=0.1305 pd=1.48 ps=1.48 nrd=0.644444444444444
+ nrs=0.644444444444444 sa=0 sb=0 sd=0 mult=1 m=1
XM1 D_N D VGND VNB sky130_fd_pr__nfet_01v8 L=0.15 W=0.45 nf=1 ad=0.1305 as=0.1305 pd=1.48 ps=1.48 nrd=0.644444444444444
+ nrs=0.644444444444444 sa=0 sb=0 sd=0 mult=1 m=1
XM2 M_N CLK_N D_N VNB sky130_fd_pr__special_nfet_01v8 L=0.15 W=0.36 nf=1 ad=0.1044 as=0.1044 pd=1.3 ps=1.3 nrd=0.805555555555556
+ nrs=0.805555555555556 sa=0 sb=0 sd=0 mult=1 m=1
XM3 M_N CLK_P D_N VPB sky130_fd_pr__pfet_01v8_hvt L=0.15 W=0.45 nf=1 ad=0.1305 as=0.1305 pd=1.48 ps=1.48 nrd=0.644444444444444
+ nrs=0.644444444444444 sa=0 sb=0 sd=0 mult=1 m=1
XM4 M_N CLK_N net1 VPB sky130_fd_pr__pfet_01v8_hvt L=0.15 W=0.45 nf=1 ad=0.1305 as=0.1305 pd=1.48 ps=1.48 nrd=0.644444444444444
+ nrs=0.644444444444444 sa=0 sb=0 sd=0 mult=1 m=1
XM5 net1 RESET_B VPWR VPB sky130_fd_pr__pfet_01v8_hvt L=0.15 W=0.45 nf=1 ad=0.1305 as=0.1305 pd=1.48 ps=1.48 nrd=0.644444444444444
+ nrs=0.644444444444444 sa=0 sb=0 sd=0 mult=1 m=1
XM6 net1 M VPWR VPB sky130_fd_pr__pfet_01v8_hvt L=0.15 W=0.45 nf=1 ad=0.1305 as=0.1305 pd=1.48 ps=1.48 nrd=0.644444444444444
+ nrs=0.644444444444444 sa=0 sb=0 sd=0 mult=1 m=1
XM7 M_N CLK_P net2 VNB sky130_fd_pr__special_nfet_01v8 L=0.15 W=0.36 nf=1 ad=0.1044 as=0.1044 pd=1.3 ps=1.3 nrd=0.805555555555556
+ nrs=0.805555555555556 sa=0 sb=0 sd=0 mult=1 m=1
XM8 net2 M net3 VNB sky130_fd_pr__nfet_01v8 L=0.15 W=0.45 nf=1 ad=0.1305 as=0.1305 pd=1.48 ps=1.48 nrd=0.644444444444444
+ nrs=0.644444444444444 sa=0 sb=0 sd=0 mult=1 m=1
XM9 net3 RESET_B VGND VNB sky130_fd_pr__nfet_01v8 L=0.15 W=0.45 nf=1 ad=0.1305 as=0.1305 pd=1.48 ps=1.48 nrd=0.644444444444444
+ nrs=0.644444444444444 sa=0 sb=0 sd=0 mult=1 m=1
XM10 M M_N VPWR VPB sky130_fd_pr__pfet_01v8_hvt L=0.15 W=0.81 nf=1 ad=0.2349 as=0.2349 pd=2.2 ps=2.2 nrd=0.358024691358025
+ nrs=0.358024691358025 sa=0 sb=0 sd=0 mult=1 m=1
XM11 M M_N VGND VNB sky130_fd_pr__nfet_01v8 L=0.15 W=0.63 nf=1 ad=0.1827 as=0.1827 pd=1.84 ps=1.84 nrd=0.46031746031746
+ nrs=0.46031746031746 sa=0 sb=0 sd=0 mult=1 m=1
XM12 S CLK_P M VNB sky130_fd_pr__special_nfet_01v8 L=0.15 W=0.36 nf=1 ad=0.1044 as=0.1044 pd=1.3 ps=1.3 nrd=0.805555555555556
+ nrs=0.805555555555556 sa=0 sb=0 sd=0 mult=1 m=1
XM13 S CLK_N M VPB sky130_fd_pr__pfet_01v8_hvt L=0.15 W=0.45 nf=1 ad=0.1305 as=0.1305 pd=1.48 ps=1.48 nrd=0.644444444444444
+ nrs=0.644444444444444 sa=0 sb=0 sd=0 mult=1 m=1
XM14 S CLK_P net4 VPB sky130_fd_pr__pfet_01v8_hvt L=0.15 W=0.45 nf=1 ad=0.1305 as=0.1305 pd=1.48 ps=1.48 nrd=0.644444444444444
+ nrs=0.644444444444444 sa=0 sb=0 sd=0 mult=1 m=1
XM15 net4 S_N VPWR VPB sky130_fd_pr__pfet_01v8_hvt L=0.15 W=0.45 nf=1 ad=0.1305 as=0.1305 pd=1.48 ps=1.48 nrd=0.644444444444444
+ nrs=0.644444444444444 sa=0 sb=0 sd=0 mult=1 m=1
XM16 S CLK_N net5 VNB sky130_fd_pr__special_nfet_01v8 L=0.15 W=0.36 nf=1 ad=0.1044 as=0.1044 pd=1.3 ps=1.3 nrd=0.805555555555556
+ nrs=0.805555555555556 sa=0 sb=0 sd=0 mult=1 m=1
XM17 net5 S_N VGND VNB sky130_fd_pr__nfet_01v8 L=0.15 W=0.45 nf=1 ad=0.1305 as=0.1305 pd=1.48 ps=1.48 nrd=0.644444444444444
+ nrs=0.644444444444444 sa=0 sb=0 sd=0 mult=1 m=1
XM18 S_N S VPWR VPB sky130_fd_pr__pfet_01v8_hvt L=0.15 W=0.45 nf=1 ad=0.1305 as=0.1305 pd=1.48 ps=1.48 nrd=0.644444444444444
+ nrs=0.644444444444444 sa=0 sb=0 sd=0 mult=1 m=1
XM19 S_N RESET_B VPWR VPB sky130_fd_pr__pfet_01v8_hvt L=0.15 W=0.45 nf=1 ad=0.1305 as=0.1305 pd=1.48 ps=1.48 nrd=0.644444444444444
+ nrs=0.644444444444444 sa=0 sb=0 sd=0 mult=1 m=1
XM20 S_N S net6 VNB sky130_fd_pr__nfet_01v8 L=0.15 W=0.45 nf=1 ad=0.1305 as=0.1305 pd=1.48 ps=1.48 nrd=0.644444444444444
+ nrs=0.644444444444444 sa=0 sb=0 sd=0 mult=1 m=1
XM21 net6 RESET_B VGND VNB sky130_fd_pr__nfet_01v8 L=0.15 W=0.45 nf=1 ad=0.1305 as=0.1305 pd=1.48 ps=1.48 nrd=0.644444444444444
+ nrs=0.644444444444444 sa=0 sb=0 sd=0 mult=1 m=1
XM22 Q S_N VPWR VPB sky130_fd_pr__pfet_01v8_hvt L=0.15 W=1.08 nf=1 ad=0.3132 as=0.3132 pd=2.74 ps=2.74 nrd=0.268518518518518
+ nrs=0.268518518518518 sa=0 sb=0 sd=0 mult=2 m=2
XM23 Q S_N VGND VNB sky130_fd_pr__nfet_01v8 L=0.15 W=0.63 nf=1 ad=0.1827 as=0.1827 pd=1.84 ps=1.84 nrd=0.46031746031746
+ nrs=0.46031746031746 sa=0 sb=0 sd=0 mult=2 m=2
XM24 CLK_N CLK VPWR VPB sky130_fd_pr__pfet_01v8_hvt L=0.15 W=0.63 nf=1 ad=0.1827 as=0.1827 pd=1.84 ps=1.84 nrd=0.46031746031746
+ nrs=0.46031746031746 sa=0 sb=0 sd=0 mult=1 m=1
XM25 CLK_N CLK VGND VNB sky130_fd_pr__nfet_01v8 L=0.15 W=0.45 nf=1 ad=0.1305 as=0.1305 pd=1.48 ps=1.48 nrd=0.644444444444444
+ nrs=0.644444444444444 sa=0 sb=0 sd=0 mult=1 m=1
XM26 CLK_P CLK_N VPWR VPB sky130_fd_pr__pfet_01v8_hvt L=0.15 W=0.63 nf=1 ad=0.1827 as=0.1827 pd=1.84 ps=1.84 nrd=0.46031746031746
+ nrs=0.46031746031746 sa=0 sb=0 sd=0 mult=1 m=1
XM27 CLK_P CLK_N VGND VNB sky130_fd_pr__nfet_01v8 L=0.15 W=0.45 nf=1 ad=0.1305 as=0.1305 pd=1.48 ps=1.48 nrd=0.644444444444444
+ nrs=0.644444444444444 sa=0 sb=0 sd=0 mult=1 m=1
.ends

.subckt sky130_efx_lvdig__dfstp_1 CLK D SET_B Q VGND VNB VPB VPWR
*.PININFO D:I Q:O CLK:I SET_B:I VGND:B VNB:B VPB:B VPWR:B
XM0 D_N D VPWR VPB sky130_fd_pr__pfet_01v8_hvt L=0.15 W=0.81 nf=1 ad=0.2349 as=0.2349 pd=2.2 ps=2.2 nrd=0.358024691358025
+ nrs=0.358024691358025 sa=0 sb=0 sd=0 mult=1 m=1
XM1 D_N D VGND VNB sky130_fd_pr__nfet_01v8 L=0.15 W=0.63 nf=1 ad=0.1827 as=0.1827 pd=1.84 ps=1.84 nrd=0.46031746031746
+ nrs=0.46031746031746 sa=0 sb=0 sd=0 mult=1 m=1
XM2 M_N CLK_N D_N VNB sky130_fd_pr__special_nfet_01v8 L=0.15 W=0.36 nf=1 ad=0.1044 as=0.1044 pd=1.3 ps=1.3 nrd=0.805555555555556
+ nrs=0.805555555555556 sa=0 sb=0 sd=0 mult=1 m=1
XM3 M_N CLK_P D_N VPB sky130_fd_pr__pfet_01v8_hvt L=0.15 W=0.45 nf=1 ad=0.1305 as=0.1305 pd=1.48 ps=1.48 nrd=0.644444444444444
+ nrs=0.644444444444444 sa=0 sb=0 sd=0 mult=1 m=1
XM4 M M_N VPWR VPB sky130_fd_pr__pfet_01v8_hvt L=0.15 W=0.45 nf=1 ad=0.1305 as=0.1305 pd=1.48 ps=1.48 nrd=0.644444444444444
+ nrs=0.644444444444444 sa=0 sb=0 sd=0 mult=1 m=1
XM5 M SET_B VPWR VPB sky130_fd_pr__pfet_01v8_hvt L=0.15 W=0.45 nf=1 ad=0.1305 as=0.1305 pd=1.48 ps=1.48 nrd=0.644444444444444
+ nrs=0.644444444444444 sa=0 sb=0 sd=0 mult=1 m=1
XM6 M M_N net1 VNB sky130_fd_pr__nfet_01v8 L=0.15 W=0.45 nf=1 ad=0.1305 as=0.1305 pd=1.48 ps=1.48 nrd=0.644444444444444
+ nrs=0.644444444444444 sa=0 sb=0 sd=0 mult=1 m=1
XM7 net1 SET_B VGND VNB sky130_fd_pr__nfet_01v8 L=0.15 W=0.45 nf=1 ad=0.1305 as=0.1305 pd=1.48 ps=1.48 nrd=0.644444444444444
+ nrs=0.644444444444444 sa=0 sb=0 sd=0 mult=1 m=1
XM8 M_N CLK_N net2 VPB sky130_fd_pr__pfet_01v8_hvt L=0.15 W=0.45 nf=1 ad=0.1305 as=0.1305 pd=1.48 ps=1.48 nrd=0.644444444444444
+ nrs=0.644444444444444 sa=0 sb=0 sd=0 mult=1 m=1
XM9 net2 M VPWR VPB sky130_fd_pr__pfet_01v8_hvt L=0.15 W=0.45 nf=1 ad=0.1305 as=0.1305 pd=1.48 ps=1.48 nrd=0.644444444444444
+ nrs=0.644444444444444 sa=0 sb=0 sd=0 mult=1 m=1
XM10 M_N CLK_P net3 VNB sky130_fd_pr__special_nfet_01v8 L=0.15 W=0.36 nf=1 ad=0.1044 as=0.1044 pd=1.3 ps=1.3 nrd=0.805555555555556
+ nrs=0.805555555555556 sa=0 sb=0 sd=0 mult=1 m=1
XM11 net3 M VGND VNB sky130_fd_pr__nfet_01v8 L=0.15 W=0.45 nf=1 ad=0.1305 as=0.1305 pd=1.48 ps=1.48 nrd=0.644444444444444
+ nrs=0.644444444444444 sa=0 sb=0 sd=0 mult=1 m=1
XM12 S CLK_N net4 VPB sky130_fd_pr__pfet_01v8_hvt L=0.15 W=0.45 nf=1 ad=0.1305 as=0.1305 pd=1.48 ps=1.48 nrd=0.644444444444444
+ nrs=0.644444444444444 sa=0 sb=0 sd=0 mult=1 m=1
XM13 net4 M_N VPWR VPB sky130_fd_pr__pfet_01v8_hvt L=0.15 W=0.45 nf=1 ad=0.1305 as=0.1305 pd=1.48 ps=1.48 nrd=0.644444444444444
+ nrs=0.644444444444444 sa=0 sb=0 sd=0 mult=1 m=1
XM14 S CLK_P net5 VNB sky130_fd_pr__nfet_01v8 L=0.15 W=0.45 nf=1 ad=0.1305 as=0.1305 pd=1.48 ps=1.48 nrd=0.644444444444444
+ nrs=0.644444444444444 sa=0 sb=0 sd=0 mult=1 m=1
XM15 net5 M_N VGND VNB sky130_fd_pr__nfet_01v8 L=0.15 W=0.45 nf=1 ad=0.1305 as=0.1305 pd=1.48 ps=1.48 nrd=0.644444444444444
+ nrs=0.644444444444444 sa=0 sb=0 sd=0 mult=1 m=1
XM16 S_N S VPWR VPB sky130_fd_pr__pfet_01v8_hvt L=0.15 W=0.81 nf=1 ad=0.2349 as=0.2349 pd=2.2 ps=2.2 nrd=0.358024691358025
+ nrs=0.358024691358025 sa=0 sb=0 sd=0 mult=1 m=1
XM17 S_N S VGND VNB sky130_fd_pr__nfet_01v8 L=0.15 W=0.54 nf=1 ad=0.1566 as=0.1566 pd=1.66 ps=1.66 nrd=0.537037037037037
+ nrs=0.537037037037037 sa=0 sb=0 sd=0 mult=1 m=1
XM18 S CLK_P net6 VPB sky130_fd_pr__pfet_01v8_hvt L=0.15 W=0.45 nf=1 ad=0.1305 as=0.1305 pd=1.48 ps=1.48 nrd=0.644444444444444
+ nrs=0.644444444444444 sa=0 sb=0 sd=0 mult=1 m=1
XM19 net6 S_N VPWR VPB sky130_fd_pr__pfet_01v8_hvt L=0.15 W=0.45 nf=1 ad=0.1305 as=0.1305 pd=1.48 ps=1.48 nrd=0.644444444444444
+ nrs=0.644444444444444 sa=0 sb=0 sd=0 mult=1 m=1
XM20 S SET_B VPWR VPB sky130_fd_pr__pfet_01v8_hvt L=0.15 W=0.45 nf=1 ad=0.1305 as=0.1305 pd=1.48 ps=1.48 nrd=0.644444444444444
+ nrs=0.644444444444444 sa=0 sb=0 sd=0 mult=1 m=1
XM21 S CLK_N net7 VNB sky130_fd_pr__nfet_01v8 L=0.15 W=0.45 nf=1 ad=0.1305 as=0.1305 pd=1.48 ps=1.48 nrd=0.644444444444444
+ nrs=0.644444444444444 sa=0 sb=0 sd=0 mult=1 m=1
XM22 net7 S_N net8 VNB sky130_fd_pr__nfet_01v8 L=0.15 W=0.45 nf=1 ad=0.1305 as=0.1305 pd=1.48 ps=1.48 nrd=0.644444444444444
+ nrs=0.644444444444444 sa=0 sb=0 sd=0 mult=1 m=1
XM23 net8 SET_B VGND VNB sky130_fd_pr__nfet_01v8 L=0.15 W=0.45 nf=1 ad=0.1305 as=0.1305 pd=1.48 ps=1.48 nrd=0.644444444444444
+ nrs=0.644444444444444 sa=0 sb=0 sd=0 mult=1 m=1
XM24 net9 S VPWR VPB sky130_fd_pr__pfet_01v8_hvt L=0.15 W=0.63 nf=1 ad=0.1827 as=0.1827 pd=1.84 ps=1.84 nrd=0.46031746031746
+ nrs=0.46031746031746 sa=0 sb=0 sd=0 mult=1 m=1
XM25 net9 S VGND VNB sky130_fd_pr__nfet_01v8 L=0.15 W=0.45 nf=1 ad=0.1305 as=0.1305 pd=1.48 ps=1.48 nrd=0.644444444444444
+ nrs=0.644444444444444 sa=0 sb=0 sd=0 mult=1 m=1
XM26 Q net9 VPWR VPB sky130_fd_pr__pfet_01v8_hvt L=0.15 W=1.08 nf=1 ad=0.3132 as=0.3132 pd=2.74 ps=2.74 nrd=0.268518518518518
+ nrs=0.268518518518518 sa=0 sb=0 sd=0 mult=1 m=1
XM27 Q net9 VGND VNB sky130_fd_pr__nfet_01v8 L=0.15 W=0.63 nf=1 ad=0.1827 as=0.1827 pd=1.84 ps=1.84 nrd=0.46031746031746
+ nrs=0.46031746031746 sa=0 sb=0 sd=0 mult=1 m=1
XM28 CLK_N CLK VPWR VPB sky130_fd_pr__pfet_01v8_hvt L=0.15 W=0.63 nf=1 ad=0.1827 as=0.1827 pd=1.84 ps=1.84 nrd=0.46031746031746
+ nrs=0.46031746031746 sa=0 sb=0 sd=0 mult=1 m=1
XM29 CLK_N CLK VGND VNB sky130_fd_pr__nfet_01v8 L=0.15 W=0.45 nf=1 ad=0.1305 as=0.1305 pd=1.48 ps=1.48 nrd=0.644444444444444
+ nrs=0.644444444444444 sa=0 sb=0 sd=0 mult=1 m=1
XM30 CLK_P CLK_N VPWR VPB sky130_fd_pr__pfet_01v8_hvt L=0.15 W=0.63 nf=1 ad=0.1827 as=0.1827 pd=1.84 ps=1.84 nrd=0.46031746031746
+ nrs=0.46031746031746 sa=0 sb=0 sd=0 mult=1 m=1
XM31 CLK_P CLK_N VGND VNB sky130_fd_pr__nfet_01v8 L=0.15 W=0.45 nf=1 ad=0.1305 as=0.1305 pd=1.48 ps=1.48 nrd=0.644444444444444
+ nrs=0.644444444444444 sa=0 sb=0 sd=0 mult=1 m=1
.ends

.subckt sky130_efx_lvdig__dfstp_2 CLK D SET_B Q VGND VNB VPB VPWR
*.PININFO D:I Q:O CLK:I SET_B:I VGND:B VNB:B VPB:B VPWR:B
XM0 D_N D VPWR VPB sky130_fd_pr__pfet_01v8_hvt L=0.15 W=0.81 nf=1 ad=0.2349 as=0.2349 pd=2.2 ps=2.2 nrd=0.358024691358025
+ nrs=0.358024691358025 sa=0 sb=0 sd=0 mult=1 m=1
XM1 D_N D VGND VNB sky130_fd_pr__nfet_01v8 L=0.15 W=0.63 nf=1 ad=0.1827 as=0.1827 pd=1.84 ps=1.84 nrd=0.46031746031746
+ nrs=0.46031746031746 sa=0 sb=0 sd=0 mult=1 m=1
XM2 M_N CLK_N D_N VNB sky130_fd_pr__special_nfet_01v8 L=0.15 W=0.36 nf=1 ad=0.1044 as=0.1044 pd=1.3 ps=1.3 nrd=0.805555555555556
+ nrs=0.805555555555556 sa=0 sb=0 sd=0 mult=1 m=1
XM3 M_N CLK_P D_N VPB sky130_fd_pr__pfet_01v8_hvt L=0.15 W=0.45 nf=1 ad=0.1305 as=0.1305 pd=1.48 ps=1.48 nrd=0.644444444444444
+ nrs=0.644444444444444 sa=0 sb=0 sd=0 mult=1 m=1
XM4 M M_N VPWR VPB sky130_fd_pr__pfet_01v8_hvt L=0.15 W=0.45 nf=1 ad=0.1305 as=0.1305 pd=1.48 ps=1.48 nrd=0.644444444444444
+ nrs=0.644444444444444 sa=0 sb=0 sd=0 mult=1 m=1
XM5 M SET_B VPWR VPB sky130_fd_pr__pfet_01v8_hvt L=0.15 W=0.45 nf=1 ad=0.1305 as=0.1305 pd=1.48 ps=1.48 nrd=0.644444444444444
+ nrs=0.644444444444444 sa=0 sb=0 sd=0 mult=1 m=1
XM6 M M_N net1 VNB sky130_fd_pr__nfet_01v8 L=0.15 W=0.45 nf=1 ad=0.1305 as=0.1305 pd=1.48 ps=1.48 nrd=0.644444444444444
+ nrs=0.644444444444444 sa=0 sb=0 sd=0 mult=1 m=1
XM7 net1 SET_B VGND VNB sky130_fd_pr__nfet_01v8 L=0.15 W=0.45 nf=1 ad=0.1305 as=0.1305 pd=1.48 ps=1.48 nrd=0.644444444444444
+ nrs=0.644444444444444 sa=0 sb=0 sd=0 mult=1 m=1
XM8 M_N CLK_N net2 VPB sky130_fd_pr__pfet_01v8_hvt L=0.15 W=0.45 nf=1 ad=0.1305 as=0.1305 pd=1.48 ps=1.48 nrd=0.644444444444444
+ nrs=0.644444444444444 sa=0 sb=0 sd=0 mult=1 m=1
XM9 net2 M VPWR VPB sky130_fd_pr__pfet_01v8_hvt L=0.15 W=0.45 nf=1 ad=0.1305 as=0.1305 pd=1.48 ps=1.48 nrd=0.644444444444444
+ nrs=0.644444444444444 sa=0 sb=0 sd=0 mult=1 m=1
XM10 M_N CLK_P net3 VNB sky130_fd_pr__special_nfet_01v8 L=0.15 W=0.36 nf=1 ad=0.1044 as=0.1044 pd=1.3 ps=1.3 nrd=0.805555555555556
+ nrs=0.805555555555556 sa=0 sb=0 sd=0 mult=1 m=1
XM11 net3 M VGND VNB sky130_fd_pr__nfet_01v8 L=0.15 W=0.45 nf=1 ad=0.1305 as=0.1305 pd=1.48 ps=1.48 nrd=0.644444444444444
+ nrs=0.644444444444444 sa=0 sb=0 sd=0 mult=1 m=1
XM12 S CLK_N net4 VPB sky130_fd_pr__pfet_01v8_hvt L=0.15 W=0.45 nf=1 ad=0.1305 as=0.1305 pd=1.48 ps=1.48 nrd=0.644444444444444
+ nrs=0.644444444444444 sa=0 sb=0 sd=0 mult=1 m=1
XM13 net4 M_N VPWR VPB sky130_fd_pr__pfet_01v8_hvt L=0.15 W=0.45 nf=1 ad=0.1305 as=0.1305 pd=1.48 ps=1.48 nrd=0.644444444444444
+ nrs=0.644444444444444 sa=0 sb=0 sd=0 mult=1 m=1
XM14 S CLK_P net5 VNB sky130_fd_pr__nfet_01v8 L=0.15 W=0.45 nf=1 ad=0.1305 as=0.1305 pd=1.48 ps=1.48 nrd=0.644444444444444
+ nrs=0.644444444444444 sa=0 sb=0 sd=0 mult=1 m=1
XM15 net5 M_N VGND VNB sky130_fd_pr__nfet_01v8 L=0.15 W=0.45 nf=1 ad=0.1305 as=0.1305 pd=1.48 ps=1.48 nrd=0.644444444444444
+ nrs=0.644444444444444 sa=0 sb=0 sd=0 mult=1 m=1
XM16 S_N S VPWR VPB sky130_fd_pr__pfet_01v8_hvt L=0.15 W=0.81 nf=1 ad=0.2349 as=0.2349 pd=2.2 ps=2.2 nrd=0.358024691358025
+ nrs=0.358024691358025 sa=0 sb=0 sd=0 mult=1 m=1
XM17 S_N S VGND VNB sky130_fd_pr__nfet_01v8 L=0.15 W=0.54 nf=1 ad=0.1566 as=0.1566 pd=1.66 ps=1.66 nrd=0.537037037037037
+ nrs=0.537037037037037 sa=0 sb=0 sd=0 mult=1 m=1
XM18 S CLK_P net6 VPB sky130_fd_pr__pfet_01v8_hvt L=0.15 W=0.45 nf=1 ad=0.1305 as=0.1305 pd=1.48 ps=1.48 nrd=0.644444444444444
+ nrs=0.644444444444444 sa=0 sb=0 sd=0 mult=1 m=1
XM19 net6 S_N VPWR VPB sky130_fd_pr__pfet_01v8_hvt L=0.15 W=0.45 nf=1 ad=0.1305 as=0.1305 pd=1.48 ps=1.48 nrd=0.644444444444444
+ nrs=0.644444444444444 sa=0 sb=0 sd=0 mult=1 m=1
XM20 S SET_B VPWR VPB sky130_fd_pr__pfet_01v8_hvt L=0.15 W=0.45 nf=1 ad=0.1305 as=0.1305 pd=1.48 ps=1.48 nrd=0.644444444444444
+ nrs=0.644444444444444 sa=0 sb=0 sd=0 mult=1 m=1
XM21 S CLK_N net7 VNB sky130_fd_pr__nfet_01v8 L=0.15 W=0.45 nf=1 ad=0.1305 as=0.1305 pd=1.48 ps=1.48 nrd=0.644444444444444
+ nrs=0.644444444444444 sa=0 sb=0 sd=0 mult=1 m=1
XM22 net7 S_N net8 VNB sky130_fd_pr__nfet_01v8 L=0.15 W=0.45 nf=1 ad=0.1305 as=0.1305 pd=1.48 ps=1.48 nrd=0.644444444444444
+ nrs=0.644444444444444 sa=0 sb=0 sd=0 mult=1 m=1
XM23 net8 SET_B VGND VNB sky130_fd_pr__nfet_01v8 L=0.15 W=0.45 nf=1 ad=0.1305 as=0.1305 pd=1.48 ps=1.48 nrd=0.644444444444444
+ nrs=0.644444444444444 sa=0 sb=0 sd=0 mult=1 m=1
XM24 net9 S VPWR VPB sky130_fd_pr__pfet_01v8_hvt L=0.15 W=1.08 nf=1 ad=0.3132 as=0.3132 pd=2.74 ps=2.74 nrd=0.268518518518518
+ nrs=0.268518518518518 sa=0 sb=0 sd=0 mult=1 m=1
XM25 net9 S VGND VNB sky130_fd_pr__nfet_01v8 L=0.15 W=0.63 nf=1 ad=0.1827 as=0.1827 pd=1.84 ps=1.84 nrd=0.46031746031746
+ nrs=0.46031746031746 sa=0 sb=0 sd=0 mult=1 m=1
XM26 Q net9 VPWR VPB sky130_fd_pr__pfet_01v8_hvt L=0.15 W=1.08 nf=1 ad=0.3132 as=0.3132 pd=2.74 ps=2.74 nrd=0.268518518518518
+ nrs=0.268518518518518 sa=0 sb=0 sd=0 mult=2 m=2
XM27 Q net9 VGND VNB sky130_fd_pr__nfet_01v8 L=0.15 W=0.63 nf=1 ad=0.1827 as=0.1827 pd=1.84 ps=1.84 nrd=0.46031746031746
+ nrs=0.46031746031746 sa=0 sb=0 sd=0 mult=2 m=2
XM28 CLK_N CLK VPWR VPB sky130_fd_pr__pfet_01v8_hvt L=0.15 W=0.63 nf=1 ad=0.1827 as=0.1827 pd=1.84 ps=1.84 nrd=0.46031746031746
+ nrs=0.46031746031746 sa=0 sb=0 sd=0 mult=1 m=1
XM29 CLK_N CLK VGND VNB sky130_fd_pr__nfet_01v8 L=0.15 W=0.45 nf=1 ad=0.1305 as=0.1305 pd=1.48 ps=1.48 nrd=0.644444444444444
+ nrs=0.644444444444444 sa=0 sb=0 sd=0 mult=1 m=1
XM30 CLK_P CLK_N VPWR VPB sky130_fd_pr__pfet_01v8_hvt L=0.15 W=0.63 nf=1 ad=0.1827 as=0.1827 pd=1.84 ps=1.84 nrd=0.46031746031746
+ nrs=0.46031746031746 sa=0 sb=0 sd=0 mult=1 m=1
XM31 CLK_P CLK_N VGND VNB sky130_fd_pr__nfet_01v8 L=0.15 W=0.45 nf=1 ad=0.1305 as=0.1305 pd=1.48 ps=1.48 nrd=0.644444444444444
+ nrs=0.644444444444444 sa=0 sb=0 sd=0 mult=1 m=1
.ends

.subckt sky130_efx_lvdig__dfxbp_2 CLK D Q Q_N VGND VNB VPB VPWR
*.PININFO D:I Q:O CLK:I Q_N:O VGND:B VNB:B VPB:B VPWR:B
XM0 D_N D VPWR VPB sky130_fd_pr__pfet_01v8_hvt L=0.15 W=0.45 nf=1 ad=0.1305 as=0.1305 pd=1.48 ps=1.48 nrd=0.644444444444444
+ nrs=0.644444444444444 sa=0 sb=0 sd=0 mult=1 m=1
XM1 D_N D VGND VNB sky130_fd_pr__nfet_01v8 L=0.15 W=0.45 nf=1 ad=0.1305 as=0.1305 pd=1.48 ps=1.48 nrd=0.644444444444444
+ nrs=0.644444444444444 sa=0 sb=0 sd=0 mult=1 m=1
XM2 M_N CLK_N D_N VNB sky130_fd_pr__special_nfet_01v8 L=0.15 W=0.36 nf=1 ad=0.1044 as=0.1044 pd=1.3 ps=1.3 nrd=0.805555555555556
+ nrs=0.805555555555556 sa=0 sb=0 sd=0 mult=1 m=1
XM3 M_N CLK_P D_N VPB sky130_fd_pr__pfet_01v8_hvt L=0.15 W=0.45 nf=1 ad=0.1305 as=0.1305 pd=1.48 ps=1.48 nrd=0.644444444444444
+ nrs=0.644444444444444 sa=0 sb=0 sd=0 mult=1 m=1
XM4 M_N CLK_N net1 VPB sky130_fd_pr__pfet_01v8_hvt L=0.15 W=0.45 nf=1 ad=0.1305 as=0.1305 pd=1.48 ps=1.48 nrd=0.644444444444444
+ nrs=0.644444444444444 sa=0 sb=0 sd=0 mult=1 m=1
XM5 net1 M VPWR VPB sky130_fd_pr__pfet_01v8_hvt L=0.15 W=0.45 nf=1 ad=0.1305 as=0.1305 pd=1.48 ps=1.48 nrd=0.644444444444444
+ nrs=0.644444444444444 sa=0 sb=0 sd=0 mult=1 m=1
XM6 M_N CLK_P net2 VNB sky130_fd_pr__special_nfet_01v8 L=0.15 W=0.36 nf=1 ad=0.1044 as=0.1044 pd=1.3 ps=1.3 nrd=0.805555555555556
+ nrs=0.805555555555556 sa=0 sb=0 sd=0 mult=1 m=1
XM7 net2 M VGND VNB sky130_fd_pr__nfet_01v8 L=0.15 W=0.45 nf=1 ad=0.1305 as=0.1305 pd=1.48 ps=1.48 nrd=0.644444444444444
+ nrs=0.644444444444444 sa=0 sb=0 sd=0 mult=1 m=1
XM8 M M_N VPWR VPB sky130_fd_pr__pfet_01v8_hvt L=0.15 W=0.72 nf=1 ad=0.2088 as=0.2088 pd=2.02 ps=2.02 nrd=0.402777777777778
+ nrs=0.402777777777778 sa=0 sb=0 sd=0 mult=1 m=1
XM9 M M_N VGND VNB sky130_fd_pr__nfet_01v8 L=0.15 W=0.63 nf=1 ad=0.1827 as=0.1827 pd=1.84 ps=1.84 nrd=0.46031746031746
+ nrs=0.46031746031746 sa=0 sb=0 sd=0 mult=1 m=1
XM10 S CLK_P M VNB sky130_fd_pr__special_nfet_01v8 L=0.15 W=0.36 nf=1 ad=0.1044 as=0.1044 pd=1.3 ps=1.3 nrd=0.805555555555556
+ nrs=0.805555555555556 sa=0 sb=0 sd=0 mult=1 m=1
XM11 S CLK_N M VPB sky130_fd_pr__pfet_01v8_hvt L=0.15 W=0.45 nf=1 ad=0.1305 as=0.1305 pd=1.48 ps=1.48 nrd=0.644444444444444
+ nrs=0.644444444444444 sa=0 sb=0 sd=0 mult=1 m=1
XM12 S CLK_P net3 VPB sky130_fd_pr__pfet_01v8_hvt L=0.15 W=0.45 nf=1 ad=0.1305 as=0.1305 pd=1.48 ps=1.48 nrd=0.644444444444444
+ nrs=0.644444444444444 sa=0 sb=0 sd=0 mult=1 m=1
XM13 net3 S_N VPWR VPB sky130_fd_pr__pfet_01v8_hvt L=0.15 W=0.45 nf=1 ad=0.1305 as=0.1305 pd=1.48 ps=1.48 nrd=0.644444444444444
+ nrs=0.644444444444444 sa=0 sb=0 sd=0 mult=1 m=1
XM14 S CLK_N net4 VNB sky130_fd_pr__special_nfet_01v8 L=0.15 W=0.36 nf=1 ad=0.1044 as=0.1044 pd=1.3 ps=1.3 nrd=0.805555555555556
+ nrs=0.805555555555556 sa=0 sb=0 sd=0 mult=1 m=1
XM15 net4 S_N VGND VNB sky130_fd_pr__nfet_01v8 L=0.15 W=0.45 nf=1 ad=0.1305 as=0.1305 pd=1.48 ps=1.48 nrd=0.644444444444444
+ nrs=0.644444444444444 sa=0 sb=0 sd=0 mult=1 m=1
XM16 S_N S VPWR VPB sky130_fd_pr__pfet_01v8_hvt L=0.15 W=1.08 nf=1 ad=0.3132 as=0.3132 pd=2.74 ps=2.74 nrd=0.268518518518518
+ nrs=0.268518518518518 sa=0 sb=0 sd=0 mult=1 m=1
XM17 S_N S VGND VNB sky130_fd_pr__nfet_01v8 L=0.15 W=0.63 nf=1 ad=0.1827 as=0.1827 pd=1.84 ps=1.84 nrd=0.46031746031746
+ nrs=0.46031746031746 sa=0 sb=0 sd=0 mult=1 m=1
XM18 Q S_N VPWR VPB sky130_fd_pr__pfet_01v8_hvt L=0.15 W=1.08 nf=1 ad=0.3132 as=0.3132 pd=2.74 ps=2.74 nrd=0.268518518518518
+ nrs=0.268518518518518 sa=0 sb=0 sd=0 mult=2 m=2
XM19 Q S_N VGND VNB sky130_fd_pr__nfet_01v8 L=0.15 W=0.63 nf=1 ad=0.1827 as=0.1827 pd=1.84 ps=1.84 nrd=0.46031746031746
+ nrs=0.46031746031746 sa=0 sb=0 sd=0 mult=2 m=2
XM20 CLK_N CLK VPWR VPB sky130_fd_pr__pfet_01v8_hvt L=0.15 W=0.63 nf=1 ad=0.1827 as=0.1827 pd=1.84 ps=1.84 nrd=0.46031746031746
+ nrs=0.46031746031746 sa=0 sb=0 sd=0 mult=1 m=1
XM21 CLK_N CLK VGND VNB sky130_fd_pr__nfet_01v8 L=0.15 W=0.45 nf=1 ad=0.1305 as=0.1305 pd=1.48 ps=1.48 nrd=0.644444444444444
+ nrs=0.644444444444444 sa=0 sb=0 sd=0 mult=1 m=1
XM22 CLK_P CLK_N VPWR VPB sky130_fd_pr__pfet_01v8_hvt L=0.15 W=0.63 nf=1 ad=0.1827 as=0.1827 pd=1.84 ps=1.84 nrd=0.46031746031746
+ nrs=0.46031746031746 sa=0 sb=0 sd=0 mult=1 m=1
XM23 CLK_P CLK_N VGND VNB sky130_fd_pr__nfet_01v8 L=0.15 W=0.45 nf=1 ad=0.1305 as=0.1305 pd=1.48 ps=1.48 nrd=0.644444444444444
+ nrs=0.644444444444444 sa=0 sb=0 sd=0 mult=1 m=1
XM24 net5 S_N VPWR VPB sky130_fd_pr__pfet_01v8_hvt L=0.15 W=0.63 nf=1 ad=0.1827 as=0.1827 pd=1.84 ps=1.84 nrd=0.46031746031746
+ nrs=0.46031746031746 sa=0 sb=0 sd=0 mult=1 m=1
XM25 net5 S_N VGND VNB sky130_fd_pr__nfet_01v8 L=0.15 W=0.45 nf=1 ad=0.1305 as=0.1305 pd=1.48 ps=1.48 nrd=0.644444444444444
+ nrs=0.644444444444444 sa=0 sb=0 sd=0 mult=1 m=1
XM26 Q_N net5 VPWR VPB sky130_fd_pr__pfet_01v8_hvt L=0.15 W=1.08 nf=1 ad=0.3132 as=0.3132 pd=2.74 ps=2.74 nrd=0.268518518518518
+ nrs=0.268518518518518 sa=0 sb=0 sd=0 mult=2 m=2
XM27 Q_N net5 VGND VNB sky130_fd_pr__nfet_01v8 L=0.15 W=0.63 nf=1 ad=0.1827 as=0.1827 pd=1.84 ps=1.84 nrd=0.46031746031746
+ nrs=0.46031746031746 sa=0 sb=0 sd=0 mult=2 m=2
.ends

.subckt sky130_efx_lvdig__dfxtp_2 CLK D Q VGND VNB VPB VPWR
*.PININFO D:I Q:O CLK:I VGND:B VNB:B VPB:B VPWR:B
XM0 D_N D VPWR VPB sky130_fd_pr__pfet_01v8_hvt L=0.15 W=0.45 nf=1 ad=0.1305 as=0.1305 pd=1.48 ps=1.48 nrd=0.644444444444444
+ nrs=0.644444444444444 sa=0 sb=0 sd=0 mult=1 m=1
XM1 D_N D VGND VNB sky130_fd_pr__nfet_01v8 L=0.15 W=0.45 nf=1 ad=0.1305 as=0.1305 pd=1.48 ps=1.48 nrd=0.644444444444444
+ nrs=0.644444444444444 sa=0 sb=0 sd=0 mult=1 m=1
XM2 M_N CLK_N D_N VNB sky130_fd_pr__special_nfet_01v8 L=0.15 W=0.36 nf=1 ad=0.1044 as=0.1044 pd=1.3 ps=1.3 nrd=0.805555555555556
+ nrs=0.805555555555556 sa=0 sb=0 sd=0 mult=1 m=1
XM3 M_N CLK_P D_N VPB sky130_fd_pr__pfet_01v8_hvt L=0.15 W=0.45 nf=1 ad=0.1305 as=0.1305 pd=1.48 ps=1.48 nrd=0.644444444444444
+ nrs=0.644444444444444 sa=0 sb=0 sd=0 mult=1 m=1
XM4 M_N CLK_N net1 VPB sky130_fd_pr__pfet_01v8_hvt L=0.15 W=0.45 nf=1 ad=0.1305 as=0.1305 pd=1.48 ps=1.48 nrd=0.644444444444444
+ nrs=0.644444444444444 sa=0 sb=0 sd=0 mult=1 m=1
XM5 net1 M VPWR VPB sky130_fd_pr__pfet_01v8_hvt L=0.15 W=0.45 nf=1 ad=0.1305 as=0.1305 pd=1.48 ps=1.48 nrd=0.644444444444444
+ nrs=0.644444444444444 sa=0 sb=0 sd=0 mult=1 m=1
XM6 M_N CLK_P net2 VNB sky130_fd_pr__special_nfet_01v8 L=0.15 W=0.36 nf=1 ad=0.1044 as=0.1044 pd=1.3 ps=1.3 nrd=0.805555555555556
+ nrs=0.805555555555556 sa=0 sb=0 sd=0 mult=1 m=1
XM7 net2 M VGND VNB sky130_fd_pr__nfet_01v8 L=0.15 W=0.45 nf=1 ad=0.1305 as=0.1305 pd=1.48 ps=1.48 nrd=0.644444444444444
+ nrs=0.644444444444444 sa=0 sb=0 sd=0 mult=1 m=1
XM8 M M_N VPWR VPB sky130_fd_pr__pfet_01v8_hvt L=0.15 W=0.72 nf=1 ad=0.2088 as=0.2088 pd=2.02 ps=2.02 nrd=0.402777777777778
+ nrs=0.402777777777778 sa=0 sb=0 sd=0 mult=1 m=1
XM9 M M_N VGND VNB sky130_fd_pr__nfet_01v8 L=0.15 W=0.63 nf=1 ad=0.1827 as=0.1827 pd=1.84 ps=1.84 nrd=0.46031746031746
+ nrs=0.46031746031746 sa=0 sb=0 sd=0 mult=1 m=1
XM10 S CLK_P M VNB sky130_fd_pr__special_nfet_01v8 L=0.15 W=0.36 nf=1 ad=0.1044 as=0.1044 pd=1.3 ps=1.3 nrd=0.805555555555556
+ nrs=0.805555555555556 sa=0 sb=0 sd=0 mult=1 m=1
XM11 S CLK_N M VPB sky130_fd_pr__pfet_01v8_hvt L=0.15 W=0.45 nf=1 ad=0.1305 as=0.1305 pd=1.48 ps=1.48 nrd=0.644444444444444
+ nrs=0.644444444444444 sa=0 sb=0 sd=0 mult=1 m=1
XM12 S CLK_P net3 VPB sky130_fd_pr__pfet_01v8_hvt L=0.15 W=0.45 nf=1 ad=0.1305 as=0.1305 pd=1.48 ps=1.48 nrd=0.644444444444444
+ nrs=0.644444444444444 sa=0 sb=0 sd=0 mult=1 m=1
XM13 net3 S_N VPWR VPB sky130_fd_pr__pfet_01v8_hvt L=0.15 W=0.45 nf=1 ad=0.1305 as=0.1305 pd=1.48 ps=1.48 nrd=0.644444444444444
+ nrs=0.644444444444444 sa=0 sb=0 sd=0 mult=1 m=1
XM14 S CLK_N net4 VNB sky130_fd_pr__special_nfet_01v8 L=0.15 W=0.36 nf=1 ad=0.1044 as=0.1044 pd=1.3 ps=1.3 nrd=0.805555555555556
+ nrs=0.805555555555556 sa=0 sb=0 sd=0 mult=1 m=1
XM15 net4 S_N VGND VNB sky130_fd_pr__nfet_01v8 L=0.15 W=0.45 nf=1 ad=0.1305 as=0.1305 pd=1.48 ps=1.48 nrd=0.644444444444444
+ nrs=0.644444444444444 sa=0 sb=0 sd=0 mult=1 m=1
XM16 S_N S VPWR VPB sky130_fd_pr__pfet_01v8_hvt L=0.15 W=1.08 nf=1 ad=0.3132 as=0.3132 pd=2.74 ps=2.74 nrd=0.268518518518518
+ nrs=0.268518518518518 sa=0 sb=0 sd=0 mult=1 m=1
XM17 S_N S VGND VNB sky130_fd_pr__nfet_01v8 L=0.15 W=0.63 nf=1 ad=0.1827 as=0.1827 pd=1.84 ps=1.84 nrd=0.46031746031746
+ nrs=0.46031746031746 sa=0 sb=0 sd=0 mult=1 m=1
XM18 Q S_N VPWR VPB sky130_fd_pr__pfet_01v8_hvt L=0.15 W=1.08 nf=1 ad=0.3132 as=0.3132 pd=2.74 ps=2.74 nrd=0.268518518518518
+ nrs=0.268518518518518 sa=0 sb=0 sd=0 mult=2 m=2
XM19 Q S_N VGND VNB sky130_fd_pr__nfet_01v8 L=0.15 W=0.63 nf=1 ad=0.1827 as=0.1827 pd=1.84 ps=1.84 nrd=0.46031746031746
+ nrs=0.46031746031746 sa=0 sb=0 sd=0 mult=2 m=2
XM20 CLK_N CLK VPWR VPB sky130_fd_pr__pfet_01v8_hvt L=0.15 W=0.63 nf=1 ad=0.1827 as=0.1827 pd=1.84 ps=1.84 nrd=0.46031746031746
+ nrs=0.46031746031746 sa=0 sb=0 sd=0 mult=1 m=1
XM21 CLK_N CLK VGND VNB sky130_fd_pr__nfet_01v8 L=0.15 W=0.45 nf=1 ad=0.1305 as=0.1305 pd=1.48 ps=1.48 nrd=0.644444444444444
+ nrs=0.644444444444444 sa=0 sb=0 sd=0 mult=1 m=1
XM22 CLK_P CLK_N VPWR VPB sky130_fd_pr__pfet_01v8_hvt L=0.15 W=0.63 nf=1 ad=0.1827 as=0.1827 pd=1.84 ps=1.84 nrd=0.46031746031746
+ nrs=0.46031746031746 sa=0 sb=0 sd=0 mult=1 m=1
XM23 CLK_P CLK_N VGND VNB sky130_fd_pr__nfet_01v8 L=0.15 W=0.45 nf=1 ad=0.1305 as=0.1305 pd=1.48 ps=1.48 nrd=0.644444444444444
+ nrs=0.644444444444444 sa=0 sb=0 sd=0 mult=1 m=1
.ends

.subckt sky130_efx_lvdig__dlygate4sd3_1 A X VGND VNB VPB VPWR
*.PININFO A:I X:O VGND:B VNB:B VPB:B VPWR:B
XM0 net1 A VPWR VPB sky130_fd_pr__pfet_01v8_hvt L=0.15 W=0.45 nf=1 ad=0.1305 as=0.1305 pd=1.48 ps=1.48 nrd=0.644444444444444
+ nrs=0.644444444444444 sa=0 sb=0 sd=0 mult=1 m=1
XM1 net1 A VGND VNB sky130_fd_pr__nfet_01v8 L=0.15 W=0.45 nf=1 ad=0.1305 as=0.1305 pd=1.48 ps=1.48 nrd=0.644444444444444
+ nrs=0.644444444444444 sa=0 sb=0 sd=0 mult=1 m=1
XM2 net2 net1 VPWR VPB sky130_fd_pr__pfet_01v8_hvt L=0.5 W=0.45 nf=1 ad=0.1305 as=0.1305 pd=1.48 ps=1.48 nrd=0.644444444444444
+ nrs=0.644444444444444 sa=0 sb=0 sd=0 mult=1 m=1
XM3 net2 net1 VGND VNB sky130_fd_pr__nfet_01v8 L=0.5 W=0.45 nf=1 ad=0.1305 as=0.1305 pd=1.48 ps=1.48 nrd=0.644444444444444
+ nrs=0.644444444444444 sa=0 sb=0 sd=0 mult=1 m=1
XM4 net3 net2 VPWR VPB sky130_fd_pr__pfet_01v8_hvt L=0.5 W=0.45 nf=1 ad=0.1305 as=0.1305 pd=1.48 ps=1.48 nrd=0.644444444444444
+ nrs=0.644444444444444 sa=0 sb=0 sd=0 mult=1 m=1
XM5 net3 net2 VGND VNB sky130_fd_pr__nfet_01v8 L=0.5 W=0.45 nf=1 ad=0.1305 as=0.1305 pd=1.48 ps=1.48 nrd=0.644444444444444
+ nrs=0.644444444444444 sa=0 sb=0 sd=0 mult=1 m=1
XM6 X net3 VPWR VPB sky130_fd_pr__pfet_01v8_hvt L=0.15 W=1.08 nf=1 ad=0.3132 as=0.3132 pd=2.74 ps=2.74 nrd=0.268518518518518
+ nrs=0.268518518518518 sa=0 sb=0 sd=0 mult=1 m=1
XM7 X net3 VGND VNB sky130_fd_pr__nfet_01v8 L=0.15 W=0.63 nf=1 ad=0.1827 as=0.1827 pd=1.84 ps=1.84 nrd=0.46031746031746
+ nrs=0.46031746031746 sa=0 sb=0 sd=0 mult=1 m=1
.ends

.subckt sky130_efx_lvdig__edfxbp_1 CLK D DE Q Q_N VGND VNB VPB VPWR
*.PININFO Q:O CLK:I DE:I Q_N:O D:I VGND:B VNB:B VPB:B VPWR:B
XM0 DM_N D net1 VPB sky130_fd_pr__pfet_01v8_hvt L=0.15 W=0.63 nf=1 ad=0.1827 as=0.1827 pd=1.84 ps=1.84 nrd=0.46031746031746
+ nrs=0.46031746031746 sa=0 sb=0 sd=0 mult=1 m=1
XM1 net1 DE_N VPWR VPB sky130_fd_pr__pfet_01v8_hvt L=0.15 W=0.63 nf=1 ad=0.1827 as=0.1827 pd=1.84 ps=1.84 nrd=0.46031746031746
+ nrs=0.46031746031746 sa=0 sb=0 sd=0 mult=1 m=1
XM2 DM_N S_N net2 VPB sky130_fd_pr__pfet_01v8_hvt L=0.15 W=0.63 nf=1 ad=0.1827 as=0.1827 pd=1.84 ps=1.84 nrd=0.46031746031746
+ nrs=0.46031746031746 sa=0 sb=0 sd=0 mult=1 m=1
XM3 net2 DE VPWR VPB sky130_fd_pr__pfet_01v8_hvt L=0.15 W=0.63 nf=1 ad=0.1827 as=0.1827 pd=1.84 ps=1.84 nrd=0.46031746031746
+ nrs=0.46031746031746 sa=0 sb=0 sd=0 mult=1 m=1
XM4 DM_N D net3 VNB sky130_fd_pr__nfet_01v8 L=0.15 W=0.45 nf=1 ad=0.1305 as=0.1305 pd=1.48 ps=1.48 nrd=0.644444444444444
+ nrs=0.644444444444444 sa=0 sb=0 sd=0 mult=1 m=1
XM5 net3 DE VGND VNB sky130_fd_pr__nfet_01v8 L=0.15 W=0.45 nf=1 ad=0.1305 as=0.1305 pd=1.48 ps=1.48 nrd=0.644444444444444
+ nrs=0.644444444444444 sa=0 sb=0 sd=0 mult=1 m=1
XM6 DM_N S_N net4 VNB sky130_fd_pr__nfet_01v8 L=0.15 W=0.45 nf=1 ad=0.1305 as=0.1305 pd=1.48 ps=1.48 nrd=0.644444444444444
+ nrs=0.644444444444444 sa=0 sb=0 sd=0 mult=1 m=1
XM7 net4 DE_N VGND VNB sky130_fd_pr__nfet_01v8 L=0.15 W=0.45 nf=1 ad=0.1305 as=0.1305 pd=1.48 ps=1.48 nrd=0.644444444444444
+ nrs=0.644444444444444 sa=0 sb=0 sd=0 mult=1 m=1
XM8 M_N CLK_N DM_N VNB sky130_fd_pr__special_nfet_01v8 L=0.15 W=0.36 nf=1 ad=0.1044 as=0.1044 pd=1.3 ps=1.3 nrd=0.805555555555556
+ nrs=0.805555555555556 sa=0 sb=0 sd=0 mult=1 m=1
XM9 M_N CLK_P DM_N VPB sky130_fd_pr__pfet_01v8_hvt L=0.15 W=0.45 nf=1 ad=0.1305 as=0.1305 pd=1.48 ps=1.48 nrd=0.644444444444444
+ nrs=0.644444444444444 sa=0 sb=0 sd=0 mult=1 m=1
XM10 M_N CLK_N net5 VPB sky130_fd_pr__pfet_01v8_hvt L=0.15 W=0.45 nf=1 ad=0.1305 as=0.1305 pd=1.48 ps=1.48 nrd=0.644444444444444
+ nrs=0.644444444444444 sa=0 sb=0 sd=0 mult=1 m=1
XM11 net5 M VPWR VPB sky130_fd_pr__pfet_01v8_hvt L=0.15 W=0.45 nf=1 ad=0.1305 as=0.1305 pd=1.48 ps=1.48 nrd=0.644444444444444
+ nrs=0.644444444444444 sa=0 sb=0 sd=0 mult=1 m=1
XM12 M_N CLK_P net6 VNB sky130_fd_pr__special_nfet_01v8 L=0.15 W=0.36 nf=1 ad=0.1044 as=0.1044 pd=1.3 ps=1.3 nrd=0.805555555555556
+ nrs=0.805555555555556 sa=0 sb=0 sd=0 mult=1 m=1
XM13 net6 M VGND VNB sky130_fd_pr__nfet_01v8 L=0.15 W=0.45 nf=1 ad=0.1305 as=0.1305 pd=1.48 ps=1.48 nrd=0.644444444444444
+ nrs=0.644444444444444 sa=0 sb=0 sd=0 mult=1 m=1
XM14 M M_N VPWR VPB sky130_fd_pr__pfet_01v8_hvt L=0.15 W=0.72 nf=1 ad=0.2088 as=0.2088 pd=2.02 ps=2.02 nrd=0.402777777777778
+ nrs=0.402777777777778 sa=0 sb=0 sd=0 mult=1 m=1
XM15 M M_N VGND VNB sky130_fd_pr__nfet_01v8 L=0.15 W=0.63 nf=1 ad=0.1827 as=0.1827 pd=1.84 ps=1.84 nrd=0.46031746031746
+ nrs=0.46031746031746 sa=0 sb=0 sd=0 mult=1 m=1
XM16 S CLK_N net7 VPB sky130_fd_pr__pfet_01v8_hvt L=0.15 W=0.45 nf=1 ad=0.1305 as=0.1305 pd=1.48 ps=1.48 nrd=0.644444444444444
+ nrs=0.644444444444444 sa=0 sb=0 sd=0 mult=1 m=1
XM17 net7 M VPWR VPB sky130_fd_pr__pfet_01v8_hvt L=0.15 W=0.45 nf=1 ad=0.1305 as=0.1305 pd=1.48 ps=1.48 nrd=0.644444444444444
+ nrs=0.644444444444444 sa=0 sb=0 sd=0 mult=1 m=1
XM18 S CLK_P net8 VNB sky130_fd_pr__special_nfet_01v8 L=0.15 W=0.36 nf=1 ad=0.1044 as=0.1044 pd=1.3 ps=1.3 nrd=0.805555555555556
+ nrs=0.805555555555556 sa=0 sb=0 sd=0 mult=1 m=1
XM19 net8 M VGND VNB sky130_fd_pr__nfet_01v8 L=0.15 W=0.45 nf=1 ad=0.1305 as=0.1305 pd=1.48 ps=1.48 nrd=0.644444444444444
+ nrs=0.644444444444444 sa=0 sb=0 sd=0 mult=1 m=1
XM20 S CLK_P net9 VPB sky130_fd_pr__pfet_01v8_hvt L=0.15 W=0.45 nf=1 ad=0.1305 as=0.1305 pd=1.48 ps=1.48 nrd=0.644444444444444
+ nrs=0.644444444444444 sa=0 sb=0 sd=0 mult=1 m=1
XM21 net9 S_N VPWR VPB sky130_fd_pr__pfet_01v8_hvt L=0.15 W=0.45 nf=1 ad=0.1305 as=0.1305 pd=1.48 ps=1.48 nrd=0.644444444444444
+ nrs=0.644444444444444 sa=0 sb=0 sd=0 mult=1 m=1
XM22 S CLK_N net10 VNB sky130_fd_pr__special_nfet_01v8 L=0.15 W=0.36 nf=1 ad=0.1044 as=0.1044 pd=1.3 ps=1.3 nrd=0.805555555555556
+ nrs=0.805555555555556 sa=0 sb=0 sd=0 mult=1 m=1
XM23 net10 S_N VGND VNB sky130_fd_pr__nfet_01v8 L=0.15 W=0.45 nf=1 ad=0.1305 as=0.1305 pd=1.48 ps=1.48 nrd=0.644444444444444
+ nrs=0.644444444444444 sa=0 sb=0 sd=0 mult=1 m=1
XM24 Q S VPWR VPB sky130_fd_pr__pfet_01v8_hvt L=0.15 W=1.08 nf=1 ad=0.3132 as=0.3132 pd=2.74 ps=2.74 nrd=0.268518518518518
+ nrs=0.268518518518518 sa=0 sb=0 sd=0 mult=1 m=1
XM25 Q S VGND VNB sky130_fd_pr__nfet_01v8 L=0.15 W=0.63 nf=1 ad=0.1827 as=0.1827 pd=1.84 ps=1.84 nrd=0.46031746031746
+ nrs=0.46031746031746 sa=0 sb=0 sd=0 mult=1 m=1
XM26 CLK_N CLK VPWR VPB sky130_fd_pr__pfet_01v8_hvt L=0.15 W=0.63 nf=1 ad=0.1827 as=0.1827 pd=1.84 ps=1.84 nrd=0.46031746031746
+ nrs=0.46031746031746 sa=0 sb=0 sd=0 mult=1 m=1
XM27 CLK_N CLK VGND VNB sky130_fd_pr__nfet_01v8 L=0.15 W=0.45 nf=1 ad=0.1305 as=0.1305 pd=1.48 ps=1.48 nrd=0.644444444444444
+ nrs=0.644444444444444 sa=0 sb=0 sd=0 mult=1 m=1
XM28 CLK_P CLK_N VPWR VPB sky130_fd_pr__pfet_01v8_hvt L=0.15 W=0.63 nf=1 ad=0.1827 as=0.1827 pd=1.84 ps=1.84 nrd=0.46031746031746
+ nrs=0.46031746031746 sa=0 sb=0 sd=0 mult=1 m=1
XM29 CLK_P CLK_N VGND VNB sky130_fd_pr__nfet_01v8 L=0.15 W=0.45 nf=1 ad=0.1305 as=0.1305 pd=1.48 ps=1.48 nrd=0.644444444444444
+ nrs=0.644444444444444 sa=0 sb=0 sd=0 mult=1 m=1
XM30 DE_N DE VPWR VPB sky130_fd_pr__pfet_01v8_hvt L=0.15 W=0.63 nf=1 ad=0.1827 as=0.1827 pd=1.84 ps=1.84 nrd=0.46031746031746
+ nrs=0.46031746031746 sa=0 sb=0 sd=0 mult=1 m=1
XM31 DE_N DE VGND VNB sky130_fd_pr__nfet_01v8 L=0.15 W=0.45 nf=1 ad=0.1305 as=0.1305 pd=1.48 ps=1.48 nrd=0.644444444444444
+ nrs=0.644444444444444 sa=0 sb=0 sd=0 mult=1 m=1
XM32 S_N S VPWR VPB sky130_fd_pr__pfet_01v8_hvt L=0.15 W=0.63 nf=1 ad=0.1827 as=0.1827 pd=1.84 ps=1.84 nrd=0.46031746031746
+ nrs=0.46031746031746 sa=0 sb=0 sd=0 mult=1 m=1
XM33 S_N S VGND VNB sky130_fd_pr__nfet_01v8 L=0.15 W=0.45 nf=1 ad=0.1305 as=0.1305 pd=1.48 ps=1.48 nrd=0.644444444444444
+ nrs=0.644444444444444 sa=0 sb=0 sd=0 mult=1 m=1
XM34 Q_N S_N VPWR VPB sky130_fd_pr__pfet_01v8_hvt L=0.15 W=1.08 nf=1 ad=0.3132 as=0.3132 pd=2.74 ps=2.74 nrd=0.268518518518518
+ nrs=0.268518518518518 sa=0 sb=0 sd=0 mult=1 m=1
XM35 Q_N S_N VGND VNB sky130_fd_pr__nfet_01v8 L=0.15 W=0.63 nf=1 ad=0.1827 as=0.1827 pd=1.84 ps=1.84 nrd=0.46031746031746
+ nrs=0.46031746031746 sa=0 sb=0 sd=0 mult=1 m=1
.ends

.subckt sky130_efx_lvdig__edfxtp_1 CLK D DE Q VGND VNB VPB VPWR
*.PININFO Q:O CLK:I DE:I D:I VGND:B VNB:B VPB:B VPWR:B
XM0 DM_N D net1 VPB sky130_fd_pr__pfet_01v8_hvt L=0.15 W=0.63 nf=1 ad=0.1827 as=0.1827 pd=1.84 ps=1.84 nrd=0.46031746031746
+ nrs=0.46031746031746 sa=0 sb=0 sd=0 mult=1 m=1
XM1 net1 DE_N VPWR VPB sky130_fd_pr__pfet_01v8_hvt L=0.15 W=0.63 nf=1 ad=0.1827 as=0.1827 pd=1.84 ps=1.84 nrd=0.46031746031746
+ nrs=0.46031746031746 sa=0 sb=0 sd=0 mult=1 m=1
XM2 DM_N S_N net2 VPB sky130_fd_pr__pfet_01v8_hvt L=0.15 W=0.63 nf=1 ad=0.1827 as=0.1827 pd=1.84 ps=1.84 nrd=0.46031746031746
+ nrs=0.46031746031746 sa=0 sb=0 sd=0 mult=1 m=1
XM3 net2 DE VPWR VPB sky130_fd_pr__pfet_01v8_hvt L=0.15 W=0.63 nf=1 ad=0.1827 as=0.1827 pd=1.84 ps=1.84 nrd=0.46031746031746
+ nrs=0.46031746031746 sa=0 sb=0 sd=0 mult=1 m=1
XM4 DM_N D net3 VNB sky130_fd_pr__nfet_01v8 L=0.15 W=0.45 nf=1 ad=0.1305 as=0.1305 pd=1.48 ps=1.48 nrd=0.644444444444444
+ nrs=0.644444444444444 sa=0 sb=0 sd=0 mult=1 m=1
XM5 net3 DE VGND VNB sky130_fd_pr__nfet_01v8 L=0.15 W=0.45 nf=1 ad=0.1305 as=0.1305 pd=1.48 ps=1.48 nrd=0.644444444444444
+ nrs=0.644444444444444 sa=0 sb=0 sd=0 mult=1 m=1
XM6 DM_N S_N net4 VNB sky130_fd_pr__nfet_01v8 L=0.15 W=0.45 nf=1 ad=0.1305 as=0.1305 pd=1.48 ps=1.48 nrd=0.644444444444444
+ nrs=0.644444444444444 sa=0 sb=0 sd=0 mult=1 m=1
XM7 net4 DE_N VGND VNB sky130_fd_pr__nfet_01v8 L=0.15 W=0.45 nf=1 ad=0.1305 as=0.1305 pd=1.48 ps=1.48 nrd=0.644444444444444
+ nrs=0.644444444444444 sa=0 sb=0 sd=0 mult=1 m=1
XM8 M_N CLK_N DM_N VNB sky130_fd_pr__special_nfet_01v8 L=0.15 W=0.36 nf=1 ad=0.1044 as=0.1044 pd=1.3 ps=1.3 nrd=0.805555555555556
+ nrs=0.805555555555556 sa=0 sb=0 sd=0 mult=1 m=1
XM9 M_N CLK_P DM_N VPB sky130_fd_pr__pfet_01v8_hvt L=0.15 W=0.45 nf=1 ad=0.1305 as=0.1305 pd=1.48 ps=1.48 nrd=0.644444444444444
+ nrs=0.644444444444444 sa=0 sb=0 sd=0 mult=1 m=1
XM10 M_N CLK_N net5 VPB sky130_fd_pr__pfet_01v8_hvt L=0.15 W=0.45 nf=1 ad=0.1305 as=0.1305 pd=1.48 ps=1.48 nrd=0.644444444444444
+ nrs=0.644444444444444 sa=0 sb=0 sd=0 mult=1 m=1
XM11 net5 M VPWR VPB sky130_fd_pr__pfet_01v8_hvt L=0.15 W=0.45 nf=1 ad=0.1305 as=0.1305 pd=1.48 ps=1.48 nrd=0.644444444444444
+ nrs=0.644444444444444 sa=0 sb=0 sd=0 mult=1 m=1
XM12 M_N CLK_P net6 VNB sky130_fd_pr__special_nfet_01v8 L=0.15 W=0.36 nf=1 ad=0.1044 as=0.1044 pd=1.3 ps=1.3 nrd=0.805555555555556
+ nrs=0.805555555555556 sa=0 sb=0 sd=0 mult=1 m=1
XM13 net6 M VGND VNB sky130_fd_pr__nfet_01v8 L=0.15 W=0.45 nf=1 ad=0.1305 as=0.1305 pd=1.48 ps=1.48 nrd=0.644444444444444
+ nrs=0.644444444444444 sa=0 sb=0 sd=0 mult=1 m=1
XM14 M M_N VPWR VPB sky130_fd_pr__pfet_01v8_hvt L=0.15 W=0.72 nf=1 ad=0.2088 as=0.2088 pd=2.02 ps=2.02 nrd=0.402777777777778
+ nrs=0.402777777777778 sa=0 sb=0 sd=0 mult=1 m=1
XM15 M M_N VGND VNB sky130_fd_pr__nfet_01v8 L=0.15 W=0.63 nf=1 ad=0.1827 as=0.1827 pd=1.84 ps=1.84 nrd=0.46031746031746
+ nrs=0.46031746031746 sa=0 sb=0 sd=0 mult=1 m=1
XM16 S CLK_N net7 VPB sky130_fd_pr__pfet_01v8_hvt L=0.15 W=0.45 nf=1 ad=0.1305 as=0.1305 pd=1.48 ps=1.48 nrd=0.644444444444444
+ nrs=0.644444444444444 sa=0 sb=0 sd=0 mult=1 m=1
XM17 net7 M VPWR VPB sky130_fd_pr__pfet_01v8_hvt L=0.15 W=0.45 nf=1 ad=0.1305 as=0.1305 pd=1.48 ps=1.48 nrd=0.644444444444444
+ nrs=0.644444444444444 sa=0 sb=0 sd=0 mult=1 m=1
XM18 S CLK_P net8 VNB sky130_fd_pr__special_nfet_01v8 L=0.15 W=0.36 nf=1 ad=0.1044 as=0.1044 pd=1.3 ps=1.3 nrd=0.805555555555556
+ nrs=0.805555555555556 sa=0 sb=0 sd=0 mult=1 m=1
XM19 net8 M VGND VNB sky130_fd_pr__nfet_01v8 L=0.15 W=0.45 nf=1 ad=0.1305 as=0.1305 pd=1.48 ps=1.48 nrd=0.644444444444444
+ nrs=0.644444444444444 sa=0 sb=0 sd=0 mult=1 m=1
XM20 S CLK_P net9 VPB sky130_fd_pr__pfet_01v8_hvt L=0.15 W=0.45 nf=1 ad=0.1305 as=0.1305 pd=1.48 ps=1.48 nrd=0.644444444444444
+ nrs=0.644444444444444 sa=0 sb=0 sd=0 mult=1 m=1
XM21 net9 S_N VPWR VPB sky130_fd_pr__pfet_01v8_hvt L=0.15 W=0.45 nf=1 ad=0.1305 as=0.1305 pd=1.48 ps=1.48 nrd=0.644444444444444
+ nrs=0.644444444444444 sa=0 sb=0 sd=0 mult=1 m=1
XM22 S CLK_N net10 VNB sky130_fd_pr__special_nfet_01v8 L=0.15 W=0.36 nf=1 ad=0.1044 as=0.1044 pd=1.3 ps=1.3 nrd=0.805555555555556
+ nrs=0.805555555555556 sa=0 sb=0 sd=0 mult=1 m=1
XM23 net10 S_N VGND VNB sky130_fd_pr__nfet_01v8 L=0.15 W=0.45 nf=1 ad=0.1305 as=0.1305 pd=1.48 ps=1.48 nrd=0.644444444444444
+ nrs=0.644444444444444 sa=0 sb=0 sd=0 mult=1 m=1
XM24 Q S VPWR VPB sky130_fd_pr__pfet_01v8_hvt L=0.15 W=1.08 nf=1 ad=0.3132 as=0.3132 pd=2.74 ps=2.74 nrd=0.268518518518518
+ nrs=0.268518518518518 sa=0 sb=0 sd=0 mult=1 m=1
XM25 Q S VGND VNB sky130_fd_pr__nfet_01v8 L=0.15 W=0.63 nf=1 ad=0.1827 as=0.1827 pd=1.84 ps=1.84 nrd=0.46031746031746
+ nrs=0.46031746031746 sa=0 sb=0 sd=0 mult=1 m=1
XM26 CLK_N CLK VPWR VPB sky130_fd_pr__pfet_01v8_hvt L=0.15 W=0.63 nf=1 ad=0.1827 as=0.1827 pd=1.84 ps=1.84 nrd=0.46031746031746
+ nrs=0.46031746031746 sa=0 sb=0 sd=0 mult=1 m=1
XM27 CLK_N CLK VGND VNB sky130_fd_pr__nfet_01v8 L=0.15 W=0.45 nf=1 ad=0.1305 as=0.1305 pd=1.48 ps=1.48 nrd=0.644444444444444
+ nrs=0.644444444444444 sa=0 sb=0 sd=0 mult=1 m=1
XM28 CLK_P CLK_N VPWR VPB sky130_fd_pr__pfet_01v8_hvt L=0.15 W=0.63 nf=1 ad=0.1827 as=0.1827 pd=1.84 ps=1.84 nrd=0.46031746031746
+ nrs=0.46031746031746 sa=0 sb=0 sd=0 mult=1 m=1
XM29 CLK_P CLK_N VGND VNB sky130_fd_pr__nfet_01v8 L=0.15 W=0.45 nf=1 ad=0.1305 as=0.1305 pd=1.48 ps=1.48 nrd=0.644444444444444
+ nrs=0.644444444444444 sa=0 sb=0 sd=0 mult=1 m=1
XM30 DE_N DE VPWR VPB sky130_fd_pr__pfet_01v8_hvt L=0.15 W=0.63 nf=1 ad=0.1827 as=0.1827 pd=1.84 ps=1.84 nrd=0.46031746031746
+ nrs=0.46031746031746 sa=0 sb=0 sd=0 mult=1 m=1
XM31 DE_N DE VGND VNB sky130_fd_pr__nfet_01v8 L=0.15 W=0.45 nf=1 ad=0.1305 as=0.1305 pd=1.48 ps=1.48 nrd=0.644444444444444
+ nrs=0.644444444444444 sa=0 sb=0 sd=0 mult=1 m=1
XM32 S_N S VPWR VPB sky130_fd_pr__pfet_01v8_hvt L=0.15 W=0.63 nf=1 ad=0.1827 as=0.1827 pd=1.84 ps=1.84 nrd=0.46031746031746
+ nrs=0.46031746031746 sa=0 sb=0 sd=0 mult=1 m=1
XM33 S_N S VGND VNB sky130_fd_pr__nfet_01v8 L=0.15 W=0.45 nf=1 ad=0.1305 as=0.1305 pd=1.48 ps=1.48 nrd=0.644444444444444
+ nrs=0.644444444444444 sa=0 sb=0 sd=0 mult=1 m=1
.ends

.subckt sky130_efx_lvdig__ha_1 A B COUT SUM VGND VNB VPB VPWR
*.PININFO COUT:O SUM:O A:I B:I VGND:B VNB:B VPB:B VPWR:B
XM0 COUT_N A VPWR VPB sky130_fd_pr__pfet_01v8_hvt L=0.15 W=0.45 nf=1 ad=0.1305 as=0.1305 pd=1.48 ps=1.48 nrd=0.644444444444444
+ nrs=0.644444444444444 sa=0 sb=0 sd=0 mult=1 m=1
XM1 COUT_N B VPWR VPB sky130_fd_pr__pfet_01v8_hvt L=0.15 W=0.45 nf=1 ad=0.1305 as=0.1305 pd=1.48 ps=1.48 nrd=0.644444444444444
+ nrs=0.644444444444444 sa=0 sb=0 sd=0 mult=1 m=1
XM2 COUT_N B net1 VNB sky130_fd_pr__nfet_01v8 L=0.15 W=0.45 nf=1 ad=0.1305 as=0.1305 pd=1.48 ps=1.48 nrd=0.644444444444444
+ nrs=0.644444444444444 sa=0 sb=0 sd=0 mult=1 m=1
XM3 net1 A VGND VNB sky130_fd_pr__nfet_01v8 L=0.15 W=0.45 nf=1 ad=0.1305 as=0.1305 pd=1.48 ps=1.48 nrd=0.644444444444444
+ nrs=0.644444444444444 sa=0 sb=0 sd=0 mult=1 m=1
XM4 COUT COUT_N VPWR VPB sky130_fd_pr__pfet_01v8_hvt L=0.15 W=1.08 nf=1 ad=0.3132 as=0.3132 pd=2.74 ps=2.74 nrd=0.268518518518518
+ nrs=0.268518518518518 sa=0 sb=0 sd=0 mult=1 m=1
XM5 COUT COUT_N VGND VNB sky130_fd_pr__nfet_01v8 L=0.15 W=0.63 nf=1 ad=0.1827 as=0.1827 pd=1.84 ps=1.84 nrd=0.46031746031746
+ nrs=0.46031746031746 sa=0 sb=0 sd=0 mult=1 m=1
XM6 net2 COUT_N VPWR VPB sky130_fd_pr__pfet_01v8_hvt L=0.15 W=0.45 nf=1 ad=0.1305 as=0.1305 pd=1.48 ps=1.48 nrd=0.644444444444444
+ nrs=0.644444444444444 sa=0 sb=0 sd=0 mult=1 m=1
XM7 net2 B net3 VPB sky130_fd_pr__pfet_01v8_hvt L=0.15 W=0.45 nf=1 ad=0.1305 as=0.1305 pd=1.48 ps=1.48 nrd=0.644444444444444
+ nrs=0.644444444444444 sa=0 sb=0 sd=0 mult=1 m=1
XM8 net3 A VPWR VPB sky130_fd_pr__pfet_01v8_hvt L=0.15 W=0.45 nf=1 ad=0.1305 as=0.1305 pd=1.48 ps=1.48 nrd=0.644444444444444
+ nrs=0.644444444444444 sa=0 sb=0 sd=0 mult=1 m=1
XM9 net2 COUT_N net4 VNB sky130_fd_pr__nfet_01v8 L=0.15 W=0.45 nf=1 ad=0.1305 as=0.1305 pd=1.48 ps=1.48 nrd=0.644444444444444
+ nrs=0.644444444444444 sa=0 sb=0 sd=0 mult=1 m=1
XM10 net4 A VGND VNB sky130_fd_pr__nfet_01v8 L=0.15 W=0.45 nf=1 ad=0.1305 as=0.1305 pd=1.48 ps=1.48 nrd=0.644444444444444
+ nrs=0.644444444444444 sa=0 sb=0 sd=0 mult=1 m=1
XM11 net4 B VGND VNB sky130_fd_pr__nfet_01v8 L=0.15 W=0.45 nf=1 ad=0.1305 as=0.1305 pd=1.48 ps=1.48 nrd=0.644444444444444
+ nrs=0.644444444444444 sa=0 sb=0 sd=0 mult=1 m=1
XM12 SUM net2 VPWR VPB sky130_fd_pr__pfet_01v8_hvt L=0.15 W=1.08 nf=1 ad=0.3132 as=0.3132 pd=2.74 ps=2.74 nrd=0.268518518518518
+ nrs=0.268518518518518 sa=0 sb=0 sd=0 mult=1 m=1
XM13 SUM net2 VGND VNB sky130_fd_pr__nfet_01v8 L=0.15 W=0.63 nf=1 ad=0.1827 as=0.1827 pd=1.84 ps=1.84 nrd=0.46031746031746
+ nrs=0.46031746031746 sa=0 sb=0 sd=0 mult=1 m=1
.ends

.subckt sky130_efx_lvdig__inv_1 A Y VGND VNB VPB VPWR
*.PININFO A:I Y:O VGND:B VNB:B VPB:B VPWR:B
XM0 Y A VPWR VPB sky130_fd_pr__pfet_01v8_hvt L=0.15 W=1.08 nf=1 ad=0.3132 as=0.3132 pd=2.74 ps=2.74 nrd=0.268518518518518
+ nrs=0.268518518518518 sa=0 sb=0 sd=0 mult=1 m=1
XM1 Y A VGND VNB sky130_fd_pr__nfet_01v8 L=0.15 W=0.63 nf=1 ad=0.1827 as=0.1827 pd=1.84 ps=1.84 nrd=0.46031746031746
+ nrs=0.46031746031746 sa=0 sb=0 sd=0 mult=1 m=1
.ends

.subckt sky130_efx_lvdig__inv_2 A Y VGND VNB VPB VPWR
*.PININFO A:I Y:O VGND:B VNB:B VPB:B VPWR:B
XM0 Y A VPWR VPB sky130_fd_pr__pfet_01v8_hvt L=0.15 W=1.08 nf=1 ad=0.3132 as=0.3132 pd=2.74 ps=2.74 nrd=0.268518518518518
+ nrs=0.268518518518518 sa=0 sb=0 sd=0 mult=2 m=2
XM1 Y A VGND VNB sky130_fd_pr__nfet_01v8 L=0.15 W=0.63 nf=1 ad=0.1827 as=0.1827 pd=1.84 ps=1.84 nrd=0.46031746031746
+ nrs=0.46031746031746 sa=0 sb=0 sd=0 mult=2 m=2
.ends

.subckt sky130_efx_lvdig__inv_4 A Y VGND VNB VPB VPWR
*.PININFO A:I Y:O VGND:B VNB:B VPB:B VPWR:B
XM0 Y A VPWR VPB sky130_fd_pr__pfet_01v8_hvt L=0.15 W=1.08 nf=1 ad=0.3132 as=0.3132 pd=2.74 ps=2.74 nrd=0.268518518518518
+ nrs=0.268518518518518 sa=0 sb=0 sd=0 mult=4 m=4
XM1 Y A VGND VNB sky130_fd_pr__nfet_01v8 L=0.15 W=0.63 nf=1 ad=0.1827 as=0.1827 pd=1.84 ps=1.84 nrd=0.46031746031746
+ nrs=0.46031746031746 sa=0 sb=0 sd=0 mult=4 m=4
.ends

.subckt sky130_efx_lvdig__mux2_1 A0 A1 S X VGND VNB VPB VPWR
*.PININFO S:I X:O A0:I A1:I VGND:B VNB:B VPB:B VPWR:B
XM0 S_N S VPWR VPB sky130_fd_pr__pfet_01v8_hvt L=0.15 W=0.45 nf=1 ad=0.1305 as=0.1305 pd=1.48 ps=1.48 nrd=0.644444444444444
+ nrs=0.644444444444444 sa=0 sb=0 sd=0 mult=1 m=1
XM1 S_N S VGND VNB sky130_fd_pr__nfet_01v8 L=0.15 W=0.45 nf=1 ad=0.1305 as=0.1305 pd=1.48 ps=1.48 nrd=0.644444444444444
+ nrs=0.644444444444444 sa=0 sb=0 sd=0 mult=1 m=1
XM2 net1 A0 net2 VPB sky130_fd_pr__pfet_01v8_hvt L=0.15 W=0.45 nf=1 ad=0.1305 as=0.1305 pd=1.48 ps=1.48 nrd=0.644444444444444
+ nrs=0.644444444444444 sa=0 sb=0 sd=0 mult=1 m=1
XM3 net2 S VPWR VPB sky130_fd_pr__pfet_01v8_hvt L=0.15 W=0.45 nf=1 ad=0.1305 as=0.1305 pd=1.48 ps=1.48 nrd=0.644444444444444
+ nrs=0.644444444444444 sa=0 sb=0 sd=0 mult=1 m=1
XM4 net1 A1 net3 VPB sky130_fd_pr__pfet_01v8_hvt L=0.15 W=0.45 nf=1 ad=0.1305 as=0.1305 pd=1.48 ps=1.48 nrd=0.644444444444444
+ nrs=0.644444444444444 sa=0 sb=0 sd=0 mult=1 m=1
XM5 net3 S_N VPWR VPB sky130_fd_pr__pfet_01v8_hvt L=0.15 W=0.45 nf=1 ad=0.1305 as=0.1305 pd=1.48 ps=1.48 nrd=0.644444444444444
+ nrs=0.644444444444444 sa=0 sb=0 sd=0 mult=1 m=1
XM6 net1 A0 net4 VNB sky130_fd_pr__nfet_01v8 L=0.15 W=0.45 nf=1 ad=0.1305 as=0.1305 pd=1.48 ps=1.48 nrd=0.644444444444444
+ nrs=0.644444444444444 sa=0 sb=0 sd=0 mult=1 m=1
XM7 net4 S_N VGND VNB sky130_fd_pr__nfet_01v8 L=0.15 W=0.45 nf=1 ad=0.1305 as=0.1305 pd=1.48 ps=1.48 nrd=0.644444444444444
+ nrs=0.644444444444444 sa=0 sb=0 sd=0 mult=1 m=1
XM8 net1 A1 net5 VNB sky130_fd_pr__nfet_01v8 L=0.15 W=0.45 nf=1 ad=0.1305 as=0.1305 pd=1.48 ps=1.48 nrd=0.644444444444444
+ nrs=0.644444444444444 sa=0 sb=0 sd=0 mult=1 m=1
XM9 net5 S VGND VNB sky130_fd_pr__nfet_01v8 L=0.15 W=0.45 nf=1 ad=0.1305 as=0.1305 pd=1.48 ps=1.48 nrd=0.644444444444444
+ nrs=0.644444444444444 sa=0 sb=0 sd=0 mult=1 m=1
XM10 X net1 VPWR VPB sky130_fd_pr__pfet_01v8_hvt L=0.15 W=1.08 nf=1 ad=0.3132 as=0.3132 pd=2.74 ps=2.74 nrd=0.268518518518518
+ nrs=0.268518518518518 sa=0 sb=0 sd=0 mult=1 m=1
XM11 X net1 VGND VNB sky130_fd_pr__nfet_01v8 L=0.15 W=0.63 nf=1 ad=0.1827 as=0.1827 pd=1.84 ps=1.84 nrd=0.46031746031746
+ nrs=0.46031746031746 sa=0 sb=0 sd=0 mult=1 m=1
.ends

.subckt sky130_efx_lvdig__mux2_2 A0 A1 S X VGND VNB VPB VPWR
*.PININFO S:I X:O A0:I A1:I VGND:B VNB:B VPB:B VPWR:B
XM0 S_N S VPWR VPB sky130_fd_pr__pfet_01v8_hvt L=0.15 W=0.63 nf=1 ad=0.1827 as=0.1827 pd=1.84 ps=1.84 nrd=0.46031746031746
+ nrs=0.46031746031746 sa=0 sb=0 sd=0 mult=1 m=1
XM1 S_N S VGND VNB sky130_fd_pr__nfet_01v8 L=0.15 W=0.45 nf=1 ad=0.1305 as=0.1305 pd=1.48 ps=1.48 nrd=0.644444444444444
+ nrs=0.644444444444444 sa=0 sb=0 sd=0 mult=1 m=1
XM2 net1 A0 net2 VPB sky130_fd_pr__pfet_01v8_hvt L=0.15 W=0.63 nf=1 ad=0.1827 as=0.1827 pd=1.84 ps=1.84 nrd=0.46031746031746
+ nrs=0.46031746031746 sa=0 sb=0 sd=0 mult=1 m=1
XM3 net2 S VPWR VPB sky130_fd_pr__pfet_01v8_hvt L=0.15 W=0.63 nf=1 ad=0.1827 as=0.1827 pd=1.84 ps=1.84 nrd=0.46031746031746
+ nrs=0.46031746031746 sa=0 sb=0 sd=0 mult=1 m=1
XM4 net1 A1 net3 VPB sky130_fd_pr__pfet_01v8_hvt L=0.15 W=0.63 nf=1 ad=0.1827 as=0.1827 pd=1.84 ps=1.84 nrd=0.46031746031746
+ nrs=0.46031746031746 sa=0 sb=0 sd=0 mult=1 m=1
XM5 net3 S_N VPWR VPB sky130_fd_pr__pfet_01v8_hvt L=0.15 W=0.63 nf=1 ad=0.1827 as=0.1827 pd=1.84 ps=1.84 nrd=0.46031746031746
+ nrs=0.46031746031746 sa=0 sb=0 sd=0 mult=1 m=1
XM6 net1 A0 net4 VNB sky130_fd_pr__nfet_01v8 L=0.15 W=0.45 nf=1 ad=0.1305 as=0.1305 pd=1.48 ps=1.48 nrd=0.644444444444444
+ nrs=0.644444444444444 sa=0 sb=0 sd=0 mult=1 m=1
XM7 net4 S_N VGND VNB sky130_fd_pr__nfet_01v8 L=0.15 W=0.45 nf=1 ad=0.1305 as=0.1305 pd=1.48 ps=1.48 nrd=0.644444444444444
+ nrs=0.644444444444444 sa=0 sb=0 sd=0 mult=1 m=1
XM8 net1 A1 net5 VNB sky130_fd_pr__nfet_01v8 L=0.15 W=0.45 nf=1 ad=0.1305 as=0.1305 pd=1.48 ps=1.48 nrd=0.644444444444444
+ nrs=0.644444444444444 sa=0 sb=0 sd=0 mult=1 m=1
XM9 net5 S VGND VNB sky130_fd_pr__nfet_01v8 L=0.15 W=0.45 nf=1 ad=0.1305 as=0.1305 pd=1.48 ps=1.48 nrd=0.644444444444444
+ nrs=0.644444444444444 sa=0 sb=0 sd=0 mult=1 m=1
XM10 X net1 VPWR VPB sky130_fd_pr__pfet_01v8_hvt L=0.15 W=1.08 nf=1 ad=0.3132 as=0.3132 pd=2.74 ps=2.74 nrd=0.268518518518518
+ nrs=0.268518518518518 sa=0 sb=0 sd=0 mult=2 m=2
XM11 X net1 VGND VNB sky130_fd_pr__nfet_01v8 L=0.15 W=0.63 nf=1 ad=0.1827 as=0.1827 pd=1.84 ps=1.84 nrd=0.46031746031746
+ nrs=0.46031746031746 sa=0 sb=0 sd=0 mult=2 m=2
.ends

.subckt sky130_efx_lvdig__nand2_1 A B Y VGND VNB VPB VPWR
*.PININFO Y:O A:I B:I VGND:B VNB:B VPB:B VPWR:B
XM0 Y A VPWR VPB sky130_fd_pr__pfet_01v8_hvt L=0.15 W=1.08 nf=1 ad=0.3132 as=0.3132 pd=2.74 ps=2.74 nrd=0.268518518518518
+ nrs=0.268518518518518 sa=0 sb=0 sd=0 mult=1 m=1
XM1 Y B VPWR VPB sky130_fd_pr__pfet_01v8_hvt L=0.15 W=1.08 nf=1 ad=0.3132 as=0.3132 pd=2.74 ps=2.74 nrd=0.268518518518518
+ nrs=0.268518518518518 sa=0 sb=0 sd=0 mult=1 m=1
XM2 Y A net1 VNB sky130_fd_pr__nfet_01v8 L=0.15 W=0.63 nf=1 ad=0.1827 as=0.1827 pd=1.84 ps=1.84 nrd=0.46031746031746
+ nrs=0.46031746031746 sa=0 sb=0 sd=0 mult=1 m=1
XM3 net1 B VGND VNB sky130_fd_pr__nfet_01v8 L=0.15 W=0.63 nf=1 ad=0.1827 as=0.1827 pd=1.84 ps=1.84 nrd=0.46031746031746
+ nrs=0.46031746031746 sa=0 sb=0 sd=0 mult=1 m=1
.ends

.subckt sky130_efx_lvdig__nand2_2 A B Y VGND VNB VPB VPWR
*.PININFO Y:O A:I B:I VGND:B VNB:B VPB:B VPWR:B
XM0 Y A VPWR VPB sky130_fd_pr__pfet_01v8_hvt L=0.15 W=1.08 nf=1 ad=0.3132 as=0.3132 pd=2.74 ps=2.74 nrd=0.268518518518518
+ nrs=0.268518518518518 sa=0 sb=0 sd=0 mult=2 m=2
XM1 Y B VPWR VPB sky130_fd_pr__pfet_01v8_hvt L=0.15 W=1.08 nf=1 ad=0.3132 as=0.3132 pd=2.74 ps=2.74 nrd=0.268518518518518
+ nrs=0.268518518518518 sa=0 sb=0 sd=0 mult=2 m=2
XM2 Y A net1 VNB sky130_fd_pr__nfet_01v8 L=0.15 W=0.63 nf=1 ad=0.1827 as=0.1827 pd=1.84 ps=1.84 nrd=0.46031746031746
+ nrs=0.46031746031746 sa=0 sb=0 sd=0 mult=2 m=2
XM3 net1 B VGND VNB sky130_fd_pr__nfet_01v8 L=0.15 W=0.63 nf=1 ad=0.1827 as=0.1827 pd=1.84 ps=1.84 nrd=0.46031746031746
+ nrs=0.46031746031746 sa=0 sb=0 sd=0 mult=2 m=2
.ends

.subckt sky130_efx_lvdig__nor2_1 A B Y VGND VNB VPB VPWR
*.PININFO Y:O A:I B:I VGND:B VNB:B VPB:B VPWR:B
XM0 Y B net1 VPB sky130_fd_pr__pfet_01v8_hvt L=0.15 W=1.08 nf=1 ad=0.3132 as=0.3132 pd=2.74 ps=2.74 nrd=0.268518518518518
+ nrs=0.268518518518518 sa=0 sb=0 sd=0 mult=1 m=1
XM1 net1 A VPWR VPB sky130_fd_pr__pfet_01v8_hvt L=0.15 W=1.08 nf=1 ad=0.3132 as=0.3132 pd=2.74 ps=2.74 nrd=0.268518518518518
+ nrs=0.268518518518518 sa=0 sb=0 sd=0 mult=1 m=1
XM2 Y A VGND VNB sky130_fd_pr__nfet_01v8 L=0.15 W=0.63 nf=1 ad=0.1827 as=0.1827 pd=1.84 ps=1.84 nrd=0.46031746031746
+ nrs=0.46031746031746 sa=0 sb=0 sd=0 mult=1 m=1
XM3 Y B VGND VNB sky130_fd_pr__nfet_01v8 L=0.15 W=0.63 nf=1 ad=0.1827 as=0.1827 pd=1.84 ps=1.84 nrd=0.46031746031746
+ nrs=0.46031746031746 sa=0 sb=0 sd=0 mult=1 m=1
.ends

.subckt sky130_efx_lvdig__nor2_2 A B Y VGND VNB VPB VPWR
*.PININFO Y:O A:I B:I VGND:B VNB:B VPB:B VPWR:B
XM0 Y B net1 VPB sky130_fd_pr__pfet_01v8_hvt L=0.15 W=1.08 nf=1 ad=0.3132 as=0.3132 pd=2.74 ps=2.74 nrd=0.268518518518518
+ nrs=0.268518518518518 sa=0 sb=0 sd=0 mult=2 m=2
XM1 net1 A VPWR VPB sky130_fd_pr__pfet_01v8_hvt L=0.15 W=1.08 nf=1 ad=0.3132 as=0.3132 pd=2.74 ps=2.74 nrd=0.268518518518518
+ nrs=0.268518518518518 sa=0 sb=0 sd=0 mult=2 m=2
XM2 Y A VGND VNB sky130_fd_pr__nfet_01v8 L=0.15 W=0.63 nf=1 ad=0.1827 as=0.1827 pd=1.84 ps=1.84 nrd=0.46031746031746
+ nrs=0.46031746031746 sa=0 sb=0 sd=0 mult=2 m=2
XM3 Y B VGND VNB sky130_fd_pr__nfet_01v8 L=0.15 W=0.63 nf=1 ad=0.1827 as=0.1827 pd=1.84 ps=1.84 nrd=0.46031746031746
+ nrs=0.46031746031746 sa=0 sb=0 sd=0 mult=2 m=2
.ends

.subckt sky130_efx_lvdig__nor3_2 A B C Y VGND VNB VPB VPWR
*.PININFO Y:O A:I B:I C:I VGND:B VNB:B VPB:B VPWR:B
XM0 Y C net1 VPB sky130_fd_pr__pfet_01v8_hvt L=0.15 W=1.08 nf=1 ad=0.3132 as=0.3132 pd=2.74 ps=2.74 nrd=0.268518518518518
+ nrs=0.268518518518518 sa=0 sb=0 sd=0 mult=2 m=2
XM1 net1 B net2 VPB sky130_fd_pr__pfet_01v8_hvt L=0.15 W=1.08 nf=1 ad=0.3132 as=0.3132 pd=2.74 ps=2.74 nrd=0.268518518518518
+ nrs=0.268518518518518 sa=0 sb=0 sd=0 mult=2 m=2
XM2 net2 A VPWR VPB sky130_fd_pr__pfet_01v8_hvt L=0.15 W=1.08 nf=1 ad=0.3132 as=0.3132 pd=2.74 ps=2.74 nrd=0.268518518518518
+ nrs=0.268518518518518 sa=0 sb=0 sd=0 mult=2 m=2
XM3 Y A VGND VNB sky130_fd_pr__nfet_01v8 L=0.15 W=0.63 nf=1 ad=0.1827 as=0.1827 pd=1.84 ps=1.84 nrd=0.46031746031746
+ nrs=0.46031746031746 sa=0 sb=0 sd=0 mult=2 m=2
XM4 Y B VGND VNB sky130_fd_pr__nfet_01v8 L=0.15 W=0.63 nf=1 ad=0.1827 as=0.1827 pd=1.84 ps=1.84 nrd=0.46031746031746
+ nrs=0.46031746031746 sa=0 sb=0 sd=0 mult=2 m=2
XM5 Y C VGND VNB sky130_fd_pr__nfet_01v8 L=0.15 W=0.63 nf=1 ad=0.1827 as=0.1827 pd=1.84 ps=1.84 nrd=0.46031746031746
+ nrs=0.46031746031746 sa=0 sb=0 sd=0 mult=2 m=2
.ends

.subckt sky130_efx_lvdig__o21a_1 A1 A2 B1 X VGND VNB VPB VPWR
*.PININFO X:O A1:I A2:I B1:I VGND:B VNB:B VPB:B VPWR:B
XM0 net1 A2 net2 VPB sky130_fd_pr__pfet_01v8_hvt L=0.15 W=1.08 nf=1 ad=0.3132 as=0.3132 pd=2.74 ps=2.74 nrd=0.268518518518518
+ nrs=0.268518518518518 sa=0 sb=0 sd=0 mult=1 m=1
XM1 net2 A1 VPWR VPB sky130_fd_pr__pfet_01v8_hvt L=0.15 W=1.08 nf=1 ad=0.3132 as=0.3132 pd=2.74 ps=2.74 nrd=0.268518518518518
+ nrs=0.268518518518518 sa=0 sb=0 sd=0 mult=1 m=1
XM2 net1 B1 VPWR VPB sky130_fd_pr__pfet_01v8_hvt L=0.15 W=1.08 nf=1 ad=0.3132 as=0.3132 pd=2.74 ps=2.74 nrd=0.268518518518518
+ nrs=0.268518518518518 sa=0 sb=0 sd=0 mult=1 m=1
XM3 net1 B1 net3 VNB sky130_fd_pr__nfet_01v8 L=0.15 W=0.63 nf=1 ad=0.1827 as=0.1827 pd=1.84 ps=1.84 nrd=0.46031746031746
+ nrs=0.46031746031746 sa=0 sb=0 sd=0 mult=1 m=1
XM4 net3 A1 VGND VNB sky130_fd_pr__nfet_01v8 L=0.15 W=0.63 nf=1 ad=0.1827 as=0.1827 pd=1.84 ps=1.84 nrd=0.46031746031746
+ nrs=0.46031746031746 sa=0 sb=0 sd=0 mult=1 m=1
XM5 net3 A2 VGND VNB sky130_fd_pr__nfet_01v8 L=0.15 W=0.63 nf=1 ad=0.1827 as=0.1827 pd=1.84 ps=1.84 nrd=0.46031746031746
+ nrs=0.46031746031746 sa=0 sb=0 sd=0 mult=1 m=1
XM6 X net1 VPWR VPB sky130_fd_pr__pfet_01v8_hvt L=0.15 W=1.08 nf=1 ad=0.3132 as=0.3132 pd=2.74 ps=2.74 nrd=0.268518518518518
+ nrs=0.268518518518518 sa=0 sb=0 sd=0 mult=1 m=1
XM7 X net1 VGND VNB sky130_fd_pr__nfet_01v8 L=0.15 W=0.63 nf=1 ad=0.1827 as=0.1827 pd=1.84 ps=1.84 nrd=0.46031746031746
+ nrs=0.46031746031746 sa=0 sb=0 sd=0 mult=1 m=1
.ends

.subckt sky130_efx_lvdig__or2_1 A B X VGND VNB VPB VPWR
*.PININFO X:O A:I B:I VGND:B VNB:B VPB:B VPWR:B
XM0 net1 B net2 VPB sky130_fd_pr__pfet_01v8_hvt L=0.15 W=0.45 nf=1 ad=0.1305 as=0.1305 pd=1.48 ps=1.48 nrd=0.644444444444444
+ nrs=0.644444444444444 sa=0 sb=0 sd=0 mult=1 m=1
XM1 net2 A VPWR VPB sky130_fd_pr__pfet_01v8_hvt L=0.15 W=0.45 nf=1 ad=0.1305 as=0.1305 pd=1.48 ps=1.48 nrd=0.644444444444444
+ nrs=0.644444444444444 sa=0 sb=0 sd=0 mult=1 m=1
XM2 net1 A VGND VNB sky130_fd_pr__nfet_01v8 L=0.15 W=0.45 nf=1 ad=0.1305 as=0.1305 pd=1.48 ps=1.48 nrd=0.644444444444444
+ nrs=0.644444444444444 sa=0 sb=0 sd=0 mult=1 m=1
XM3 net1 B VGND VNB sky130_fd_pr__nfet_01v8 L=0.15 W=0.45 nf=1 ad=0.1305 as=0.1305 pd=1.48 ps=1.48 nrd=0.644444444444444
+ nrs=0.644444444444444 sa=0 sb=0 sd=0 mult=1 m=1
XM4 X net1 VPWR VPB sky130_fd_pr__pfet_01v8_hvt L=0.15 W=1.08 nf=1 ad=0.3132 as=0.3132 pd=2.74 ps=2.74 nrd=0.268518518518518
+ nrs=0.268518518518518 sa=0 sb=0 sd=0 mult=1 m=1
XM5 X net1 VGND VNB sky130_fd_pr__nfet_01v8 L=0.15 W=0.63 nf=1 ad=0.1827 as=0.1827 pd=1.84 ps=1.84 nrd=0.46031746031746
+ nrs=0.46031746031746 sa=0 sb=0 sd=0 mult=1 m=1
.ends

.subckt sky130_efx_lvdig__or2_2 A B X VGND VNB VPB VPWR
*.PININFO X:O A:I B:I VGND:B VNB:B VPB:B VPWR:B
XM0 net1 B net2 VPB sky130_fd_pr__pfet_01v8_hvt L=0.15 W=0.45 nf=1 ad=0.1305 as=0.1305 pd=1.48 ps=1.48 nrd=0.644444444444444
+ nrs=0.644444444444444 sa=0 sb=0 sd=0 mult=1 m=1
XM1 net2 A VPWR VPB sky130_fd_pr__pfet_01v8_hvt L=0.15 W=0.45 nf=1 ad=0.1305 as=0.1305 pd=1.48 ps=1.48 nrd=0.644444444444444
+ nrs=0.644444444444444 sa=0 sb=0 sd=0 mult=1 m=1
XM2 net1 A VGND VNB sky130_fd_pr__nfet_01v8 L=0.15 W=0.45 nf=1 ad=0.1305 as=0.1305 pd=1.48 ps=1.48 nrd=0.644444444444444
+ nrs=0.644444444444444 sa=0 sb=0 sd=0 mult=1 m=1
XM3 net1 B VGND VNB sky130_fd_pr__nfet_01v8 L=0.15 W=0.45 nf=1 ad=0.1305 as=0.1305 pd=1.48 ps=1.48 nrd=0.644444444444444
+ nrs=0.644444444444444 sa=0 sb=0 sd=0 mult=1 m=1
XM4 X net1 VPWR VPB sky130_fd_pr__pfet_01v8_hvt L=0.15 W=1.08 nf=1 ad=0.3132 as=0.3132 pd=2.74 ps=2.74 nrd=0.268518518518518
+ nrs=0.268518518518518 sa=0 sb=0 sd=0 mult=2 m=2
XM5 X net1 VGND VNB sky130_fd_pr__nfet_01v8 L=0.15 W=0.63 nf=1 ad=0.1827 as=0.1827 pd=1.84 ps=1.84 nrd=0.46031746031746
+ nrs=0.46031746031746 sa=0 sb=0 sd=0 mult=2 m=2
.ends

.subckt sky130_efx_lvdig__or2_4 A B X VGND VNB VPB VPWR
*.PININFO X:O A:I B:I VGND:B VNB:B VPB:B VPWR:B
XM0 net1 B net2 VPB sky130_fd_pr__pfet_01v8_hvt L=0.15 W=1.08 nf=1 ad=0.3132 as=0.3132 pd=2.74 ps=2.74 nrd=0.268518518518518
+ nrs=0.268518518518518 sa=0 sb=0 sd=0 mult=1 m=1
XM1 net2 A VPWR VPB sky130_fd_pr__pfet_01v8_hvt L=0.15 W=1.08 nf=1 ad=0.3132 as=0.3132 pd=2.74 ps=2.74 nrd=0.268518518518518
+ nrs=0.268518518518518 sa=0 sb=0 sd=0 mult=1 m=1
XM2 net1 A VGND VNB sky130_fd_pr__nfet_01v8 L=0.15 W=0.63 nf=1 ad=0.1827 as=0.1827 pd=1.84 ps=1.84 nrd=0.46031746031746
+ nrs=0.46031746031746 sa=0 sb=0 sd=0 mult=1 m=1
XM3 net1 B VGND VNB sky130_fd_pr__nfet_01v8 L=0.15 W=0.63 nf=1 ad=0.1827 as=0.1827 pd=1.84 ps=1.84 nrd=0.46031746031746
+ nrs=0.46031746031746 sa=0 sb=0 sd=0 mult=1 m=1
XM4 X net1 VPWR VPB sky130_fd_pr__pfet_01v8_hvt L=0.15 W=1.08 nf=1 ad=0.3132 as=0.3132 pd=2.74 ps=2.74 nrd=0.268518518518518
+ nrs=0.268518518518518 sa=0 sb=0 sd=0 mult=4 m=4
XM5 X net1 VGND VNB sky130_fd_pr__nfet_01v8 L=0.15 W=0.63 nf=1 ad=0.1827 as=0.1827 pd=1.84 ps=1.84 nrd=0.46031746031746
+ nrs=0.46031746031746 sa=0 sb=0 sd=0 mult=4 m=4
.ends

.subckt sky130_efx_lvdig__or3_1 A B C X VGND VNB VPB VPWR
*.PININFO X:O A:I B:I C:I VGND:B VNB:B VPB:B VPWR:B
XM0 net1 C net2 VPB sky130_fd_pr__pfet_01v8_hvt L=0.15 W=0.45 nf=1 ad=0.1305 as=0.1305 pd=1.48 ps=1.48 nrd=0.644444444444444
+ nrs=0.644444444444444 sa=0 sb=0 sd=0 mult=1 m=1
XM1 net2 B net3 VPB sky130_fd_pr__pfet_01v8_hvt L=0.15 W=0.45 nf=1 ad=0.1305 as=0.1305 pd=1.48 ps=1.48 nrd=0.644444444444444
+ nrs=0.644444444444444 sa=0 sb=0 sd=0 mult=1 m=1
XM2 net3 A VPWR VPB sky130_fd_pr__pfet_01v8_hvt L=0.15 W=0.45 nf=1 ad=0.1305 as=0.1305 pd=1.48 ps=1.48 nrd=0.644444444444444
+ nrs=0.644444444444444 sa=0 sb=0 sd=0 mult=1 m=1
XM3 net1 A VGND VNB sky130_fd_pr__nfet_01v8 L=0.15 W=0.45 nf=1 ad=0.1305 as=0.1305 pd=1.48 ps=1.48 nrd=0.644444444444444
+ nrs=0.644444444444444 sa=0 sb=0 sd=0 mult=1 m=1
XM4 net1 B VGND VNB sky130_fd_pr__nfet_01v8 L=0.15 W=0.45 nf=1 ad=0.1305 as=0.1305 pd=1.48 ps=1.48 nrd=0.644444444444444
+ nrs=0.644444444444444 sa=0 sb=0 sd=0 mult=1 m=1
XM5 net1 C VGND VNB sky130_fd_pr__nfet_01v8 L=0.15 W=0.45 nf=1 ad=0.1305 as=0.1305 pd=1.48 ps=1.48 nrd=0.644444444444444
+ nrs=0.644444444444444 sa=0 sb=0 sd=0 mult=1 m=1
XM6 X net1 VPWR VPB sky130_fd_pr__pfet_01v8_hvt L=0.15 W=1.08 nf=1 ad=0.3132 as=0.3132 pd=2.74 ps=2.74 nrd=0.268518518518518
+ nrs=0.268518518518518 sa=0 sb=0 sd=0 mult=1 m=1
XM7 X net1 VGND VNB sky130_fd_pr__nfet_01v8 L=0.15 W=0.63 nf=1 ad=0.1827 as=0.1827 pd=1.84 ps=1.84 nrd=0.46031746031746
+ nrs=0.46031746031746 sa=0 sb=0 sd=0 mult=1 m=1
.ends
