* Copyright (c) 2026 Eric Fogleman
* SPDX-License-Identifier: Apache-2.0
* Derived from SkyWater sky130_fd_sc_hd (Apache-2.0); see NOTICE
*
* sky130_efx_lvdig standard cells: layout-extracted netlist with parasitic R
* and C, one .subckt per cell from the layouts in mag/ (generated by
* `make libspice PEX=rc`; don't edit): extresist (all nets, tolerance 10) for
* wiring and contact resistance, ext2spice cthresh 0 for every non-zero
* capacitance (substrate node VNB). Nets are split at the resistors: Magic
* names the pieces <net>.n<k> (wiring) and <net>.t<k> (device terminals).
* Magic on a flattened copy of each cell (every device has its own
* source/drain area and perimeter). Internal nets have Magic's coordinate
* names (a_<x>_<y>#). Ports are in the same order as cdl/sky130_efx_lvdig.cdl
* (the schematic netlist), so the netlists can be swapped in a testbench.
*
* Cell topologies and device sizes are derived from SkyWater's sky130_fd_sc_hd
* (Apache-2.0; see NOTICE). Layouts are independent.
*
* Not interchangeable with the PDK's sky130_fd_sc_hd netlists:
*  - device widths are on the efx lambda grid (L = 0.18 um; e.g. 0.42 -> 0.45,
*    0.65 -> 0.63, 1.00 -> 1.08), conb_1's resistors W 0.45 x L 0.54
*  - ports: logic pins, then VGND VNB VPB VPWR (hd: power pins in between),
*    so instantiate by the .subckt lines below, not by hd's pin order
* Devices are sky130_fd_pr models; include the PDK model library first, e.g.
*   .lib $PDK_ROOT/sky130A/libs.tech/ngspice/sky130.lib.spice tt

.subckt sky130_efx_lvdig__a21o_1 A1 A2 B1 X VGND VNB VPB VPWR
X0 nmos_n3f5_f2_l150_fnf_0.D0.t2 A1.t0 a_141_36.t1 VNB.t3 sky130_fd_pr__nfet_01v8 ad=0.23625 pd=2.01 as=0.12285 ps=1.02 w=0.63 l=0.15
X1 VPWR.t2 A2.t1 pmos_n6_f2_l150_hvt_ftf_0.S0.t0 VPB.t1 sky130_fd_pr__pfet_01v8_hvt ad=0.2106 pd=1.47 as=0.405 ps=2.91 w=1.08 l=0.15
X2 X.t1 nmos_n3f5_f2_l150_fnf_0.D0.t3 VGND.t0 VNB.t0 sky130_fd_pr__nfet_01v8 ad=0.23625 pd=2.01 as=0.23625 ps=2.01 w=0.63 l=0.15
X3 pmos_n6_f2_l150_hvt_ftf_0.S0.t2 A1.t1 VPWR.t1 VPB.t3 sky130_fd_pr__pfet_01v8_hvt ad=0.405 pd=2.91 as=0.2106 ps=1.47 w=1.08 l=0.15
X4 X.t0 nmos_n3f5_f2_l150_fnf_0.D0.t4 VPWR.t0 VPB.t0 sky130_fd_pr__pfet_01v8_hvt ad=0.405 pd=2.91 as=0.405 ps=2.91 w=1.08 l=0.15
X5 a_141_36.t0 A2.t0 VGND.t2 VNB.t1 sky130_fd_pr__nfet_01v8 ad=0.12285 pd=1.02 as=0.23625 ps=2.01 w=0.63 l=0.15
X6 pmos_n6_f2_l150_hvt_ftf_0.S0.t1 B1.t1 nmos_n3f5_f2_l150_fnf_0.D0.t0 VPB.t2 sky130_fd_pr__pfet_01v8_hvt ad=0.405 pd=2.91 as=0.405 ps=2.91 w=1.08 l=0.15
X7 VGND.t1 B1.t0 nmos_n3f5_f2_l150_fnf_0.D0.t1 VNB.t2 sky130_fd_pr__nfet_01v8 ad=0.23625 pd=2.01 as=0.23625 ps=2.01 w=0.63 l=0.15
C0 VPWR X 0.08434f
C1 VPWR B1 0.01315f
C2 VGND A1 0.02239f
C3 A2 VPB 0.04956f
C4 pmos_n6_f2_l150_hvt_ftf_0.S0 VPB 0.03277f
C5 A2 nmos_n3f5_f2_l150_fnf_0.D0 0.00301f
C6 pmos_n6_f2_l150_hvt_ftf_0.S0 nmos_n3f5_f2_l150_fnf_0.D0 0.09534f
C7 A1 VPB 0.05339f
C8 A1 nmos_n3f5_f2_l150_fnf_0.D0 0.05417f
C9 pmos_n6_f2_l150_hvt_ftf_0.S0 X 0.00575f
C10 pmos_n6_f2_l150_hvt_ftf_0.S0 B1 0.0115f
C11 VGND VPB 0.01447f
C12 VGND nmos_n3f5_f2_l150_fnf_0.D0 0.27376f
C13 A1 B1 0.01968f
C14 VPWR A2 0.02169f
C15 pmos_n6_f2_l150_hvt_ftf_0.S0 VPWR 0.37233f
C16 VGND X 0.10221f
C17 VGND B1 0.054f
C18 VPB nmos_n3f5_f2_l150_fnf_0.D0 0.08619f
C19 VPWR A1 0.02241f
C20 VGND VPWR 0.07871f
C21 X VPB 0.01078f
C22 X nmos_n3f5_f2_l150_fnf_0.D0 0.10826f
C23 B1 VPB 0.05944f
C24 B1 nmos_n3f5_f2_l150_fnf_0.D0 0.14331f
C25 pmos_n6_f2_l150_hvt_ftf_0.S0 A2 0.05856f
C26 VPWR VPB 0.16185f
C27 VPWR nmos_n3f5_f2_l150_fnf_0.D0 0.08205f
C28 A1 A2 0.06327f
C29 pmos_n6_f2_l150_hvt_ftf_0.S0 A1 0.05856f
C31 VGND A2 0.05267f
C32 VGND pmos_n6_f2_l150_hvt_ftf_0.S0 0.01831f
R0 VGND VGND.t0 231.744
R1 VGND VGND.t1 231.744
R2 VGND VGND.t2 231.744
R3 VGND.n15 VGND.n14 15.7005
R4 VGND.n3 VGND 13.7372
R5 VGND.n5 VGND.n4 12.8005
R6 VGND.n5 VGND.n2 12.8005
R7 VGND.n9 VGND.n2 12.8005
R8 VGND.n10 VGND.n9 12.8005
R9 VGND.n11 VGND.n10 12.8005
R10 VGND.n11 VGND.n0 12.8005
R11 VGND.n4 VGND 9.6005
R12 VGND VGND.n15 9.6005
R13 VGND.n13 VGND.n0 9.3005
R14 VGND.n12 VGND.n11 9.3005
R15 VGND.n10 VGND.n1 9.3005
R16 VGND.n9 VGND.n8 9.3005
R17 VGND.n7 VGND.n2 9.3005
R18 VGND.n6 VGND.n5 9.3005
R19 VGND.n15 VGND.n0 6.4005
R20 VGND.n4 VGND.n3 5.5582
R21 VGND.n6 VGND.n3 0.763402
R22 VGND.n7 VGND.n6 0.063
R23 VGND.n8 VGND.n7 0.063
R24 VGND.n8 VGND.n1 0.063
R25 VGND.n12 VGND.n1 0.063
R26 VGND.n13 VGND.n12 0.063
R27 VGND.n14 VGND.n13 0.063
R28 VGND.n14 VGND 0.03175
R29 X X.t0 366.469
R30 X.n0 X.t1 222.143
R31 X.n0 X 19.2005
R32 X X.n0 9.6005
R33 VPWR.n1 VPWR.t0 792.043
R34 VPWR.n1 VPWR.n0 602.489
R35 VPWR.n0 VPWR.t1 35.5699
R36 VPWR.n0 VPWR.t2 35.5699
R37 VPWR VPWR.n1 0.163603
R38 B1.n0 B1.t1 247.428
R39 B1.n0 B1.t0 204.048
R40 B1 B1.n0 158.4
R41 A1.n0 A1.t1 247.428
R42 A1.n0 A1.t0 204.048
R43 A1 A1.n0 158.4
R44 A2.n0 A2.t1 247.428
R45 A2.n0 A2.t0 204.048
R46 A2 A2.n0 158.4
R47 VPB.t2 VPB.t0 604.545
R48 VPB.t3 VPB.t2 604.545
R49 VPB VPB.t1 302.274
R50 VPB.t1 VPB.t3 259.091
R51 VNB.t2 VNB.t0 2800
R52 VNB.t3 VNB.t2 2800
R53 VNB VNB.t1 1400
R54 VNB.t1 VNB.t3 1200
R55 a_141_36.t0 a_141_36.t1 74.2862
R56 pmos_n6_f2_l150_hvt_ftf_0.S0 pmos_n6_f2_l150_hvt_ftf_0.S0.t0 334.469
R57 pmos_n6_f2_l150_hvt_ftf_0.S0 pmos_n6_f2_l150_hvt_ftf_0.S0.n0 6.4005
R58 pmos_n6_f2_l150_hvt_ftf_0.S0.n0 pmos_n6_f2_l150_hvt_ftf_0.S0.t1 825.321
R59 pmos_n6_f2_l150_hvt_ftf_0.S0.n0 pmos_n6_f2_l150_hvt_ftf_0.S0.t2 328.07
R60 nmos_n3f5_f2_l150_fnf_0.D0 nmos_n3f5_f2_l150_fnf_0.D0.t1 222.143
R61 nmos_n3f5_f2_l150_fnf_0.D0 nmos_n3f5_f2_l150_fnf_0.D0.n0 38.4005
R62 nmos_n3f5_f2_l150_fnf_0.D0.n0 nmos_n3f5_f2_l150_fnf_0.D0.n1 209.601
R63 nmos_n3f5_f2_l150_fnf_0.D0.n1 nmos_n3f5_f2_l150_fnf_0.D0.t3 204.048
R64 nmos_n3f5_f2_l150_fnf_0.D0.n1 nmos_n3f5_f2_l150_fnf_0.D0.t4 247.428
R65 nmos_n3f5_f2_l150_fnf_0.D0.n0 nmos_n3f5_f2_l150_fnf_0.D0.t0 774.12
R66 nmos_n3f5_f2_l150_fnf_0.D0.t2 nmos_n3f5_f2_l150_fnf_0.D0 222.143
C33 VGND VNB 0.73286f
C34 X VNB 0.26355f
C35 VPWR VNB 0.52322f
C36 B1 VNB 0.19062f
C37 A1 VNB 0.18367f
C38 A2 VNB 0.20896f
C39 VPB VNB 1.06059f
C40 pmos_n6_f2_l150_hvt_ftf_0.S0 VNB 0.25124f
C41 nmos_n3f5_f2_l150_fnf_0.D0 VNB 0.41452f
C42 nmos_n3f5_f2_l150_fnf_0.D0.t1 VNB 0.05895f
C43 nmos_n3f5_f2_l150_fnf_0.D0.t2 VNB 0.05895f
C44 nmos_n3f5_f2_l150_fnf_0.D0.n0 VNB 0.25435f
C45 nmos_n3f5_f2_l150_fnf_0.D0.t0 VNB 0.10594f
C46 nmos_n3f5_f2_l150_fnf_0.D0.t4 VNB 0.03265f
C47 nmos_n3f5_f2_l150_fnf_0.D0.t3 VNB 0.02033f
C48 nmos_n3f5_f2_l150_fnf_0.D0.n1 VNB 0.11109f
C49 pmos_n6_f2_l150_hvt_ftf_0.S0.t0 VNB 0.09155f
C50 pmos_n6_f2_l150_hvt_ftf_0.S0.t2 VNB 0.09035f
C51 pmos_n6_f2_l150_hvt_ftf_0.S0.n0 VNB 0.17542f
C52 pmos_n6_f2_l150_hvt_ftf_0.S0.t1 VNB 0.09573f
C53 a_141_36.t0 VNB 0.0139f
C54 a_141_36.t1 VNB 0.0139f
C55 VPB.t0 VNB 0.13663f
C56 VPB.t2 VNB 0.13663f
C57 VPB.t3 VNB 0.0976f
C58 VPB.t1 VNB 0.06344f
C59 A2.t1 VNB 0.04802f
C60 A2.t0 VNB 0.0299f
C61 A2.n0 VNB 0.11821f
C62 A1.t1 VNB 0.05673f
C63 A1.t0 VNB 0.03533f
C64 A1.n0 VNB 0.13964f
C65 B1.t1 VNB 0.05827f
C66 B1.t0 VNB 0.03629f
C67 B1.n0 VNB 0.14344f
C68 VPWR.t1 VNB 0.015f
C69 VPWR.t2 VNB 0.015f
C70 VPWR.n0 VNB 0.0309f
C71 VPWR.t0 VNB 0.05399f
C72 VPWR.n1 VNB 0.6442f
C73 X.t0 VNB 0.08399f
C74 X.t1 VNB 0.04173f
C75 X.n0 VNB 0.03528f
C76 VGND.t2 VNB 0.02171f
C77 VGND.n0 VNB 0.00985f
C78 VGND.n1 VNB 0.02627f
C79 VGND.n2 VNB 0.01313f
C80 VGND.t0 VNB 0.02171f
C81 VGND.n3 VNB 0.04215f
C82 VGND.t1 VNB 0.02171f
C83 VGND.n4 VNB 0.02129f
C84 VGND.n5 VNB 0.01313f
C85 VGND.n6 VNB 0.16069f
C86 VGND.n7 VNB 0.02627f
C87 VGND.n8 VNB 0.02627f
C88 VGND.n9 VNB 0.01313f
C89 VGND.n10 VNB 0.01313f
C90 VGND.n11 VNB 0.01313f
C91 VGND.n12 VNB 0.02627f
C92 VGND.n13 VNB 0.02627f
C93 VGND.n14 VNB 0.02371f
C94 VGND.n15 VNB 0.01733f
.ends

.subckt sky130_efx_lvdig__a22o_1 A1 A2 B1 B2 X VGND VNB VPB VPWR
X0 nmos_n3f5_f2_l150_fnf_1.S0.t2 A1.t0 a_141_36.t0 VNB.t2 sky130_fd_pr__nfet_01v8 ad=0.23625 pd=2.01 as=0.12285 ps=1.02 w=0.63 l=0.15
X1 X.t0 nmos_n3f5_f2_l150_fnf_1.S0.t4 VGND.t1 VNB.t1 sky130_fd_pr__nfet_01v8 ad=0.23625 pd=2.01 as=0.23625 ps=2.01 w=0.63 l=0.15
X2 a_141_324.t3 A2.t1 VPWR.t1 VPB.t4 sky130_fd_pr__pfet_01v8_hvt ad=0.2106 pd=1.47 as=0.405 ps=2.91 w=1.08 l=0.15
X3 VPWR.t2 A1.t1 a_141_324.t1 VPB.t2 sky130_fd_pr__pfet_01v8_hvt ad=0.405 pd=2.91 as=0.2106 ps=1.47 w=1.08 l=0.15
X4 VGND.t2 B2.t0 a_501_36.t1 VNB.t3 sky130_fd_pr__nfet_01v8 ad=0.23625 pd=2.01 as=0.12285 ps=1.02 w=0.63 l=0.15
X5 X.t1 nmos_n3f5_f2_l150_fnf_1.S0.t5 VPWR.t0 VPB.t1 sky130_fd_pr__pfet_01v8_hvt ad=0.405 pd=2.91 as=0.405 ps=2.91 w=1.08 l=0.15
X6 a_141_36.t1 A2.t0 VGND.t0 VNB.t4 sky130_fd_pr__nfet_01v8 ad=0.12285 pd=1.02 as=0.23625 ps=2.01 w=0.63 l=0.15
X7 nmos_n3f5_f2_l150_fnf_1.S0.t1 B1.t1 a_141_324.t0 VPB.t0 sky130_fd_pr__pfet_01v8_hvt ad=0.2106 pd=1.47 as=0.405 ps=2.91 w=1.08 l=0.15
X8 a_141_324.t2 B2.t1 nmos_n3f5_f2_l150_fnf_1.S0.t3 VPB.t3 sky130_fd_pr__pfet_01v8_hvt ad=0.405 pd=2.91 as=0.2106 ps=1.47 w=1.08 l=0.15
X9 a_501_36.t0 B1.t0 nmos_n3f5_f2_l150_fnf_1.S0.t0 VNB.t0 sky130_fd_pr__nfet_01v8 ad=0.12285 pd=1.02 as=0.23625 ps=2.01 w=0.63 l=0.15
C0 VGND nmos_n3f5_f2_l150_fnf_1.S0 0.28348f
C1 B2 VGND 0.0531f
C2 A2 nmos_n3f5_f2_l150_fnf_1.S0 0.00276f
C3 B1 nmos_n3f5_f2_l150_fnf_1.S0 0.09117f
C4 VPWR X 0.08434f
C5 B2 B1 0.04923f
C6 A2 VGND 0.05375f
C7 A1 VPB 0.05339f
C8 B1 VGND 0.01843f
C9 X nmos_n3f5_f2_l150_fnf_1.S0 0.10829f
C11 VPB VPWR 0.20187f
C12 VGND X 0.10221f
C13 VPB nmos_n3f5_f2_l150_fnf_1.S0 0.08336f
C14 B2 VPB 0.05339f
C16 VPB VGND 0.01785f
C17 A1 VPWR 0.02379f
C18 VPB A2 0.04956f
C19 VPB B1 0.05339f
C20 A1 nmos_n3f5_f2_l150_fnf_1.S0 0.0319f
C21 VPB X 0.01417f
C22 A1 VGND 0.02228f
C23 VPWR nmos_n3f5_f2_l150_fnf_1.S0 0.08292f
C24 B2 VPWR 0.01229f
C25 A1 A2 0.06327f
C26 A1 B1 0.04604f
C27 VGND VPWR 0.09518f
C28 A2 VPWR 0.06512f
C29 B2 nmos_n3f5_f2_l150_fnf_1.S0 0.14147f
C30 B1 VPWR 0.013f
R0 VGND VGND.t1 231.744
R1 VGND VGND.t2 231.744
R2 VGND VGND.t0 231.744
R3 VGND.n19 VGND.n18 15.7005
R4 VGND.n5 VGND 14.6867
R5 VGND.n8 VGND.n7 12.8005
R6 VGND.n9 VGND.n8 12.8005
R7 VGND.n9 VGND.n2 12.8005
R8 VGND.n13 VGND.n2 12.8005
R9 VGND.n14 VGND.n13 12.8005
R10 VGND.n15 VGND.n14 12.8005
R11 VGND.n15 VGND.n0 12.8005
R12 VGND.n5 VGND.n4 11.2737
R13 VGND.n4 VGND 9.6005
R14 VGND VGND.n19 9.6005
R15 VGND.n17 VGND.n0 9.3005
R16 VGND.n16 VGND.n15 9.3005
R17 VGND.n14 VGND.n1 9.3005
R18 VGND.n13 VGND.n12 9.3005
R19 VGND.n11 VGND.n2 9.3005
R20 VGND.n10 VGND.n9 9.3005
R21 VGND.n8 VGND.n3 9.3005
R22 VGND.n7 VGND.n6 9.3005
R23 VGND.n7 VGND.n4 6.4005
R24 VGND.n19 VGND.n0 6.4005
R25 VGND.n6 VGND.n5 1.44789
R26 VGND.n6 VGND.n3 0.063
R27 VGND.n10 VGND.n3 0.063
R28 VGND.n11 VGND.n10 0.063
R29 VGND.n12 VGND.n11 0.063
R30 VGND.n12 VGND.n1 0.063
R31 VGND.n16 VGND.n1 0.063
R32 VGND.n17 VGND.n16 0.063
R33 VGND.n18 VGND.n17 0.063
R34 VGND.n18 VGND 0.03175
R35 X X.t1 366.469
R36 X.n0 X.t0 222.143
R37 X.n0 X 19.2005
R38 X X.n0 9.6005
R39 VPWR.n3 VPWR.t0 793.586
R40 VPWR.n2 VPWR.t2 786.92
R41 VPWR.n8 VPWR.t1 353.67
R42 VPWR.n9 VPWR.n8 15.7005
R43 VPWR.n6 VPWR.n1 12.8005
R44 VPWR.n7 VPWR.n6 12.8005
R45 VPWR.n3 VPWR.n2 12.622
R46 VPWR.n7 VPWR.n0 9.3005
R47 VPWR.n6 VPWR.n5 9.3005
R48 VPWR.n4 VPWR.n1 9.3005
R49 VPWR.n2 VPWR.n1 6.4005
R50 VPWR.n8 VPWR.n7 6.4005
R51 VPWR.n4 VPWR.n3 0.0992222
R52 VPWR.n5 VPWR.n4 0.063
R53 VPWR.n5 VPWR.n0 0.063
R54 VPWR.n9 VPWR.n0 0.063
R55 VPWR VPWR.n9 0.03175
R56 B2.n0 B2.t1 247.428
R57 B2.n0 B2.t0 204.048
R58 B2 B2.n0 158.4
R59 B1.n0 B1.t1 247.428
R60 B1.n0 B1.t0 204.048
R61 B1 B1.n0 158.4
R62 A1.n0 A1.t1 247.428
R63 A1.n0 A1.t0 204.048
R64 A1 A1.n0 158.4
R65 A2.n0 A2.t1 247.428
R66 A2.n0 A2.t0 204.048
R67 A2 A2.n0 158.4
R68 VPB.t3 VPB.t1 604.545
R69 VPB.t2 VPB.t0 604.545
R70 VPB VPB.t4 302.274
R71 VPB.t0 VPB.t3 259.091
R72 VPB.t4 VPB.t2 259.091
R73 VNB.t3 VNB.t1 2800
R74 VNB.t2 VNB.t0 2800
R75 VNB VNB.t4 1400
R76 VNB.t0 VNB.t3 1200
R77 VNB.t4 VNB.t2 1200
R78 a_501_36.t0 a_501_36.t1 74.2862
R79 a_141_36.t0 a_141_36.t1 74.2862
R80 a_141_324.t0 a_141_324.n1 328.07
R81 a_141_324.n1 a_141_324.n0 350.101
R82 a_141_324.n0 a_141_324.t3 35.5699
R83 a_141_324.n0 a_141_324.t1 35.5699
R84 a_141_324.n1 a_141_324.t2 818.92
R85 nmos_n3f5_f2_l150_fnf_1.S0 nmos_n3f5_f2_l150_fnf_1.S0.t0 222.143
R86 nmos_n3f5_f2_l150_fnf_1.S0 nmos_n3f5_f2_l150_fnf_1.S0.n0 56.5338
R87 nmos_n3f5_f2_l150_fnf_1.S0.n0 nmos_n3f5_f2_l150_fnf_1.S0.n1 585
R88 nmos_n3f5_f2_l150_fnf_1.S0.n0 nmos_n3f5_f2_l150_fnf_1.S0.n2 209.601
R89 nmos_n3f5_f2_l150_fnf_1.S0.n2 nmos_n3f5_f2_l150_fnf_1.S0.t4 204.048
R90 nmos_n3f5_f2_l150_fnf_1.S0.n2 nmos_n3f5_f2_l150_fnf_1.S0.t5 247.428
R91 nmos_n3f5_f2_l150_fnf_1.S0.n1 nmos_n3f5_f2_l150_fnf_1.S0.t1 35.5699
R92 nmos_n3f5_f2_l150_fnf_1.S0.n1 nmos_n3f5_f2_l150_fnf_1.S0.t3 35.5699
R93 nmos_n3f5_f2_l150_fnf_1.S0.t2 nmos_n3f5_f2_l150_fnf_1.S0 222.143
C31 VGND VNB 0.81309f
C32 X VNB 0.26133f
C33 VPWR VNB 0.54986f
C34 B2 VNB 0.18305f
C35 B1 VNB 0.18358f
C36 A1 VNB 0.17997f
C37 A2 VNB 0.208f
C38 VPB VNB 1.23238f
C39 nmos_n3f5_f2_l150_fnf_1.S0 VNB 0.44425f
C40 nmos_n3f5_f2_l150_fnf_1.S0.t0 VNB 0.06318f
C41 nmos_n3f5_f2_l150_fnf_1.S0.t2 VNB 0.06318f
C42 nmos_n3f5_f2_l150_fnf_1.S0.n0 VNB 0.28558f
C43 nmos_n3f5_f2_l150_fnf_1.S0.t1 VNB 0.03214f
C44 nmos_n3f5_f2_l150_fnf_1.S0.t3 VNB 0.03214f
C45 nmos_n3f5_f2_l150_fnf_1.S0.n1 VNB 0.06428f
C46 nmos_n3f5_f2_l150_fnf_1.S0.t5 VNB 0.035f
C47 nmos_n3f5_f2_l150_fnf_1.S0.t4 VNB 0.02179f
C48 nmos_n3f5_f2_l150_fnf_1.S0.n2 VNB 0.11907f
C49 a_141_324.t0 VNB 0.1003f
C50 a_141_324.t2 VNB 0.10508f
C51 a_141_324.t3 VNB 0.02835f
C52 a_141_324.t1 VNB 0.02835f
C53 a_141_324.n0 VNB 0.0811f
C54 a_141_324.n1 VNB 0.3896f
C55 a_141_36.t0 VNB 0.01386f
C56 a_141_36.t1 VNB 0.01386f
C57 a_501_36.t0 VNB 0.01239f
C58 a_501_36.t1 VNB 0.01239f
C59 VPB.t1 VNB 0.15947f
C60 VPB.t3 VNB 0.09967f
C61 VPB.t0 VNB 0.09967f
C62 VPB.t2 VNB 0.09967f
C63 VPB.t4 VNB 0.06479f
C64 A2.t1 VNB 0.04714f
C65 A2.t0 VNB 0.02936f
C66 A2.n0 VNB 0.11604f
C67 A1.t1 VNB 0.05727f
C68 A1.t0 VNB 0.03566f
C69 A1.n0 VNB 0.14097f
C70 B1.t1 VNB 0.06267f
C71 B1.t0 VNB 0.03903f
C72 B1.n0 VNB 0.15427f
C73 B2.t1 VNB 0.06219f
C74 B2.t0 VNB 0.03873f
C75 B2.n0 VNB 0.15309f
C76 VPWR.n0 VNB 0.03504f
C77 VPWR.t1 VNB 0.05384f
C78 VPWR.n1 VNB 0.01314f
C79 VPWR.t0 VNB 0.05128f
C80 VPWR.t2 VNB 0.05064f
C81 VPWR.n2 VNB 0.04977f
C82 VPWR.n3 VNB 0.5032f
C83 VPWR.n4 VNB 0.0721f
C84 VPWR.n5 VNB 0.03504f
C85 VPWR.n6 VNB 0.01752f
C86 VPWR.n7 VNB 0.01314f
C87 VPWR.n8 VNB 0.07876f
C88 VPWR.n9 VNB 0.03163f
C89 X.t1 VNB 0.08507f
C90 X.t0 VNB 0.04227f
C91 X.n0 VNB 0.03574f
C92 VGND.t0 VNB 0.02102f
C93 VGND.n0 VNB 0.00953f
C94 VGND.n1 VNB 0.02542f
C95 VGND.n2 VNB 0.01271f
C96 VGND.n3 VNB 0.02542f
C97 VGND.t2 VNB 0.02102f
C98 VGND.n4 VNB 0.01582f
C99 VGND.t1 VNB 0.02102f
C100 VGND.n5 VNB 0.03405f
C101 VGND.n6 VNB 0.17066f
C102 VGND.n7 VNB 0.00953f
C103 VGND.n8 VNB 0.01271f
C104 VGND.n9 VNB 0.01271f
C105 VGND.n10 VNB 0.02542f
C106 VGND.n11 VNB 0.02542f
C107 VGND.n12 VNB 0.02542f
C108 VGND.n13 VNB 0.01271f
C109 VGND.n14 VNB 0.01271f
C110 VGND.n15 VNB 0.01271f
C111 VGND.n16 VNB 0.02542f
C112 VGND.n17 VNB 0.02542f
C113 VGND.n18 VNB 0.02295f
C114 VGND.n19 VNB 0.01677f
.ends

.subckt sky130_efx_lvdig__and2_1 A B X VGND VNB VPB VPWR
X0 a_141_450.t1 A.t0 a_141_36.t1 VNB.t2 sky130_fd_pr__nfet_01v8 ad=0.16875 pd=1.65 as=0.08775 ps=0.84 w=0.45 l=0.15
X1 a_141_450.t0 B.t1 VPWR.t0 VPB.t0 sky130_fd_pr__pfet_01v8_hvt ad=0.08775 pd=0.84 as=0.16875 ps=1.65 w=0.45 l=0.15
X2 a_141_36.t0 B.t0 VGND.t1 VNB.t0 sky130_fd_pr__nfet_01v8 ad=0.08775 pd=0.84 as=0.16875 ps=1.65 w=0.45 l=0.15
X3 VPWR.t1 A.t1 a_141_450.t2 VPB.t2 sky130_fd_pr__pfet_01v8_hvt ad=0.16875 pd=1.65 as=0.08775 ps=0.84 w=0.45 l=0.15
X4 X.t1 a_141_450.t4 VPWR.t2 VPB.t1 sky130_fd_pr__pfet_01v8_hvt ad=0.405 pd=2.91 as=0.405 ps=2.91 w=1.08 l=0.15
X5 X.t0 a_141_450.t3 VGND.t0 VNB.t1 sky130_fd_pr__nfet_01v8 ad=0.23625 pd=2.01 as=0.23625 ps=2.01 w=0.63 l=0.15
C0 B VPWR 0.0366f
C1 VPWR VPB 0.14391f
C2 B A 0.08246f
C3 VPB A 0.10842f
C4 VGND X 0.10221f
C5 VPWR A 0.02484f
C6 B VGND 0.04411f
C7 VGND VPB 0.01587f
C8 VPB X 0.01538f
C9 VGND VPWR 0.06339f
C10 VPWR X 0.08657f
C11 B VPB 0.09793f
C12 VGND A 0.0195f
C13 X A 0.00172f
R0 VGND.n0 VGND.t1 259.95
R1 VGND VGND.t0 231.744
R2 VGND VGND.n0 16.1606
R3 VGND.n0 VGND 0.110184
R4 X X.t1 366.469
R5 X.n0 X.t0 222.143
R6 X.n0 X 19.2005
R7 X X.n0 9.6005
R8 VPWR.n3 VPWR.t2 792.006
R9 VPWR.n8 VPWR.t0 683.168
R10 VPWR.n2 VPWR.t1 683.168
R11 VPWR.n9 VPWR.n8 15.7005
R12 VPWR.n6 VPWR.n1 12.8005
R13 VPWR.n7 VPWR.n6 12.8005
R14 VPWR.n3 VPWR.n2 11.2737
R15 VPWR.n7 VPWR.n0 9.3005
R16 VPWR.n6 VPWR.n5 9.3005
R17 VPWR.n4 VPWR.n1 9.3005
R18 VPWR.n2 VPWR.n1 6.4005
R19 VPWR.n8 VPWR.n7 6.4005
R20 VPWR.n4 VPWR.n3 1.44789
R21 VPWR.n5 VPWR.n4 0.063
R22 VPWR.n5 VPWR.n0 0.063
R23 VPWR.n9 VPWR.n0 0.063
R24 VPWR VPWR.n9 0.03175
R25 A.n0 A.t1 348.647
R26 A.n0 A.t0 232.968
R27 A A.n0 158.4
R28 B.n0 B.t1 348.647
R29 B.n0 B.t0 232.968
R30 B B.n0 158.4
R31 VPB.t2 VPB.t1 604.545
R32 VPB VPB.t0 302.274
R33 VPB.t0 VPB.t2 259.091
R34 VNB.t2 VNB.t1 2800
R35 VNB VNB.t0 1400
R36 VNB.t0 VNB.t2 1200
R37 a_141_36.t0 a_141_36.t1 104.001
R38 a_141_450.t0 a_141_450.n0 85.3672
R39 a_141_450.n0 a_141_450.t2 85.3672
R40 a_141_450.n0 a_141_450.n1 604.201
R41 a_141_450.n1 a_141_450.n2 209.601
R42 a_141_450.n2 a_141_450.t3 204.048
R43 a_141_450.n2 a_141_450.t4 247.428
R44 a_141_450.n1 a_141_450.t1 289.267
C14 VGND VNB 0.63614f
C15 X VNB 0.26199f
C16 VPWR VNB 0.38381f
C17 A VNB 0.22971f
C18 B VNB 0.25709f
C19 VPB VNB 0.81729f
C20 a_141_450.t0 VNB 0.01618f
C21 a_141_450.n0 VNB 0.03425f
C22 a_141_450.t1 VNB 0.07779f
C23 a_141_450.n1 VNB 0.55052f
C24 a_141_450.t4 VNB 0.04227f
C25 a_141_450.t3 VNB 0.02633f
C26 a_141_450.n2 VNB 0.14383f
C27 a_141_450.t2 VNB 0.01618f
C28 a_141_36.t0 VNB 0.0103f
C29 a_141_36.t1 VNB 0.0103f
C30 VPB.t1 VNB 0.21697f
C31 VPB.t2 VNB 0.13561f
C32 VPB.t0 VNB 0.08814f
C33 B.t1 VNB 0.0496f
C34 B.t0 VNB 0.03532f
C35 B.n0 VNB 0.17265f
C36 A.t1 VNB 0.06595f
C37 A.t0 VNB 0.04696f
C38 A.n0 VNB 0.22954f
C39 VPWR.n0 VNB 0.03092f
C40 VPWR.t0 VNB 0.01863f
C41 VPWR.n1 VNB 0.01159f
C42 VPWR.t2 VNB 0.04501f
C43 VPWR.t1 VNB 0.01863f
C44 VPWR.n2 VNB 0.042f
C45 VPWR.n3 VNB 0.07216f
C46 VPWR.n4 VNB 0.20753f
C47 VPWR.n5 VNB 0.03092f
C48 VPWR.n6 VNB 0.01546f
C49 VPWR.n7 VNB 0.01159f
C50 VPWR.n8 VNB 0.04315f
C51 VPWR.n9 VNB 0.02791f
C52 X.t1 VNB 0.08544f
C53 X.t0 VNB 0.04245f
C54 X.n0 VNB 0.03589f
C55 VGND.t0 VNB 0.02154f
C56 VGND.t1 VNB 0.0165f
C57 VGND.n0 VNB 0.27876f
.ends

.subckt sky130_efx_lvdig__and2_2 A B X VGND VNB VPB VPWR
X0 a_141_450.t1 A.t0 a_141_36.t1 VNB.t2 sky130_fd_pr__nfet_01v8 ad=0.16875 pd=1.65 as=0.08775 ps=0.84 w=0.45 l=0.15
X1 VGND.t2 a_141_450.t3 X.t3 VNB.t3 sky130_fd_pr__nfet_01v8 ad=0.23625 pd=2.01 as=0.12285 ps=1.02 w=0.63 l=0.15
X2 a_141_450.t0 B.t1 VPWR.t1 VPB.t2 sky130_fd_pr__pfet_01v8_hvt ad=0.08775 pd=0.84 as=0.16875 ps=1.65 w=0.45 l=0.15
X3 a_141_36.t0 B.t0 VGND.t0 VNB.t1 sky130_fd_pr__nfet_01v8 ad=0.08775 pd=0.84 as=0.16875 ps=1.65 w=0.45 l=0.15
X4 VPWR.t0 A.t1 a_141_450.t2 VPB.t3 sky130_fd_pr__pfet_01v8_hvt ad=0.16875 pd=1.65 as=0.08775 ps=0.84 w=0.45 l=0.15
X5 X.t2 a_141_450.t6 VPWR.t3 VPB.t1 sky130_fd_pr__pfet_01v8_hvt ad=0.2106 pd=1.47 as=0.405 ps=2.91 w=1.08 l=0.15
X6 VPWR.t2 a_141_450.t5 X.t1 VPB.t0 sky130_fd_pr__pfet_01v8_hvt ad=0.405 pd=2.91 as=0.2106 ps=1.47 w=1.08 l=0.15
X7 X.t0 a_141_450.t4 VGND.t1 VNB.t0 sky130_fd_pr__nfet_01v8 ad=0.12285 pd=1.02 as=0.23625 ps=2.01 w=0.63 l=0.15
C0 VPWR A 0.0253f
C1 B VGND 0.04411f
C2 VGND X 0.15357f
C3 A VPB 0.10919f
C4 VPWR VPB 0.15368f
C5 B A 0.08246f
C6 B VPWR 0.0366f
C7 A X 0.00172f
C8 VPWR X 0.17427f
C9 B VPB 0.09793f
C10 A VGND 0.01963f
C11 VPWR VGND 0.0815f
C12 X VPB 0.00865f
C13 VGND VPB 0.01449f
R0 VGND.n3 VGND.t0 253
R1 VGND VGND.t2 231.744
R2 VGND VGND.t1 231.744
R3 VGND.n0 VGND 16.2074
R4 VGND.n4 VGND.n3 15.7005
R5 VGND.n12 VGND.n1 12.8005
R6 VGND.n8 VGND.n1 12.8005
R7 VGND.n8 VGND.n7 12.8005
R8 VGND.n7 VGND.n6 12.8005
R9 VGND.n13 VGND.n0 12.1406
R10 VGND VGND.n13 9.6005
R11 VGND.n6 VGND.n5 9.3005
R12 VGND.n7 VGND.n2 9.3005
R13 VGND.n9 VGND.n8 9.3005
R14 VGND.n10 VGND.n1 9.3005
R15 VGND.n12 VGND.n11 9.3005
R16 VGND.n13 VGND.n12 6.4005
R17 VGND.n6 VGND.n3 6.4005
R18 VGND.n11 VGND.n0 0.584022
R19 VGND.n11 VGND.n10 0.063
R20 VGND.n10 VGND.n9 0.063
R21 VGND.n9 VGND.n2 0.063
R22 VGND.n5 VGND.n2 0.063
R23 VGND.n5 VGND.n4 0.063
R24 VGND.n4 VGND 0.03175
R25 X X.n0 308.5
R26 X.n2 X.n1 185
R27 X.n1 X.t3 37.1434
R28 X.n1 X.t0 37.1434
R29 X.n0 X.t1 35.5699
R30 X.n0 X.t2 35.5699
R31 X X.n2 19.2005
R32 X.n2 X 9.6005
R33 VPWR.n13 VPWR.t3 786.92
R34 VPWR.n3 VPWR.t1 683.168
R35 VPWR.n1 VPWR.t0 683.168
R36 VPWR.n15 VPWR.t2 328.07
R37 VPWR.n15 VPWR.n14 32.2074
R38 VPWR VPWR.n15 16.0005
R39 VPWR.n4 VPWR.n3 15.7005
R40 VPWR.n12 VPWR.n11 12.8005
R41 VPWR.n8 VPWR.n7 12.8005
R42 VPWR.n7 VPWR.n6 12.8005
R43 VPWR.n14 VPWR.n13 12.1406
R44 VPWR.n6 VPWR.n5 9.3005
R45 VPWR.n7 VPWR.n2 9.3005
R46 VPWR.n9 VPWR.n8 9.3005
R47 VPWR.n11 VPWR.n10 9.3005
R48 VPWR.n12 VPWR.n0 9.3005
R49 VPWR.n13 VPWR.n12 6.4005
R50 VPWR.n11 VPWR.n1 6.4005
R51 VPWR.n8 VPWR.n1 6.4005
R52 VPWR.n6 VPWR.n3 6.4005
R53 VPWR.n14 VPWR.n0 0.584022
R54 VPWR.n10 VPWR.n0 0.063
R55 VPWR.n10 VPWR.n9 0.063
R56 VPWR.n9 VPWR.n2 0.063
R57 VPWR.n5 VPWR.n2 0.063
R58 VPWR.n5 VPWR.n4 0.063
R59 VPWR.n4 VPWR 0.03175
R60 A.n0 A.t1 348.647
R61 A.n0 A.t0 232.968
R62 A A.n0 158.4
R63 B.n0 B.t1 348.647
R64 B.n0 B.t0 232.968
R65 B B.n0 158.4
R66 VPB.t3 VPB.t1 604.545
R67 VPB VPB.t2 302.274
R68 VPB.t1 VPB.t0 259.091
R69 VPB.t2 VPB.t3 259.091
R70 VNB.t2 VNB.t0 2800
R71 VNB VNB.t1 1400
R72 VNB.t0 VNB.t3 1200
R73 VNB.t1 VNB.t2 1200
R74 a_141_36.t0 a_141_36.t1 104.001
R75 a_141_450.t0 a_141_450.n0 85.3672
R76 a_141_450.n0 a_141_450.t2 85.3672
R77 a_141_450.n0 a_141_450.n1 604.201
R78 a_141_450.n1 a_141_450.n3 245.75
R79 a_141_450.n3 a_141_450.n2 72.3005
R80 a_141_450.n3 a_141_450.t6 231.361
R81 a_141_450.n3 a_141_450.t4 187.981
R82 a_141_450.n2 a_141_450.t5 231.361
R83 a_141_450.n2 a_141_450.t3 187.981
R84 a_141_450.n1 a_141_450.t1 289.267
C14 VGND VNB 0.6421f
C15 X VNB 0.27487f
C16 VPWR VNB 0.46567f
C17 A VNB 0.22923f
C18 B VNB 0.25709f
C19 VPB VNB 0.90217f
C20 a_141_450.t0 VNB 0.01588f
C21 a_141_450.n0 VNB 0.03363f
C22 a_141_450.t1 VNB 0.07637f
C23 a_141_450.n1 VNB 0.55247f
C24 a_141_450.t3 VNB 0.02321f
C25 a_141_450.t5 VNB 0.03909f
C26 a_141_450.n2 VNB 0.08234f
C27 a_141_450.t4 VNB 0.02321f
C28 a_141_450.t6 VNB 0.03909f
C29 a_141_450.n3 VNB 0.15772f
C30 a_141_450.t2 VNB 0.01588f
C31 a_141_36.t0 VNB 0.0103f
C32 a_141_36.t1 VNB 0.0103f
C33 VPB.t0 VNB 0.13375f
C34 VPB.t1 VNB 0.13375f
C35 VPB.t3 VNB 0.13375f
C36 VPB.t2 VNB 0.08694f
C37 B.t1 VNB 0.0496f
C38 B.t0 VNB 0.03532f
C39 B.n0 VNB 0.17265f
C40 A.t1 VNB 0.06615f
C41 A.t0 VNB 0.0471f
C42 A.n0 VNB 0.23025f
C43 VPWR.n0 VNB 0.14089f
C44 VPWR.t3 VNB 0.04457f
C45 VPWR.t0 VNB 0.01858f
C46 VPWR.n1 VNB 0.03618f
C47 VPWR.n2 VNB 0.03083f
C48 VPWR.t1 VNB 0.01858f
C49 VPWR.n3 VNB 0.04303f
C50 VPWR.n4 VNB 0.02784f
C51 VPWR.n5 VNB 0.03083f
C52 VPWR.n6 VNB 0.01156f
C53 VPWR.n7 VNB 0.01542f
C54 VPWR.n8 VNB 0.01156f
C55 VPWR.n9 VNB 0.03083f
C56 VPWR.n10 VNB 0.03083f
C57 VPWR.n11 VNB 0.01156f
C58 VPWR.n12 VNB 0.01156f
C59 VPWR.n13 VNB 0.04208f
C60 VPWR.n14 VNB 0.07105f
C61 VPWR.t2 VNB 0.04431f
C62 VPWR.n15 VNB 0.03674f
C63 X.t1 VNB 0.03338f
C64 X.t2 VNB 0.03338f
C65 X.n0 VNB 0.07128f
C66 X.t3 VNB 0.01947f
C67 X.t0 VNB 0.01947f
C68 X.n1 VNB 0.03894f
C69 X.n2 VNB 0.04621f
C70 VGND.t1 VNB 0.02167f
C71 VGND.t2 VNB 0.02167f
C72 VGND.n0 VNB 0.04898f
C73 VGND.n1 VNB 0.01311f
C74 VGND.n2 VNB 0.02621f
C75 VGND.t0 VNB 0.0154f
C76 VGND.n3 VNB 0.03698f
C77 VGND.n4 VNB 0.02367f
C78 VGND.n5 VNB 0.02621f
C79 VGND.n6 VNB 0.00983f
C80 VGND.n7 VNB 0.01311f
C81 VGND.n8 VNB 0.01311f
C82 VGND.n9 VNB 0.02621f
C83 VGND.n10 VNB 0.02621f
C84 VGND.n11 VNB 0.11977f
C85 VGND.n12 VNB 0.00983f
C86 VGND.n13 VNB 0.01796f
.ends

.subckt sky130_efx_lvdig__and2_4 A B X VGND VNB VPB VPWR
X0 VPWR.t0 nmos_n3f5_f2_l150_fnf_0.D0.t7 X.t0 VPB.t0 sky130_fd_pr__pfet_01v8_hvt ad=0.405 pd=2.91 as=0.2106 ps=1.47 w=1.08 l=0.15
X1 nmos_n3f5_f2_l150_fnf_0.D0.t2 A.t0 a_141_36.t1 VNB.t4 sky130_fd_pr__nfet_01v8 ad=0.23625 pd=2.01 as=0.12285 ps=1.02 w=0.63 l=0.15
X2 nmos_n3f5_f2_l150_fnf_0.D0.t0 B.t1 VPWR.t4 VPB.t4 sky130_fd_pr__pfet_01v8_hvt ad=0.2106 pd=1.47 as=0.405 ps=2.91 w=1.08 l=0.15
X3 VPWR.t5 A.t1 nmos_n3f5_f2_l150_fnf_0.D0.t1 VPB.t5 sky130_fd_pr__pfet_01v8_hvt ad=0.405 pd=2.91 as=0.2106 ps=1.47 w=1.08 l=0.15
X4 X.t5 nmos_n3f5_f2_l150_fnf_0.D0.t4 VGND.t2 VNB.t1 sky130_fd_pr__nfet_01v8 ad=0.12285 pd=1.02 as=0.12285 ps=1.02 w=0.63 l=0.15
X5 VGND.t1 nmos_n3f5_f2_l150_fnf_0.D0.t3 X.t2 VNB.t0 sky130_fd_pr__nfet_01v8 ad=0.23625 pd=2.01 as=0.12285 ps=1.02 w=0.63 l=0.15
X6 VGND.t3 nmos_n3f5_f2_l150_fnf_0.D0.t5 X.t6 VNB.t2 sky130_fd_pr__nfet_01v8 ad=0.12285 pd=1.02 as=0.12285 ps=1.02 w=0.63 l=0.15
X7 a_141_36.t0 B.t0 VGND.t0 VNB.t3 sky130_fd_pr__nfet_01v8 ad=0.12285 pd=1.02 as=0.23625 ps=2.01 w=0.63 l=0.15
X8 X.t3 nmos_n3f5_f2_l150_fnf_0.D0.t10 VPWR.t2 VPB.t2 sky130_fd_pr__pfet_01v8_hvt ad=0.2106 pd=1.47 as=0.405 ps=2.91 w=1.08 l=0.15
X9 VPWR.t1 nmos_n3f5_f2_l150_fnf_0.D0.t9 X.t1 VPB.t1 sky130_fd_pr__pfet_01v8_hvt ad=0.2106 pd=1.47 as=0.2106 ps=1.47 w=1.08 l=0.15
X10 X.t7 nmos_n3f5_f2_l150_fnf_0.D0.t6 VGND.t4 VNB.t5 sky130_fd_pr__nfet_01v8 ad=0.12285 pd=1.02 as=0.23625 ps=2.01 w=0.63 l=0.15
X11 X.t4 nmos_n3f5_f2_l150_fnf_0.D0.t8 VPWR.t3 VPB.t3 sky130_fd_pr__pfet_01v8_hvt ad=0.2106 pd=1.47 as=0.2106 ps=1.47 w=1.08 l=0.15
C0 VGND B 0.0539f
C1 nmos_n3f5_f2_l150_fnf_0.D0 VPWR 0.37571f
C2 X VPWR 0.43734f
C3 VGND A 0.01875f
C4 nmos_n3f5_f2_l150_fnf_0.D0 VPB 0.2201f
C5 X VPB 0.0153f
C6 nmos_n3f5_f2_l150_fnf_0.D0 B 0.05785f
C7 VPWR VPB 0.17877f
C8 nmos_n3f5_f2_l150_fnf_0.D0 A 0.18781f
C9 VGND nmos_n3f5_f2_l150_fnf_0.D0 0.2867f
C11 VPWR B 0.06512f
C12 X VGND 0.34107f
C13 VPWR A 0.02376f
C14 VGND VPWR 0.1038f
C15 B VPB 0.04956f
C16 A VPB 0.05339f
C17 X nmos_n3f5_f2_l150_fnf_0.D0 0.28553f
C18 VGND VPB 0.01254f
C19 A B 0.04923f
R0 VGND VGND.t1 231.744
R1 VGND VGND.t4 231.744
R2 VGND VGND.t0 231.744
R3 VGND VGND.n4 194.601
R4 VGND.n4 VGND.t2 37.1434
R5 VGND.n4 VGND.t3 37.1434
R6 VGND.n6 VGND 16.2074
R7 VGND.n21 VGND.n20 15.7005
R8 VGND.n9 VGND.n8 12.8005
R9 VGND.n11 VGND.n9 12.8005
R10 VGND.n15 VGND.n2 12.8005
R11 VGND.n16 VGND.n15 12.8005
R12 VGND.n17 VGND.n16 12.8005
R13 VGND.n17 VGND.n0 12.8005
R14 VGND.n6 VGND.n5 12.1406
R15 VGND.n5 VGND 9.6005
R16 VGND.n10 VGND 9.6005
R17 VGND VGND.n21 9.6005
R18 VGND.n19 VGND.n0 9.3005
R19 VGND.n18 VGND.n17 9.3005
R20 VGND.n16 VGND.n1 9.3005
R21 VGND.n15 VGND.n14 9.3005
R22 VGND.n13 VGND.n2 9.3005
R23 VGND.n12 VGND.n11 9.3005
R24 VGND.n9 VGND.n3 9.3005
R25 VGND.n8 VGND.n7 9.3005
R26 VGND.n8 VGND.n5 6.4005
R27 VGND.n11 VGND.n10 6.4005
R28 VGND.n10 VGND.n2 6.4005
R29 VGND.n21 VGND.n0 6.4005
R30 VGND.n7 VGND.n6 0.584022
R31 VGND.n7 VGND.n3 0.063
R32 VGND.n12 VGND.n3 0.063
R33 VGND.n13 VGND.n12 0.063
R34 VGND.n14 VGND.n13 0.063
R35 VGND.n14 VGND.n1 0.063
R36 VGND.n18 VGND.n1 0.063
R37 VGND.n19 VGND.n18 0.063
R38 VGND.n20 VGND.n19 0.063
R39 VGND.n20 VGND 0.03175
R40 X X.n3 308.5
R41 X X.n0 308.5
R42 X.n5 X.n4 185
R43 X.n2 X.n1 185
R44 X.n7 X.n6 38.4005
R45 X.n4 X.t2 37.1434
R46 X.n4 X.t5 37.1434
R47 X.n1 X.t6 37.1434
R48 X.n1 X.t7 37.1434
R49 X.n3 X.t0 35.5699
R50 X.n3 X.t4 35.5699
R51 X.n0 X.t1 35.5699
R52 X.n0 X.t3 35.5699
R53 X.n6 X.n5 19.2005
R54 X.n7 X.n2 19.2005
R55 X.n6 X 9.6005
R56 X.n5 X 9.6005
R57 X X.n7 9.6005
R58 X.n2 X 9.6005
R59 X.n7 X 6.4005
R60 VPWR.n14 VPWR.t5 786.92
R61 VPWR.n5 VPWR.t2 786.92
R62 VPWR.n8 VPWR.t4 353.67
R63 VPWR.n24 VPWR.t0 328.07
R64 VPWR.n2 VPWR.n1 292.5
R65 VPWR.n1 VPWR.t3 35.5699
R66 VPWR.n1 VPWR.t1 35.5699
R67 VPWR.n24 VPWR.n23 32.2074
R68 VPWR.n22 VPWR.n2 25.6005
R69 VPWR.n2 VPWR 16.0005
R70 VPWR VPWR.n24 16.0005
R71 VPWR.n8 VPWR.n7 15.7005
R72 VPWR.n21 VPWR.n20 12.8005
R73 VPWR.n20 VPWR.n3 12.8005
R74 VPWR.n16 VPWR.n15 12.8005
R75 VPWR.n13 VPWR.n6 12.8005
R76 VPWR.n9 VPWR.n6 12.8005
R77 VPWR.n23 VPWR.n22 12.1406
R78 VPWR.n10 VPWR.n9 9.3005
R79 VPWR.n11 VPWR.n6 9.3005
R80 VPWR.n13 VPWR.n12 9.3005
R81 VPWR.n15 VPWR.n4 9.3005
R82 VPWR.n17 VPWR.n16 9.3005
R83 VPWR.n18 VPWR.n3 9.3005
R84 VPWR.n20 VPWR.n19 9.3005
R85 VPWR.n21 VPWR.n0 9.3005
R86 VPWR.n22 VPWR.n21 6.4005
R87 VPWR.n5 VPWR.n3 6.4005
R88 VPWR.n16 VPWR.n5 6.4005
R89 VPWR.n15 VPWR.n14 6.4005
R90 VPWR.n14 VPWR.n13 6.4005
R91 VPWR.n9 VPWR.n8 6.4005
R92 VPWR.n23 VPWR.n0 0.584022
R93 VPWR.n19 VPWR.n0 0.063
R94 VPWR.n19 VPWR.n18 0.063
R95 VPWR.n18 VPWR.n17 0.063
R96 VPWR.n17 VPWR.n4 0.063
R97 VPWR.n12 VPWR.n4 0.063
R98 VPWR.n12 VPWR.n11 0.063
R99 VPWR.n11 VPWR.n10 0.063
R100 VPWR.n10 VPWR.n7 0.063
R101 VPWR.n7 VPWR 0.03175
R102 A.n0 A.t1 247.428
R103 A.n0 A.t0 204.048
R104 A A.n0 158.4
R105 B.n0 B.t1 247.428
R106 B.n0 B.t0 204.048
R107 B B.n0 158.4
R108 VPB.t5 VPB.t2 604.545
R109 VPB VPB.t4 302.274
R110 VPB.t3 VPB.t0 259.091
R111 VPB.t1 VPB.t3 259.091
R112 VPB.t2 VPB.t1 259.091
R113 VPB.t4 VPB.t5 259.091
R114 VNB.t4 VNB.t5 2800
R115 VNB VNB.t3 1400
R116 VNB.t1 VNB.t0 1200
R117 VNB.t2 VNB.t1 1200
R118 VNB.t5 VNB.t2 1200
R119 VNB.t3 VNB.t4 1200
R120 a_141_36.t0 a_141_36.t1 74.2862
R121 nmos_n3f5_f2_l150_fnf_0.D0.t2 nmos_n3f5_f2_l150_fnf_0.D0.n6 222.143
R122 nmos_n3f5_f2_l150_fnf_0.D0 nmos_n3f5_f2_l150_fnf_0.D0.n6 9.6005
R123 nmos_n3f5_f2_l150_fnf_0.D0.n6 nmos_n3f5_f2_l150_fnf_0.D0.n1 51.2005
R124 nmos_n3f5_f2_l150_fnf_0.D0.n1 nmos_n3f5_f2_l150_fnf_0.D0.n5 245.75
R125 nmos_n3f5_f2_l150_fnf_0.D0.n5 nmos_n3f5_f2_l150_fnf_0.D0.n4 72.3005
R126 nmos_n3f5_f2_l150_fnf_0.D0.n4 nmos_n3f5_f2_l150_fnf_0.D0.n3 72.3005
R127 nmos_n3f5_f2_l150_fnf_0.D0.n3 nmos_n3f5_f2_l150_fnf_0.D0.n2 72.3005
R128 nmos_n3f5_f2_l150_fnf_0.D0.n5 nmos_n3f5_f2_l150_fnf_0.D0.t10 231.361
R129 nmos_n3f5_f2_l150_fnf_0.D0.n5 nmos_n3f5_f2_l150_fnf_0.D0.t6 187.981
R130 nmos_n3f5_f2_l150_fnf_0.D0.n4 nmos_n3f5_f2_l150_fnf_0.D0.t9 231.361
R131 nmos_n3f5_f2_l150_fnf_0.D0.n4 nmos_n3f5_f2_l150_fnf_0.D0.t5 187.981
R132 nmos_n3f5_f2_l150_fnf_0.D0.n3 nmos_n3f5_f2_l150_fnf_0.D0.t8 231.361
R133 nmos_n3f5_f2_l150_fnf_0.D0.n3 nmos_n3f5_f2_l150_fnf_0.D0.t4 187.981
R134 nmos_n3f5_f2_l150_fnf_0.D0.n2 nmos_n3f5_f2_l150_fnf_0.D0.t7 231.361
R135 nmos_n3f5_f2_l150_fnf_0.D0.n2 nmos_n3f5_f2_l150_fnf_0.D0.t3 187.981
R136 nmos_n3f5_f2_l150_fnf_0.D0.n1 nmos_n3f5_f2_l150_fnf_0.D0.n0 298.901
R137 nmos_n3f5_f2_l150_fnf_0.D0.n0 nmos_n3f5_f2_l150_fnf_0.D0.t0 35.5699
R138 nmos_n3f5_f2_l150_fnf_0.D0.n0 nmos_n3f5_f2_l150_fnf_0.D0.t1 35.5699
C20 VGND VNB 0.82911f
C21 X VNB 0.35851f
C22 VPWR VNB 0.58281f
C23 A VNB 0.1855f
C24 B VNB 0.21234f
C25 VPB VNB 1.14762f
C26 nmos_n3f5_f2_l150_fnf_0.D0 VNB 0.48042f
C27 nmos_n3f5_f2_l150_fnf_0.D0.t2 VNB 0.07035f
C28 nmos_n3f5_f2_l150_fnf_0.D0.t0 VNB 0.03578f
C29 nmos_n3f5_f2_l150_fnf_0.D0.t1 VNB 0.03578f
C30 nmos_n3f5_f2_l150_fnf_0.D0.n0 VNB 0.07322f
C31 nmos_n3f5_f2_l150_fnf_0.D0.n1 VNB 0.41066f
C32 nmos_n3f5_f2_l150_fnf_0.D0.t3 VNB 0.02179f
C33 nmos_n3f5_f2_l150_fnf_0.D0.t7 VNB 0.0367f
C34 nmos_n3f5_f2_l150_fnf_0.D0.n2 VNB 0.0773f
C35 nmos_n3f5_f2_l150_fnf_0.D0.t4 VNB 0.02179f
C36 nmos_n3f5_f2_l150_fnf_0.D0.t8 VNB 0.0367f
C37 nmos_n3f5_f2_l150_fnf_0.D0.n3 VNB 0.09932f
C38 nmos_n3f5_f2_l150_fnf_0.D0.t5 VNB 0.02179f
C39 nmos_n3f5_f2_l150_fnf_0.D0.t9 VNB 0.0367f
C40 nmos_n3f5_f2_l150_fnf_0.D0.n4 VNB 0.09932f
C41 nmos_n3f5_f2_l150_fnf_0.D0.t6 VNB 0.02179f
C42 nmos_n3f5_f2_l150_fnf_0.D0.t10 VNB 0.0367f
C43 nmos_n3f5_f2_l150_fnf_0.D0.n5 VNB 0.14808f
C44 nmos_n3f5_f2_l150_fnf_0.D0.n6 VNB 0.11591f
C45 a_141_36.t0 VNB 0.01236f
C46 a_141_36.t1 VNB 0.01236f
C47 VPB.t0 VNB 0.10186f
C48 VPB.t3 VNB 0.06111f
C49 VPB.t1 VNB 0.06111f
C50 VPB.t2 VNB 0.10186f
C51 VPB.t5 VNB 0.10186f
C52 VPB.t4 VNB 0.06621f
C53 B.t1 VNB 0.05321f
C54 B.t0 VNB 0.03314f
C55 B.n0 VNB 0.13099f
C56 A.t1 VNB 0.06442f
C57 A.t0 VNB 0.04012f
C58 A.n0 VNB 0.15858f
C59 VPWR.n0 VNB 0.15871f
C60 VPWR.t3 VNB 0.01411f
C61 VPWR.t1 VNB 0.01411f
C62 VPWR.n1 VNB 0.02822f
C63 VPWR.n2 VNB 0.02822f
C64 VPWR.n3 VNB 0.01303f
C65 VPWR.n4 VNB 0.03473f
C66 VPWR.t2 VNB 0.05021f
C67 VPWR.n5 VNB 0.0388f
C68 VPWR.t5 VNB 0.05021f
C69 VPWR.n6 VNB 0.01737f
C70 VPWR.n7 VNB 0.03136f
C71 VPWR.t4 VNB 0.05338f
C72 VPWR.n8 VNB 0.07808f
C73 VPWR.n9 VNB 0.01303f
C74 VPWR.n10 VNB 0.03473f
C75 VPWR.n11 VNB 0.03473f
C76 VPWR.n12 VNB 0.03473f
C77 VPWR.n13 VNB 0.01303f
C78 VPWR.n14 VNB 0.0388f
C79 VPWR.n15 VNB 0.01303f
C80 VPWR.n16 VNB 0.01303f
C81 VPWR.n17 VNB 0.03473f
C82 VPWR.n18 VNB 0.03473f
C83 VPWR.n19 VNB 0.03473f
C84 VPWR.n20 VNB 0.01737f
C85 VPWR.n21 VNB 0.01303f
C86 VPWR.n22 VNB 0.03465f
C87 VPWR.n23 VNB 0.08004f
C88 VPWR.t0 VNB 0.04992f
C89 VPWR.n24 VNB 0.04139f
C90 X.t1 VNB 0.03338f
C91 X.t3 VNB 0.03338f
C92 X.n0 VNB 0.07128f
C93 X.t6 VNB 0.01947f
C94 X.t7 VNB 0.01947f
C95 X.n1 VNB 0.03894f
C96 X.n2 VNB 0.04621f
C97 X.t0 VNB 0.03338f
C98 X.t4 VNB 0.03338f
C99 X.n3 VNB 0.07128f
C100 X.t2 VNB 0.01947f
C101 X.t5 VNB 0.01947f
C102 X.n4 VNB 0.03894f
C103 X.n5 VNB 0.04621f
C104 X.n6 VNB 0.12837f
C105 X.n7 VNB 0.1181f
C106 VGND.t0 VNB 0.0247f
C107 VGND.n0 VNB 0.0112f
C108 VGND.n1 VNB 0.02988f
C109 VGND.n2 VNB 0.0112f
C110 VGND.n3 VNB 0.02988f
C111 VGND.t2 VNB 0.00708f
C112 VGND.t3 VNB 0.00708f
C113 VGND.n4 VNB 0.01499f
C114 VGND.n5 VNB 0.02047f
C115 VGND.t1 VNB 0.0247f
C116 VGND.n6 VNB 0.05583f
C117 VGND.n7 VNB 0.13652f
C118 VGND.n8 VNB 0.0112f
C119 VGND.n9 VNB 0.01494f
C120 VGND.t4 VNB 0.0247f
C121 VGND.n10 VNB 0.01307f
C122 VGND.n11 VNB 0.0112f
C123 VGND.n12 VNB 0.02988f
C124 VGND.n13 VNB 0.02988f
C125 VGND.n14 VNB 0.02988f
C126 VGND.n15 VNB 0.01494f
C127 VGND.n16 VNB 0.01494f
C128 VGND.n17 VNB 0.01494f
C129 VGND.n18 VNB 0.02988f
C130 VGND.n19 VNB 0.02988f
C131 VGND.n20 VNB 0.02698f
C132 VGND.n21 VNB 0.01971f
.ends

.subckt sky130_efx_lvdig__and3_1 A B C X VGND VNB VPB VPWR
X0 a_141_450.t3 B.t1 VPWR.t1 VPB.t3 sky130_fd_pr__pfet_01v8_hvt ad=0.08775 pd=0.84 as=0.16875 ps=1.65 w=0.45 l=0.15
X1 VPWR.t2 A.t1 a_141_450.t2 VPB.t2 sky130_fd_pr__pfet_01v8_hvt ad=0.16875 pd=1.65 as=0.08775 ps=0.84 w=0.45 l=0.15
X2 X.t1 a_141_450.t4 VGND.t0 VNB.t0 sky130_fd_pr__nfet_01v8 ad=0.23625 pd=2.01 as=0.23625 ps=2.01 w=0.63 l=0.15
X3 X.t0 a_141_450.t5 VPWR.t0 VPB.t0 sky130_fd_pr__pfet_01v8_hvt ad=0.405 pd=2.91 as=0.405 ps=2.91 w=1.08 l=0.15
X4 a_141_450.t0 C.t1 VPWR.t3 VPB.t1 sky130_fd_pr__pfet_01v8_hvt ad=0.16875 pd=1.65 as=0.16875 ps=1.65 w=0.45 l=0.15
X5 a_141_36.t0 C.t0 VGND.t1 VNB.t1 sky130_fd_pr__nfet_01v8 ad=0.16875 pd=1.65 as=0.16875 ps=1.65 w=0.45 l=0.15
X6 a_393_36.t1 B.t0 a_141_36.t1 VNB.t3 sky130_fd_pr__nfet_01v8 ad=0.08775 pd=0.84 as=0.16875 ps=1.65 w=0.45 l=0.15
X7 a_141_450.t1 A.t0 a_393_36.t0 VNB.t2 sky130_fd_pr__nfet_01v8 ad=0.16875 pd=1.65 as=0.08775 ps=0.84 w=0.45 l=0.15
C0 X VGND 0.10221f
C1 X VPWR 0.08657f
C2 C VPB 0.11458f
C3 B C 0.0414f
C4 VGND VPB 0.01692f
C5 B VGND 0.01946f
C6 VPWR VPB 0.18804f
C7 VPWR B 0.02487f
C8 A VGND 0.01753f
C9 X VPB 0.01121f
C10 A VPWR 0.02484f
C11 X A 0.00172f
C12 VGND C 0.0448f
C13 VPWR C 0.03739f
C14 B VPB 0.10467f
C15 A VPB 0.10794f
C16 A B 0.08246f
C17 VPWR VGND 0.07949f
R0 VGND.n0 VGND.t1 259.976
R1 VGND VGND.t0 231.744
R2 VGND VGND.n0 14.803
R3 VGND.n0 VGND 0.0844344
R4 X X.t0 366.469
R5 X.n0 X.t1 222.143
R6 X.n0 X 19.2005
R7 X X.n0 9.6005
R8 VPWR.n4 VPWR.t0 791.058
R9 VPWR.n3 VPWR.t2 683.168
R10 VPWR.n8 VPWR.t1 683.168
R11 VPWR.n14 VPWR.t3 683.168
R12 VPWR.n15 VPWR.n14 15.7005
R13 VPWR.n6 VPWR.n3 12.8005
R14 VPWR.n7 VPWR.n6 12.8005
R15 VPWR.n8 VPWR.n7 12.8005
R16 VPWR.n8 VPWR.n1 12.8005
R17 VPWR.n12 VPWR.n1 12.8005
R18 VPWR.n13 VPWR.n12 12.8005
R19 VPWR.n13 VPWR.n0 9.3005
R20 VPWR.n12 VPWR.n11 9.3005
R21 VPWR.n10 VPWR.n1 9.3005
R22 VPWR.n9 VPWR.n8 9.3005
R23 VPWR.n7 VPWR.n2 9.3005
R24 VPWR.n6 VPWR.n5 9.3005
R25 VPWR.n14 VPWR.n13 6.4005
R26 VPWR.n4 VPWR.n3 5.5582
R27 VPWR.n5 VPWR.n4 0.763402
R28 VPWR.n5 VPWR.n2 0.063
R29 VPWR.n9 VPWR.n2 0.063
R30 VPWR.n10 VPWR.n9 0.063
R31 VPWR.n11 VPWR.n10 0.063
R32 VPWR.n11 VPWR.n0 0.063
R33 VPWR.n15 VPWR.n0 0.063
R34 VPWR VPWR.n15 0.03175
R35 A.n0 A.t1 348.647
R36 A.n0 A.t0 232.968
R37 A A.n0 158.4
R38 B.n0 B.t1 348.647
R39 B.n0 B.t0 232.968
R40 B B.n0 158.4
R41 C.n0 C.t1 348.647
R42 C.n0 C.t0 232.968
R43 C C.n0 158.4
R44 VPB.t2 VPB.t0 604.545
R45 VPB.t1 VPB.t3 604.545
R46 VPB VPB.t1 302.274
R47 VPB.t3 VPB.t2 259.091
R48 VNB.t2 VNB.t0 2800
R49 VNB.t1 VNB.t3 2800
R50 VNB VNB.t1 1400
R51 VNB.t3 VNB.t2 1200
R52 a_393_36.t0 a_393_36.t1 104.001
R53 a_141_36.t0 a_141_36.t1 499.601
R54 a_141_450.t0 a_141_450.n1 734.367
R55 a_141_450.n1 a_141_450.n2 209.601
R56 a_141_450.n2 a_141_450.t4 204.048
R57 a_141_450.n2 a_141_450.t5 247.428
R58 a_141_450.n1 a_141_450.n0 604.201
R59 a_141_450.n0 a_141_450.t3 85.3672
R60 a_141_450.n0 a_141_450.t2 85.3672
R61 a_141_450.n1 a_141_450.t1 289.267
C18 VGND VNB 0.71438f
C19 X VNB 0.26414f
C20 VPWR VNB 0.46961f
C21 A VNB 0.23f
C22 B VNB 0.22459f
C23 C VNB 0.26245f
C24 VPB VNB 1.07695f
C25 a_141_450.t0 VNB 0.06855f
C26 a_141_450.t1 VNB 0.0753f
C27 a_141_450.t3 VNB 0.01566f
C28 a_141_450.t2 VNB 0.01566f
C29 a_141_450.n0 VNB 0.03315f
C30 a_141_450.n1 VNB 0.77899f
C31 a_141_450.t5 VNB 0.04092f
C32 a_141_450.t4 VNB 0.02548f
C33 a_141_450.n2 VNB 0.13923f
C34 a_141_36.t0 VNB 0.11558f
C35 a_141_36.t1 VNB 0.11558f
C36 a_393_36.t0 VNB 0.01032f
C37 a_393_36.t1 VNB 0.01032f
C38 VPB.t0 VNB 0.20208f
C39 VPB.t2 VNB 0.14434f
C40 VPB.t3 VNB 0.14434f
C41 VPB.t1 VNB 0.15156f
C42 C.t1 VNB 0.03972f
C43 C.t0 VNB 0.02828f
C44 C.n0 VNB 0.13825f
C45 B.t1 VNB 0.06276f
C46 B.t0 VNB 0.04469f
C47 B.n0 VNB 0.21846f
C48 A.t1 VNB 0.0658f
C49 A.t0 VNB 0.04685f
C50 A.n0 VNB 0.22903f
C51 VPWR.n0 VNB 0.03295f
C52 VPWR.t3 VNB 0.01986f
C53 VPWR.n1 VNB 0.01648f
C54 VPWR.n2 VNB 0.03295f
C55 VPWR.t1 VNB 0.01986f
C56 VPWR.t2 VNB 0.01986f
C57 VPWR.n3 VNB 0.05097f
C58 VPWR.t0 VNB 0.04794f
C59 VPWR.n4 VNB 0.08621f
C60 VPWR.n5 VNB 0.2016f
C61 VPWR.n6 VNB 0.01648f
C62 VPWR.n7 VNB 0.01648f
C63 VPWR.n8 VNB 0.04691f
C64 VPWR.n9 VNB 0.03295f
C65 VPWR.n10 VNB 0.03295f
C66 VPWR.n11 VNB 0.03295f
C67 VPWR.n12 VNB 0.01648f
C68 VPWR.n13 VNB 0.01236f
C69 VPWR.n14 VNB 0.04599f
C70 VPWR.n15 VNB 0.02975f
C71 X.t0 VNB 0.08431f
C72 X.t1 VNB 0.04189f
C73 X.n0 VNB 0.03542f
C74 VGND.t0 VNB 0.02406f
C75 VGND.t1 VNB 0.01844f
C76 VGND.n0 VNB 0.49956f
.ends

.subckt sky130_efx_lvdig__and4_2 A B C D X VGND VNB VPB VPWR
X0 a_249_36.t0 C.t0 a_141_36.t0 VNB.t3 sky130_fd_pr__nfet_01v8 ad=0.16875 pd=1.65 as=0.08775 ps=0.84 w=0.45 l=0.15
X1 X.t1 a_141_450.t6 VGND.t0 VNB.t0 sky130_fd_pr__nfet_01v8 ad=0.12285 pd=1.02 as=0.23625 ps=2.01 w=0.63 l=0.15
X2 a_141_450.t4 B.t1 VPWR.t2 VPB.t5 sky130_fd_pr__pfet_01v8_hvt ad=0.08775 pd=0.84 as=0.16875 ps=1.65 w=0.45 l=0.15
X3 VPWR.t5 A.t1 a_141_450.t0 VPB.t1 sky130_fd_pr__pfet_01v8_hvt ad=0.16875 pd=1.65 as=0.08775 ps=0.84 w=0.45 l=0.15
X4 a_141_450.t1 A.t0 a_501_36.t0 VNB.t1 sky130_fd_pr__nfet_01v8 ad=0.16875 pd=1.65 as=0.08775 ps=0.84 w=0.45 l=0.15
X5 a_141_450.t3 D.t1 VPWR.t0 VPB.t4 sky130_fd_pr__pfet_01v8_hvt ad=0.08775 pd=0.84 as=0.16875 ps=1.65 w=0.45 l=0.15
X6 X.t0 a_141_450.t8 VPWR.t1 VPB.t0 sky130_fd_pr__pfet_01v8_hvt ad=0.2106 pd=1.47 as=0.405 ps=2.91 w=1.08 l=0.15
X7 a_141_36.t1 D.t0 VGND.t2 VNB.t4 sky130_fd_pr__nfet_01v8 ad=0.08775 pd=0.84 as=0.16875 ps=1.65 w=0.45 l=0.15
X8 VGND.t1 a_141_450.t5 X.t2 VNB.t2 sky130_fd_pr__nfet_01v8 ad=0.23625 pd=2.01 as=0.12285 ps=1.02 w=0.63 l=0.15
X9 VPWR.t3 a_141_450.t7 X.t3 VPB.t2 sky130_fd_pr__pfet_01v8_hvt ad=0.405 pd=2.91 as=0.2106 ps=1.47 w=1.08 l=0.15
X10 VPWR.t4 C.t1 a_141_450.t2 VPB.t3 sky130_fd_pr__pfet_01v8_hvt ad=0.16875 pd=1.65 as=0.08775 ps=0.84 w=0.45 l=0.15
X11 a_501_36.t1 B.t0 a_249_36.t1 VNB.t5 sky130_fd_pr__nfet_01v8 ad=0.08775 pd=0.84 as=0.16875 ps=1.65 w=0.45 l=0.15
C0 VPWR VGND 0.11115f
C1 VPWR A 0.0253f
C2 VPWR B 0.025f
C3 C VGND 0.02153f
C4 A VGND 0.01761f
C5 B C 0.05771f
C6 B VGND 0.01936f
C7 B A 0.08246f
C8 VPB X 0.00865f
C9 X VPWR 0.17427f
C10 D VPB 0.09793f
C11 X VGND 0.15357f
C12 X A 0.00172f
C13 D VPWR 0.0366f
C14 D C 0.0965f
C15 D VGND 0.04393f
C16 VPB VPWR 0.23111f
C17 VPB C 0.10467f
C18 VPB VGND 0.02051f
C19 VPB A 0.10919f
C20 VPB B 0.10467f
C21 VPWR C 0.025f
R0 VGND.n6 VGND.t2 253
R1 VGND VGND.t1 231.744
R2 VGND VGND.t0 231.744
R3 VGND.n0 VGND 16.2074
R4 VGND.n7 VGND.n6 15.7005
R5 VGND.n22 VGND.n1 12.8005
R6 VGND.n18 VGND.n1 12.8005
R7 VGND.n18 VGND.n17 12.8005
R8 VGND.n17 VGND.n16 12.8005
R9 VGND.n16 VGND.n3 12.8005
R10 VGND.n12 VGND.n3 12.8005
R11 VGND.n12 VGND.n11 12.8005
R12 VGND.n11 VGND.n10 12.8005
R13 VGND.n10 VGND.n5 12.8005
R14 VGND.n23 VGND.n0 12.1406
R15 VGND VGND.n23 9.6005
R16 VGND.n8 VGND.n5 9.3005
R17 VGND.n10 VGND.n9 9.3005
R18 VGND.n11 VGND.n4 9.3005
R19 VGND.n13 VGND.n12 9.3005
R20 VGND.n14 VGND.n3 9.3005
R21 VGND.n16 VGND.n15 9.3005
R22 VGND.n17 VGND.n2 9.3005
R23 VGND.n19 VGND.n18 9.3005
R24 VGND.n20 VGND.n1 9.3005
R25 VGND.n22 VGND.n21 9.3005
R26 VGND.n23 VGND.n22 6.4005
R27 VGND.n6 VGND.n5 6.4005
R28 VGND.n21 VGND.n0 0.584022
R29 VGND.n21 VGND.n20 0.063
R30 VGND.n20 VGND.n19 0.063
R31 VGND.n19 VGND.n2 0.063
R32 VGND.n15 VGND.n2 0.063
R33 VGND.n15 VGND.n14 0.063
R34 VGND.n14 VGND.n13 0.063
R35 VGND.n13 VGND.n4 0.063
R36 VGND.n9 VGND.n4 0.063
R37 VGND.n9 VGND.n8 0.063
R38 VGND.n8 VGND.n7 0.063
R39 VGND.n7 VGND 0.03175
R40 X X.n0 308.5
R41 X.n2 X.n1 185
R42 X.n1 X.t2 37.1434
R43 X.n1 X.t1 37.1434
R44 X.n0 X.t3 35.5699
R45 X.n0 X.t0 35.5699
R46 X X.n2 19.2005
R47 X.n2 X 9.6005
R48 VPWR.n25 VPWR.t1 786.92
R49 VPWR.n7 VPWR.t0 683.168
R50 VPWR.n13 VPWR.t4 683.168
R51 VPWR.n3 VPWR.t2 683.168
R52 VPWR.n1 VPWR.t5 683.168
R53 VPWR.n27 VPWR.t3 328.07
R54 VPWR.n27 VPWR.n26 32.2074
R55 VPWR VPWR.n27 16.0005
R56 VPWR.n7 VPWR.n6 15.7005
R57 VPWR.n24 VPWR.n23 12.8005
R58 VPWR.n20 VPWR.n19 12.8005
R59 VPWR.n19 VPWR.n18 12.8005
R60 VPWR.n15 VPWR.n14 12.8005
R61 VPWR.n12 VPWR.n5 12.8005
R62 VPWR.n8 VPWR.n5 12.8005
R63 VPWR.n26 VPWR.n25 12.1406
R64 VPWR.n9 VPWR.n8 9.3005
R65 VPWR.n10 VPWR.n5 9.3005
R66 VPWR.n12 VPWR.n11 9.3005
R67 VPWR.n14 VPWR.n4 9.3005
R68 VPWR.n16 VPWR.n15 9.3005
R69 VPWR.n18 VPWR.n17 9.3005
R70 VPWR.n19 VPWR.n2 9.3005
R71 VPWR.n21 VPWR.n20 9.3005
R72 VPWR.n23 VPWR.n22 9.3005
R73 VPWR.n24 VPWR.n0 9.3005
R74 VPWR.n25 VPWR.n24 6.4005
R75 VPWR.n23 VPWR.n1 6.4005
R76 VPWR.n20 VPWR.n1 6.4005
R77 VPWR.n18 VPWR.n3 6.4005
R78 VPWR.n15 VPWR.n3 6.4005
R79 VPWR.n14 VPWR.n13 6.4005
R80 VPWR.n13 VPWR.n12 6.4005
R81 VPWR.n8 VPWR.n7 6.4005
R82 VPWR.n26 VPWR.n0 0.584022
R83 VPWR.n22 VPWR.n0 0.063
R84 VPWR.n22 VPWR.n21 0.063
R85 VPWR.n21 VPWR.n2 0.063
R86 VPWR.n17 VPWR.n2 0.063
R87 VPWR.n17 VPWR.n16 0.063
R88 VPWR.n16 VPWR.n4 0.063
R89 VPWR.n11 VPWR.n4 0.063
R90 VPWR.n11 VPWR.n10 0.063
R91 VPWR.n10 VPWR.n9 0.063
R92 VPWR.n9 VPWR.n6 0.063
R93 VPWR.n6 VPWR 0.03175
R94 A.n0 A.t1 348.647
R95 A.n0 A.t0 232.968
R96 A A.n0 158.4
R97 B.n0 B.t1 348.647
R98 B.n0 B.t0 232.968
R99 B B.n0 158.4
R100 C.n0 C.t1 348.647
R101 C.n0 C.t0 232.968
R102 C C.n0 158.4
R103 D.n0 D.t1 348.647
R104 D.n0 D.t0 232.968
R105 D D.n0 158.4
R106 VPB.t1 VPB.t0 604.545
R107 VPB.t3 VPB.t5 604.545
R108 VPB VPB.t4 302.274
R109 VPB.t0 VPB.t2 259.091
R110 VPB.t5 VPB.t1 259.091
R111 VPB.t4 VPB.t3 259.091
R112 VNB.t1 VNB.t0 2800
R113 VNB.t3 VNB.t5 2800
R114 VNB VNB.t4 1400
R115 VNB.t0 VNB.t2 1200
R116 VNB.t5 VNB.t1 1200
R117 VNB.t4 VNB.t3 1200
R118 a_501_36.t0 a_501_36.t1 104.001
R119 a_249_36.t0 a_249_36.t1 499.601
R120 a_141_36.t0 a_141_36.t1 104.001
R121 a_141_450.n0 a_141_450.t4 85.3672
R122 a_141_450.t0 a_141_450.n0 85.3672
R123 a_141_450.n0 a_141_450.n1 604.201
R124 a_141_450.n1 a_141_450.n4 245.75
R125 a_141_450.n4 a_141_450.n3 72.3005
R126 a_141_450.n4 a_141_450.t8 231.361
R127 a_141_450.n4 a_141_450.t6 187.981
R128 a_141_450.n3 a_141_450.t7 231.361
R129 a_141_450.n3 a_141_450.t5 187.981
R130 a_141_450.n1 a_141_450.n2 668.201
R131 a_141_450.n2 a_141_450.t3 85.3672
R132 a_141_450.n2 a_141_450.t2 85.3672
R133 a_141_450.n1 a_141_450.t1 289.267
C22 VGND VNB 0.85299f
C23 X VNB 0.27487f
C24 VPWR VNB 0.60926f
C25 A VNB 0.22912f
C26 B VNB 0.22138f
C27 C VNB 0.21672f
C28 D VNB 0.25225f
C29 VPB VNB 1.33435f
C30 a_141_450.t0 VNB 0.01605f
C31 a_141_450.n0 VNB 0.03399f
C32 a_141_450.t1 VNB 0.0772f
C33 a_141_450.n1 VNB 0.86603f
C34 a_141_450.t3 VNB 0.01605f
C35 a_141_450.t2 VNB 0.01605f
C36 a_141_450.n2 VNB 0.05652f
C37 a_141_450.t5 VNB 0.02346f
C38 a_141_450.t7 VNB 0.03952f
C39 a_141_450.n3 VNB 0.08323f
C40 a_141_450.t6 VNB 0.02346f
C41 a_141_450.t8 VNB 0.03952f
C42 a_141_450.n4 VNB 0.15944f
C43 a_141_450.t4 VNB 0.01605f
C44 a_141_36.t0 VNB 0.00997f
C45 a_141_36.t1 VNB 0.00997f
C46 a_249_36.t0 VNB 0.11174f
C47 a_249_36.t1 VNB 0.11174f
C48 a_501_36.t0 VNB 0.01032f
C49 a_501_36.t1 VNB 0.01032f
C50 VPB.t2 VNB 0.1466f
C51 VPB.t0 VNB 0.1466f
C52 VPB.t1 VNB 0.1466f
C53 VPB.t5 VNB 0.1466f
C54 VPB.t3 VNB 0.1466f
C55 VPB.t4 VNB 0.09529f
C56 D.t1 VNB 0.04447f
C57 D.t0 VNB 0.03167f
C58 D.n0 VNB 0.15479f
C59 C.t1 VNB 0.06007f
C60 C.t0 VNB 0.04277f
C61 C.n0 VNB 0.20908f
C62 B.t1 VNB 0.06507f
C63 B.t0 VNB 0.04633f
C64 B.n0 VNB 0.22649f
C65 A.t1 VNB 0.06608f
C66 A.t0 VNB 0.04705f
C67 A.n0 VNB 0.22998f
C68 VPWR.n0 VNB 0.14466f
C69 VPWR.t1 VNB 0.04576f
C70 VPWR.t5 VNB 0.01908f
C71 VPWR.n1 VNB 0.03715f
C72 VPWR.n2 VNB 0.03166f
C73 VPWR.t2 VNB 0.01908f
C74 VPWR.n3 VNB 0.03715f
C75 VPWR.n4 VNB 0.03166f
C76 VPWR.t4 VNB 0.01908f
C77 VPWR.n5 VNB 0.01583f
C78 VPWR.n6 VNB 0.02858f
C79 VPWR.t0 VNB 0.01908f
C80 VPWR.n7 VNB 0.04419f
C81 VPWR.n8 VNB 0.01187f
C82 VPWR.n9 VNB 0.03166f
C83 VPWR.n10 VNB 0.03166f
C84 VPWR.n11 VNB 0.03166f
C85 VPWR.n12 VNB 0.01187f
C86 VPWR.n13 VNB 0.03715f
C87 VPWR.n14 VNB 0.01187f
C88 VPWR.n15 VNB 0.01187f
C89 VPWR.n16 VNB 0.03166f
C90 VPWR.n17 VNB 0.03166f
C91 VPWR.n18 VNB 0.01187f
C92 VPWR.n19 VNB 0.01583f
C93 VPWR.n20 VNB 0.01187f
C94 VPWR.n21 VNB 0.03166f
C95 VPWR.n22 VNB 0.03166f
C96 VPWR.n23 VNB 0.01187f
C97 VPWR.n24 VNB 0.01187f
C98 VPWR.n25 VNB 0.0432f
C99 VPWR.n26 VNB 0.07296f
C100 VPWR.t3 VNB 0.0455f
C101 VPWR.n27 VNB 0.03773f
C102 X.t3 VNB 0.03338f
C103 X.t0 VNB 0.03338f
C104 X.n0 VNB 0.07128f
C105 X.t2 VNB 0.01947f
C106 X.t1 VNB 0.01947f
C107 X.n1 VNB 0.03894f
C108 X.n2 VNB 0.04621f
C109 VGND.t0 VNB 0.0224f
C110 VGND.t1 VNB 0.0224f
C111 VGND.n0 VNB 0.05063f
C112 VGND.n1 VNB 0.01355f
C113 VGND.n2 VNB 0.02709f
C114 VGND.n3 VNB 0.01355f
C115 VGND.n4 VNB 0.02709f
C116 VGND.n5 VNB 0.01016f
C117 VGND.t2 VNB 0.01592f
C118 VGND.n6 VNB 0.03822f
C119 VGND.n7 VNB 0.02446f
C120 VGND.n8 VNB 0.02709f
C121 VGND.n9 VNB 0.02709f
C122 VGND.n10 VNB 0.01355f
C123 VGND.n11 VNB 0.01355f
C124 VGND.n12 VNB 0.01355f
C125 VGND.n13 VNB 0.02709f
C126 VGND.n14 VNB 0.02709f
C127 VGND.n15 VNB 0.02709f
C128 VGND.n16 VNB 0.01355f
C129 VGND.n17 VNB 0.01355f
C130 VGND.n18 VNB 0.01355f
C131 VGND.n19 VNB 0.02709f
C132 VGND.n20 VNB 0.02709f
C133 VGND.n21 VNB 0.1238f
C134 VGND.n22 VNB 0.01016f
C135 VGND.n23 VNB 0.01856f
.ends

.subckt sky130_efx_lvdig__buf_1 A X VGND VNB VPB VPWR
X0 pmos_n4f5_f1_l150_hvt_0.D0.t0 A.t1 VPWR.t1 VPB.t1 sky130_fd_pr__pfet_01v8_hvt ad=0.30375 pd=2.37 as=0.30375 ps=2.37 w=0.81 l=0.15
X1 X.t0 pmos_n4f5_f1_l150_hvt_0.D0.t3 VPWR.t0 VPB.t0 sky130_fd_pr__pfet_01v8_hvt ad=0.30375 pd=2.37 as=0.30375 ps=2.37 w=0.81 l=0.15
X2 pmos_n4f5_f1_l150_hvt_0.D0.t1 A.t0 VGND.t0 VNB.t0 sky130_fd_pr__nfet_01v8 ad=0.2025 pd=1.83 as=0.2025 ps=1.83 w=0.54 l=0.15
X3 X.t1 pmos_n4f5_f1_l150_hvt_0.D0.t2 VGND.t1 VNB.t1 sky130_fd_pr__nfet_01v8 ad=0.2025 pd=1.83 as=0.2025 ps=1.83 w=0.54 l=0.15
C0 VPB VPWR 0.12004f
C1 A VPWR 0.04838f
C2 VGND X 0.09485f
C3 X VPB 0.01701f
C4 X VPWR 0.11669f
C5 VGND VPB 0.01397f
C6 VGND A 0.04989f
C7 A VPB 0.08142f
C8 VGND VPWR 0.05372f
R0 VGND VGND.t1 234.733
R1 VGND VGND.t0 234.733
R2 VGND VGND.n0 16.4553
R3 VGND.n0 VGND 14.3674
R4 VGND.n0 VGND 0.204961
R5 X X.t0 352.726
R6 X.n0 X.t1 228.333
R7 X X.n0 22.4005
R8 X.n0 X 6.4005
R9 VPWR.n0 VPWR.t1 369.182
R10 VPWR.n0 VPWR.t0 367.094
R11 VPWR VPWR.n0 0.204961
R12 A.n0 A.t1 281.168
R13 A.n0 A.t0 208.868
R14 A A.n0 158.4
R15 VPB.t1 VPB.t0 604.545
R16 VPB VPB.t1 302.274
R17 VNB.t0 VNB.t1 2800
R18 VNB VNB.t0 1400
R19 pmos_n4f5_f1_l150_hvt_0.D0.t1 pmos_n4f5_f1_l150_hvt_0.D0.n2 228.333
R20 nmos_n3_f1_l150_0.S0 pmos_n4f5_f1_l150_hvt_0.D0.n2 6.4005
R21 pmos_n4f5_f1_l150_hvt_0.D0.n2 pmos_n4f5_f1_l150_hvt_0.D0.n0 35.2005
R22 pmos_n4f5_f1_l150_hvt_0.D0.n0 pmos_n4f5_f1_l150_hvt_0.D0.n1 228.25
R23 pmos_n4f5_f1_l150_hvt_0.D0.n1 pmos_n4f5_f1_l150_hvt_0.D0.t3 265.101
R24 pmos_n4f5_f1_l150_hvt_0.D0.n1 pmos_n4f5_f1_l150_hvt_0.D0.t2 192.8
R25 pmos_n4f5_f1_l150_hvt_0.D0.n0 pmos_n4f5_f1_l150_hvt_0.D0.t0 384.726
C9 VGND VNB 0.63775f
C10 X VNB 0.28248f
C11 VPWR VNB 0.51061f
C12 A VNB 0.23606f
C13 VPB VNB 0.64275f
C14 pmos_n4f5_f1_l150_hvt_0.D0.t1 VNB 0.05817f
C15 pmos_n4f5_f1_l150_hvt_0.D0.t0 VNB 0.10401f
C16 pmos_n4f5_f1_l150_hvt_0.D0.n0 VNB 0.23632f
C17 pmos_n4f5_f1_l150_hvt_0.D0.t2 VNB 0.01996f
C18 pmos_n4f5_f1_l150_hvt_0.D0.t3 VNB 0.03226f
C19 pmos_n4f5_f1_l150_hvt_0.D0.n1 VNB 0.1188f
C20 nmos_n3_f1_l150_0.S0 VNB 0.02166f
C21 pmos_n4f5_f1_l150_hvt_0.D0.n2 VNB 0.05626f
C22 VPB.t0 VNB 0.17601f
C23 VPB.t1 VNB 0.13201f
C24 A.t1 VNB 0.04336f
C25 A.t0 VNB 0.02836f
C26 A.n0 VNB 0.1293f
C27 VPWR.t0 VNB 0.04013f
C28 VPWR.t1 VNB 0.04037f
C29 VPWR.n0 VNB 0.2836f
C30 X.t0 VNB 0.06081f
C31 X.t1 VNB 0.03757f
C32 X.n0 VNB 0.0376f
C33 VGND.t0 VNB 0.01881f
C34 VGND.t1 VNB 0.01881f
C35 VGND.n0 VNB 0.13335f
.ends

.subckt sky130_efx_lvdig__buf_2 A X VGND VNB VPB VPWR
X0 pmos_n3f5_f1_l150_hvt_0.D0.t0 A.t1 VPWR.t2 VPB.t2 sky130_fd_pr__pfet_01v8_hvt ad=0.23625 pd=2.01 as=0.23625 ps=2.01 w=0.63 l=0.15
X1 pmos_n3f5_f1_l150_hvt_0.D0.t1 A.t0 VGND.t2 VNB.t2 sky130_fd_pr__nfet_01v8 ad=0.16875 pd=1.65 as=0.16875 ps=1.65 w=0.45 l=0.15
X2 X.t1 pmos_n3f5_f1_l150_hvt_0.D0.t5 VPWR.t1 VPB.t1 sky130_fd_pr__pfet_01v8_hvt ad=0.2106 pd=1.47 as=0.405 ps=2.91 w=1.08 l=0.15
X3 VPWR.t0 pmos_n3f5_f1_l150_hvt_0.D0.t4 X.t0 VPB.t0 sky130_fd_pr__pfet_01v8_hvt ad=0.405 pd=2.91 as=0.2106 ps=1.47 w=1.08 l=0.15
X4 X.t2 pmos_n3f5_f1_l150_hvt_0.D0.t3 VGND.t0 VNB.t0 sky130_fd_pr__nfet_01v8 ad=0.12285 pd=1.02 as=0.23625 ps=2.01 w=0.63 l=0.15
X5 VGND.t1 pmos_n3f5_f1_l150_hvt_0.D0.t2 X.t3 VNB.t1 sky130_fd_pr__nfet_01v8 ad=0.23625 pd=2.01 as=0.12285 ps=1.02 w=0.63 l=0.15
C0 VPB A 0.10218f
C1 pmos_n3f5_f1_l150_hvt_0.D0 VPB 0.15195f
C2 VPWR VGND 0.08723f
C3 VPWR X 0.22627f
C4 pmos_n3f5_f1_l150_hvt_0.D0 A 0.09439f
C5 VPWR VPB 0.15612f
C6 VGND X 0.15357f
C7 VPWR A 0.04391f
C8 VPWR pmos_n3f5_f1_l150_hvt_0.D0 0.23881f
C9 VGND VPB 0.01756f
C10 VPB X 0.00808f
C11 VGND A 0.04637f
C13 pmos_n3f5_f1_l150_hvt_0.D0 VGND 0.19525f
C14 pmos_n3f5_f1_l150_hvt_0.D0 X 0.11017f
R0 VGND VGND.t2 243.4
R1 VGND VGND.t1 231.744
R2 VGND VGND.t0 231.744
R3 VGND.n9 VGND.n8 15.7005
R4 VGND.n2 VGND 14.3698
R5 VGND.n4 VGND.n3 12.8005
R6 VGND.n5 VGND.n4 12.8005
R7 VGND.n5 VGND.n0 12.8005
R8 VGND.n3 VGND 9.6005
R9 VGND VGND.n9 9.6005
R10 VGND.n7 VGND.n0 9.3005
R11 VGND.n6 VGND.n5 9.3005
R12 VGND.n4 VGND.n1 9.3005
R13 VGND.n9 VGND.n0 6.4005
R14 VGND.n3 VGND.n2 6.00163
R15 VGND.n2 VGND.n1 0.319971
R16 VGND.n6 VGND.n1 0.063
R17 VGND.n7 VGND.n6 0.063
R18 VGND.n8 VGND.n7 0.063
R19 VGND.n8 VGND 0.03175
R20 X X.n0 308.5
R21 X.n2 X.n1 185
R22 X.n1 X.t3 37.1434
R23 X.n1 X.t2 37.1434
R24 X.n0 X.t0 35.5699
R25 X.n0 X.t1 35.5699
R26 X X.n2 19.2005
R27 X.n2 X 9.6005
R28 VPWR.n3 VPWR.t2 665.177
R29 VPWR.n8 VPWR.t0 328.07
R30 VPWR.n11 VPWR.t1 328.07
R31 VPWR.n9 VPWR.n8 30.3698
R32 VPWR.n11 VPWR.n10 25.6005
R33 VPWR.n8 VPWR 16.0005
R34 VPWR VPWR.n11 16.0005
R35 VPWR.n3 VPWR.n2 15.7005
R36 VPWR.n10 VPWR.n0 12.8005
R37 VPWR.n5 VPWR.n0 12.8005
R38 VPWR.n5 VPWR.n4 12.8005
R39 VPWR.n4 VPWR.n1 9.3005
R40 VPWR.n6 VPWR.n5 9.3005
R41 VPWR.n7 VPWR.n0 9.3005
R42 VPWR.n4 VPWR.n3 6.4005
R43 VPWR.n10 VPWR.n9 6.00163
R44 VPWR.n9 VPWR.n7 0.319971
R45 VPWR.n7 VPWR.n6 0.063
R46 VPWR.n6 VPWR.n1 0.063
R47 VPWR.n2 VPWR.n1 0.063
R48 VPWR.n2 VPWR 0.03175
R49 A.n0 A.t1 300.447
R50 A.n0 A.t0 223.327
R51 A A.n0 158.4
R52 VPB.t2 VPB.t1 604.545
R53 VPB VPB.t2 302.274
R54 VPB.t1 VPB.t0 259.091
R55 VNB.t2 VNB.t0 2800
R56 VNB VNB.t2 1400
R57 VNB.t0 VNB.t1 1200
R58 pmos_n3f5_f1_l150_hvt_0.D0.t1 pmos_n3f5_f1_l150_hvt_0.D0.n3 237
R59 pmos_n3f5_f1_l150_hvt_0.D0 pmos_n3f5_f1_l150_hvt_0.D0.n3 6.4005
R60 pmos_n3f5_f1_l150_hvt_0.D0.n3 pmos_n3f5_f1_l150_hvt_0.D0.n0 22.4005
R61 pmos_n3f5_f1_l150_hvt_0.D0.n0 pmos_n3f5_f1_l150_hvt_0.D0.n2 249.15
R62 pmos_n3f5_f1_l150_hvt_0.D0.n2 pmos_n3f5_f1_l150_hvt_0.D0.n1 72.3005
R63 pmos_n3f5_f1_l150_hvt_0.D0.n2 pmos_n3f5_f1_l150_hvt_0.D0.t5 231.361
R64 pmos_n3f5_f1_l150_hvt_0.D0.n2 pmos_n3f5_f1_l150_hvt_0.D0.t3 187.981
R65 pmos_n3f5_f1_l150_hvt_0.D0.n1 pmos_n3f5_f1_l150_hvt_0.D0.t4 231.361
R66 pmos_n3f5_f1_l150_hvt_0.D0.n1 pmos_n3f5_f1_l150_hvt_0.D0.t2 187.981
R67 pmos_n3f5_f1_l150_hvt_0.D0.n0 pmos_n3f5_f1_l150_hvt_0.D0 22.4005
R68 pmos_n3f5_f1_l150_hvt_0.D0.t0 pmos_n3f5_f1_l150_hvt_0.D0 655.577
C15 VGND VNB 0.62487f
C16 X VNB 0.27318f
C17 VPWR VNB 0.45923f
C18 A VNB 0.25958f
C19 VPB VNB 0.8122f
C20 pmos_n3f5_f1_l150_hvt_0.D0 VNB 0.45957f
C21 pmos_n3f5_f1_l150_hvt_0.D0.t1 VNB 0.0447f
C22 pmos_n3f5_f1_l150_hvt_0.D0.t0 VNB 0.07039f
C23 pmos_n3f5_f1_l150_hvt_0.D0.n0 VNB 0.17065f
C24 pmos_n3f5_f1_l150_hvt_0.D0.t2 VNB 0.02028f
C25 pmos_n3f5_f1_l150_hvt_0.D0.t4 VNB 0.03415f
C26 pmos_n3f5_f1_l150_hvt_0.D0.n1 VNB 0.07193f
C27 pmos_n3f5_f1_l150_hvt_0.D0.t3 VNB 0.02028f
C28 pmos_n3f5_f1_l150_hvt_0.D0.t5 VNB 0.03415f
C29 pmos_n3f5_f1_l150_hvt_0.D0.n2 VNB 0.13692f
C30 pmos_n3f5_f1_l150_hvt_0.D0.n3 VNB 0.05477f
C31 VPB.t0 VNB 0.1453f
C32 VPB.t1 VNB 0.12108f
C33 VPB.t2 VNB 0.12713f
C34 A.t1 VNB 0.04573f
C35 A.t0 VNB 0.03012f
C36 A.n0 VNB 0.15258f
C37 VPWR.n0 VNB 0.01697f
C38 VPWR.n1 VNB 0.03395f
C39 VPWR.t2 VNB 0.02958f
C40 VPWR.n2 VNB 0.03065f
C41 VPWR.n3 VNB 0.05558f
C42 VPWR.n4 VNB 0.01273f
C43 VPWR.n5 VNB 0.01697f
C44 VPWR.n6 VNB 0.03395f
C45 VPWR.n7 VNB 0.16609f
C46 VPWR.t0 VNB 0.04879f
C47 VPWR.n8 VNB 0.03982f
C48 VPWR.n9 VNB 0.10811f
C49 VPWR.n10 VNB 0.04033f
C50 VPWR.t1 VNB 0.04879f
C51 VPWR.n11 VNB 0.03184f
C52 X.t0 VNB 0.03337f
C53 X.t1 VNB 0.03337f
C54 X.n0 VNB 0.07128f
C55 X.t3 VNB 0.01947f
C56 X.t2 VNB 0.01947f
C57 X.n1 VNB 0.03894f
C58 X.n2 VNB 0.04621f
C59 VGND.t2 VNB 0.01461f
C60 VGND.n0 VNB 0.00982f
C61 VGND.n1 VNB 0.12808f
C62 VGND.t0 VNB 0.02164f
C63 VGND.t1 VNB 0.02164f
C64 VGND.n2 VNB 0.07105f
C65 VGND.n3 VNB 0.02292f
C66 VGND.n4 VNB 0.01309f
C67 VGND.n5 VNB 0.01309f
C68 VGND.n6 VNB 0.02618f
C69 VGND.n7 VNB 0.02618f
C70 VGND.n8 VNB 0.02364f
C71 VGND.n9 VNB 0.01727f
.ends

.subckt sky130_efx_lvdig__buf_4 A X VGND VNB VPB VPWR
X0 nmos_n3f5_f1_l150_0.D0.t0 A.t1 VPWR.t0 VPB.t2 sky130_fd_pr__pfet_01v8_hvt ad=0.405 pd=2.91 as=0.405 ps=2.91 w=1.08 l=0.15
X1 VGND.t4 nmos_n3f5_f1_l150_0.D0.t2 X.t7 VNB.t4 sky130_fd_pr__nfet_01v8 ad=0.23625 pd=2.01 as=0.12285 ps=1.02 w=0.63 l=0.15
X2 X.t3 nmos_n3f5_f1_l150_0.D0.t3 VGND.t1 VNB.t1 sky130_fd_pr__nfet_01v8 ad=0.12285 pd=1.02 as=0.12285 ps=1.02 w=0.63 l=0.15
X3 nmos_n3f5_f1_l150_0.D0.t1 A.t0 VGND.t0 VNB.t0 sky130_fd_pr__nfet_01v8 ad=0.23625 pd=2.01 as=0.23625 ps=2.01 w=0.63 l=0.15
X4 X.t2 nmos_n3f5_f1_l150_0.D0.t9 VPWR.t3 VPB.t3 sky130_fd_pr__pfet_01v8_hvt ad=0.2106 pd=1.47 as=0.405 ps=2.91 w=1.08 l=0.15
X5 VPWR.t2 nmos_n3f5_f1_l150_0.D0.t8 X.t1 VPB.t1 sky130_fd_pr__pfet_01v8_hvt ad=0.2106 pd=1.47 as=0.2106 ps=1.47 w=1.08 l=0.15
X6 X.t4 nmos_n3f5_f1_l150_0.D0.t7 VPWR.t4 VPB.t4 sky130_fd_pr__pfet_01v8_hvt ad=0.2106 pd=1.47 as=0.2106 ps=1.47 w=1.08 l=0.15
X7 X.t5 nmos_n3f5_f1_l150_0.D0.t5 VGND.t2 VNB.t2 sky130_fd_pr__nfet_01v8 ad=0.12285 pd=1.02 as=0.23625 ps=2.01 w=0.63 l=0.15
X8 VGND.t3 nmos_n3f5_f1_l150_0.D0.t4 X.t6 VNB.t3 sky130_fd_pr__nfet_01v8 ad=0.12285 pd=1.02 as=0.12285 ps=1.02 w=0.63 l=0.15
X9 VPWR.t1 nmos_n3f5_f1_l150_0.D0.t6 X.t0 VPB.t0 sky130_fd_pr__pfet_01v8_hvt ad=0.405 pd=2.91 as=0.2106 ps=1.47 w=1.08 l=0.15
C0 nmos_n3f5_f1_l150_0.D0 VPWR 0.35976f
C1 VPB X 0.01594f
C2 VPWR VGND 0.0988f
C3 A VPWR 0.06591f
C4 VPB VPWR 0.18657f
C5 X VPWR 0.48984f
C6 nmos_n3f5_f1_l150_0.D0 VGND 0.27844f
C7 nmos_n3f5_f1_l150_0.D0 A 0.08133f
C8 A VGND 0.05517f
C9 VPB nmos_n3f5_f1_l150_0.D0 0.21827f
C10 nmos_n3f5_f1_l150_0.D0 X 0.24311f
C11 VPB VGND 0.01601f
C12 VPB A 0.05561f
C13 X VGND 0.34107f
R0 VGND VGND.t4 231.744
R1 VGND VGND.t2 231.744
R2 VGND VGND.t0 231.744
R3 VGND VGND.n4 194.601
R4 VGND.n4 VGND.t1 37.1434
R5 VGND.n4 VGND.t3 37.1434
R6 VGND.n16 VGND.n15 15.7005
R7 VGND.n3 VGND 14.3698
R8 VGND.n6 VGND.n5 12.8005
R9 VGND.n6 VGND.n2 12.8005
R10 VGND.n10 VGND.n2 12.8005
R11 VGND.n11 VGND.n10 12.8005
R12 VGND.n12 VGND.n11 12.8005
R13 VGND.n12 VGND.n0 12.8005
R14 VGND.n5 VGND 9.6005
R15 VGND.n10 VGND 9.6005
R16 VGND VGND.n16 9.6005
R17 VGND.n14 VGND.n0 9.3005
R18 VGND.n13 VGND.n12 9.3005
R19 VGND.n11 VGND.n1 9.3005
R20 VGND.n10 VGND.n9 9.3005
R21 VGND.n8 VGND.n2 9.3005
R22 VGND.n7 VGND.n6 9.3005
R23 VGND.n16 VGND.n0 6.4005
R24 VGND.n5 VGND.n3 6.00163
R25 VGND.n7 VGND.n3 0.319971
R26 VGND.n8 VGND.n7 0.063
R27 VGND.n9 VGND.n8 0.063
R28 VGND.n9 VGND.n1 0.063
R29 VGND.n13 VGND.n1 0.063
R30 VGND.n14 VGND.n13 0.063
R31 VGND.n15 VGND.n14 0.063
R32 VGND.n15 VGND 0.03175
R33 X X.n3 308.5
R34 X X.n0 308.5
R35 X.n5 X.n4 185
R36 X.n2 X.n1 185
R37 X.n7 X.n6 38.4005
R38 X.n4 X.t7 37.1434
R39 X.n4 X.t3 37.1434
R40 X.n1 X.t6 37.1434
R41 X.n1 X.t5 37.1434
R42 X.n3 X.t0 35.5699
R43 X.n3 X.t4 35.5699
R44 X.n0 X.t1 35.5699
R45 X.n0 X.t2 35.5699
R46 X.n6 X.n5 19.2005
R47 X.n7 X.n2 19.2005
R48 X.n6 X 9.6005
R49 X.n5 X 9.6005
R50 X X.n7 9.6005
R51 X.n2 X 9.6005
R52 X.n7 X 6.4005
R53 VPWR.n4 VPWR.t1 328.07
R54 VPWR.n2 VPWR.t3 328.07
R55 VPWR.n20 VPWR.t0 328.07
R56 VPWR.n7 VPWR.n6 292.5
R57 VPWR.n6 VPWR.t4 35.5699
R58 VPWR.n6 VPWR.t2 35.5699
R59 VPWR.n5 VPWR.n4 30.3698
R60 VPWR.n8 VPWR.n7 25.6005
R61 VPWR.n13 VPWR.n2 25.6005
R62 VPWR.n20 VPWR.n19 25.6005
R63 VPWR.n4 VPWR 16.0005
R64 VPWR.n7 VPWR 16.0005
R65 VPWR.n2 VPWR 16.0005
R66 VPWR VPWR.n20 16.0005
R67 VPWR.n19 VPWR.n18 15.7005
R68 VPWR.n9 VPWR.n8 12.8005
R69 VPWR.n9 VPWR.n3 12.8005
R70 VPWR.n13 VPWR.n3 12.8005
R71 VPWR.n14 VPWR.n13 12.8005
R72 VPWR.n15 VPWR.n14 12.8005
R73 VPWR.n15 VPWR.n0 12.8005
R74 VPWR.n17 VPWR.n0 9.3005
R75 VPWR.n16 VPWR.n15 9.3005
R76 VPWR.n14 VPWR.n1 9.3005
R77 VPWR.n13 VPWR.n12 9.3005
R78 VPWR.n11 VPWR.n3 9.3005
R79 VPWR.n10 VPWR.n9 9.3005
R80 VPWR.n19 VPWR.n0 6.4005
R81 VPWR.n8 VPWR.n5 6.00163
R82 VPWR.n10 VPWR.n5 0.319971
R83 VPWR.n11 VPWR.n10 0.063
R84 VPWR.n12 VPWR.n11 0.063
R85 VPWR.n12 VPWR.n1 0.063
R86 VPWR.n16 VPWR.n1 0.063
R87 VPWR.n17 VPWR.n16 0.063
R88 VPWR.n18 VPWR.n17 0.063
R89 VPWR.n18 VPWR 0.03175
R90 A.n0 A.t1 247.428
R91 A.n0 A.t0 204.048
R92 A A.n0 158.4
R93 VPB.t2 VPB.t3 604.545
R94 VPB VPB.t2 302.274
R95 VPB.t4 VPB.t0 259.091
R96 VPB.t1 VPB.t4 259.091
R97 VPB.t3 VPB.t1 259.091
R98 VNB.t0 VNB.t2 2800
R99 VNB VNB.t0 1400
R100 VNB.t1 VNB.t4 1200
R101 VNB.t3 VNB.t1 1200
R102 VNB.t2 VNB.t3 1200
R103 nmos_n3f5_f1_l150_0.D0.t1 nmos_n3f5_f1_l150_0.D0.n5 222.143
R104 nmos_n3f5_f1_l150_0.D0 nmos_n3f5_f1_l150_0.D0.n5 9.6005
R105 nmos_n3f5_f1_l150_0.D0.n5 nmos_n3f5_f1_l150_0.D0.n0 19.2005
R106 nmos_n3f5_f1_l150_0.D0.n0 nmos_n3f5_f1_l150_0.D0.n4 213.75
R107 nmos_n3f5_f1_l150_0.D0.n4 nmos_n3f5_f1_l150_0.D0.n3 72.3005
R108 nmos_n3f5_f1_l150_0.D0.n3 nmos_n3f5_f1_l150_0.D0.n2 72.3005
R109 nmos_n3f5_f1_l150_0.D0.n2 nmos_n3f5_f1_l150_0.D0.n1 72.3005
R110 nmos_n3f5_f1_l150_0.D0.n4 nmos_n3f5_f1_l150_0.D0.t9 231.361
R111 nmos_n3f5_f1_l150_0.D0.n4 nmos_n3f5_f1_l150_0.D0.t5 187.981
R112 nmos_n3f5_f1_l150_0.D0.n3 nmos_n3f5_f1_l150_0.D0.t8 231.361
R113 nmos_n3f5_f1_l150_0.D0.n3 nmos_n3f5_f1_l150_0.D0.t4 187.981
R114 nmos_n3f5_f1_l150_0.D0.n2 nmos_n3f5_f1_l150_0.D0.t7 231.361
R115 nmos_n3f5_f1_l150_0.D0.n2 nmos_n3f5_f1_l150_0.D0.t3 187.981
R116 nmos_n3f5_f1_l150_0.D0.n1 nmos_n3f5_f1_l150_0.D0.t6 231.361
R117 nmos_n3f5_f1_l150_0.D0.n1 nmos_n3f5_f1_l150_0.D0.t2 187.981
R118 nmos_n3f5_f1_l150_0.D0.n0 nmos_n3f5_f1_l150_0.D0 9.6005
R119 nmos_n3f5_f1_l150_0.D0.t0 nmos_n3f5_f1_l150_0.D0 344.07
C14 VGND VNB 0.79399f
C15 X VNB 0.35968f
C16 VPWR VNB 0.59098f
C17 A VNB 0.22047f
C18 VPB VNB 1.06234f
C19 nmos_n3f5_f1_l150_0.D0 VNB 0.61532f
C20 nmos_n3f5_f1_l150_0.D0.t1 VNB 0.0667f
C21 nmos_n3f5_f1_l150_0.D0.t0 VNB 0.12463f
C22 nmos_n3f5_f1_l150_0.D0.n0 VNB 0.17092f
C23 nmos_n3f5_f1_l150_0.D0.t2 VNB 0.02066f
C24 nmos_n3f5_f1_l150_0.D0.t6 VNB 0.0348f
C25 nmos_n3f5_f1_l150_0.D0.n1 VNB 0.07329f
C26 nmos_n3f5_f1_l150_0.D0.t3 VNB 0.02066f
C27 nmos_n3f5_f1_l150_0.D0.t7 VNB 0.0348f
C28 nmos_n3f5_f1_l150_0.D0.n2 VNB 0.09417f
C29 nmos_n3f5_f1_l150_0.D0.t4 VNB 0.02066f
C30 nmos_n3f5_f1_l150_0.D0.t8 VNB 0.0348f
C31 nmos_n3f5_f1_l150_0.D0.n3 VNB 0.09417f
C32 nmos_n3f5_f1_l150_0.D0.t5 VNB 0.02066f
C33 nmos_n3f5_f1_l150_0.D0.t9 VNB 0.0348f
C34 nmos_n3f5_f1_l150_0.D0.n4 VNB 0.11637f
C35 nmos_n3f5_f1_l150_0.D0.n5 VNB 0.05639f
C36 VPB.t0 VNB 0.1231f
C37 VPB.t4 VNB 0.06155f
C38 VPB.t1 VNB 0.06155f
C39 VPB.t3 VNB 0.10259f
C40 VPB.t2 VNB 0.10772f
C41 A.t1 VNB 0.04981f
C42 A.t0 VNB 0.03102f
C43 A.n0 VNB 0.12261f
C44 VPWR.n0 VNB 0.01438f
C45 VPWR.n1 VNB 0.03835f
C46 VPWR.t3 VNB 0.05512f
C47 VPWR.n2 VNB 0.03597f
C48 VPWR.n3 VNB 0.01918f
C49 VPWR.t1 VNB 0.05512f
C50 VPWR.n4 VNB 0.04498f
C51 VPWR.n5 VNB 0.12213f
C52 VPWR.t4 VNB 0.01558f
C53 VPWR.t2 VNB 0.01558f
C54 VPWR.n6 VNB 0.03116f
C55 VPWR.n7 VNB 0.03116f
C56 VPWR.n8 VNB 0.04556f
C57 VPWR.n9 VNB 0.01918f
C58 VPWR.n10 VNB 0.18763f
C59 VPWR.n11 VNB 0.03835f
C60 VPWR.n12 VNB 0.03835f
C61 VPWR.n13 VNB 0.03835f
C62 VPWR.n14 VNB 0.01918f
C63 VPWR.n15 VNB 0.01918f
C64 VPWR.n16 VNB 0.03835f
C65 VPWR.n17 VNB 0.03835f
C66 VPWR.n18 VNB 0.03463f
C67 VPWR.n19 VNB 0.03728f
C68 VPWR.t0 VNB 0.05512f
C69 VPWR.n20 VNB 0.03597f
C70 X.t1 VNB 0.03368f
C71 X.t2 VNB 0.03368f
C72 X.n0 VNB 0.07194f
C73 X.t6 VNB 0.01965f
C74 X.t5 VNB 0.01965f
C75 X.n1 VNB 0.0393f
C76 X.n2 VNB 0.04664f
C77 X.t0 VNB 0.03368f
C78 X.t4 VNB 0.03368f
C79 X.n3 VNB 0.07194f
C80 X.t7 VNB 0.01965f
C81 X.t3 VNB 0.01965f
C82 X.n4 VNB 0.0393f
C83 X.n5 VNB 0.04664f
C84 X.n6 VNB 0.12955f
C85 X.n7 VNB 0.11919f
C86 VGND.t0 VNB 0.02493f
C87 VGND.n0 VNB 0.01131f
C88 VGND.n1 VNB 0.03015f
C89 VGND.t2 VNB 0.02493f
C90 VGND.n2 VNB 0.01508f
C91 VGND.t4 VNB 0.02493f
C92 VGND.n3 VNB 0.08184f
C93 VGND.t1 VNB 0.00715f
C94 VGND.t3 VNB 0.00715f
C95 VGND.n4 VNB 0.01513f
C96 VGND.n5 VNB 0.0264f
C97 VGND.n6 VNB 0.01508f
C98 VGND.n7 VNB 0.14752f
C99 VGND.n8 VNB 0.03015f
C100 VGND.n9 VNB 0.03015f
C101 VGND.n10 VNB 0.02073f
C102 VGND.n11 VNB 0.01508f
C103 VGND.n12 VNB 0.01508f
C104 VGND.n13 VNB 0.03015f
C105 VGND.n14 VNB 0.03015f
C106 VGND.n15 VNB 0.02722f
C107 VGND.n16 VNB 0.01989f
.ends

.subckt sky130_efx_lvdig__clkbuf_1 A X VGND VNB VPB VPWR
X0 pmos_n4f5_f1_l150_hvt_0.D0.t0 A.t1 VPWR.t0 VPB.t0 sky130_fd_pr__pfet_01v8_hvt ad=0.30375 pd=2.37 as=0.30375 ps=2.37 w=0.81 l=0.15
X1 X.t1 pmos_n4f5_f1_l150_hvt_0.D0.t3 VPWR.t1 VPB.t1 sky130_fd_pr__pfet_01v8_hvt ad=0.30375 pd=2.37 as=0.30375 ps=2.37 w=0.81 l=0.15
X2 pmos_n4f5_f1_l150_hvt_0.D0.t1 A.t0 VGND.t1 VNB.t1 sky130_fd_pr__nfet_01v8 ad=0.2025 pd=1.83 as=0.2025 ps=1.83 w=0.54 l=0.15
X3 X.t0 pmos_n4f5_f1_l150_hvt_0.D0.t2 VGND.t0 VNB.t0 sky130_fd_pr__nfet_01v8 ad=0.2025 pd=1.83 as=0.2025 ps=1.83 w=0.54 l=0.15
C0 A VPB 0.08142f
C1 VPWR VGND 0.05022f
C2 pmos_n4f5_f1_l150_hvt_0.D0 VPB 0.11187f
C3 X VGND 0.09485f
C4 A VPWR 0.04838f
C5 pmos_n4f5_f1_l150_hvt_0.D0 VPWR 0.21283f
C6 X pmos_n4f5_f1_l150_hvt_0.D0 0.08363f
C7 A VGND 0.04989f
C8 pmos_n4f5_f1_l150_hvt_0.D0 VGND 0.18132f
C9 A pmos_n4f5_f1_l150_hvt_0.D0 0.09073f
C10 VPWR VPB 0.1192f
C11 X VPB 0.01701f
C12 VPB VGND 0.01225f
C13 X VPWR 0.11669f
R0 VGND VGND.t0 234.733
R1 VGND VGND.t1 234.733
R2 VGND VGND.n0 16.4553
R3 VGND.n0 VGND 14.3674
R4 VGND.n0 VGND 0.204961
R5 X X.t1 352.726
R6 X.n0 X.t0 228.333
R7 X X.n0 22.4005
R8 X.n0 X 6.4005
R9 VPWR.n0 VPWR.t0 369.182
R10 VPWR.n0 VPWR.t1 367.094
R11 VPWR VPWR.n0 0.204961
R12 A.n0 A.t1 281.168
R13 A.n0 A.t0 208.868
R14 A A.n0 158.4
R15 VPB.t0 VPB.t1 604.545
R16 VPB VPB.t0 302.274
R17 VNB.t1 VNB.t0 2800
R18 VNB VNB.t1 1400
R19 pmos_n4f5_f1_l150_hvt_0.D0.t1 pmos_n4f5_f1_l150_hvt_0.D0.n2 228.333
R20 pmos_n4f5_f1_l150_hvt_0.D0 pmos_n4f5_f1_l150_hvt_0.D0.n2 6.4005
R21 pmos_n4f5_f1_l150_hvt_0.D0.n2 pmos_n4f5_f1_l150_hvt_0.D0.n0 22.4005
R22 pmos_n4f5_f1_l150_hvt_0.D0.n0 pmos_n4f5_f1_l150_hvt_0.D0.n1 177.601
R23 pmos_n4f5_f1_l150_hvt_0.D0.n1 pmos_n4f5_f1_l150_hvt_0.D0.t2 208.868
R24 pmos_n4f5_f1_l150_hvt_0.D0.n1 pmos_n4f5_f1_l150_hvt_0.D0.t3 281.168
R25 pmos_n4f5_f1_l150_hvt_0.D0.n0 pmos_n4f5_f1_l150_hvt_0.D0 16.0005
R26 pmos_n4f5_f1_l150_hvt_0.D0.t0 pmos_n4f5_f1_l150_hvt_0.D0 352.726
C14 VGND VNB 0.63866f
C15 X VNB 0.28643f
C16 VPWR VNB 0.50979f
C17 A VNB 0.24008f
C18 VPB VNB 0.64147f
C19 pmos_n4f5_f1_l150_hvt_0.D0 VNB 0.37107f
C20 pmos_n4f5_f1_l150_hvt_0.D0.t1 VNB 0.05514f
C21 pmos_n4f5_f1_l150_hvt_0.D0.t0 VNB 0.08925f
C22 pmos_n4f5_f1_l150_hvt_0.D0.n0 VNB 0.17586f
C23 pmos_n4f5_f1_l150_hvt_0.D0.t3 VNB 0.03274f
C24 pmos_n4f5_f1_l150_hvt_0.D0.t2 VNB 0.02141f
C25 pmos_n4f5_f1_l150_hvt_0.D0.n1 VNB 0.10525f
C26 pmos_n4f5_f1_l150_hvt_0.D0.n2 VNB 0.05519f
C27 VPB.t1 VNB 0.17087f
C28 VPB.t0 VNB 0.12815f
C29 A.t1 VNB 0.04621f
C30 A.t0 VNB 0.03023f
C31 A.n0 VNB 0.13779f
C32 VPWR.t1 VNB 0.04036f
C33 VPWR.t0 VNB 0.0406f
C34 VPWR.n0 VNB 0.28519f
C35 X.t1 VNB 0.06223f
C36 X.t0 VNB 0.03844f
C37 X.n0 VNB 0.03848f
C38 VGND.t1 VNB 0.01901f
C39 VGND.t0 VNB 0.01901f
C40 VGND.n0 VNB 0.13481f
.ends

.subckt sky130_efx_lvdig__clkbuf_2 A X VGND VNB VPB VPWR
X0 pmos_n6_f1_l150_hvt_0.D0.t0 A.t1 VPWR.t2 VPB.t2 sky130_fd_pr__pfet_01v8_hvt ad=0.405 pd=2.91 as=0.405 ps=2.91 w=1.08 l=0.15
X1 pmos_n6_f1_l150_hvt_0.D0.t1 A.t0 VGND.t0 VNB.t2 sky130_fd_pr__nfet_01v8 ad=0.16875 pd=1.65 as=0.16875 ps=1.65 w=0.45 l=0.15
X2 X.t0 pmos_n6_f1_l150_hvt_0.D0.t5 VPWR.t0 VPB.t0 sky130_fd_pr__pfet_01v8_hvt ad=0.2106 pd=1.47 as=0.405 ps=2.91 w=1.08 l=0.15
X3 VPWR.t1 pmos_n6_f1_l150_hvt_0.D0.t4 X.t1 VPB.t1 sky130_fd_pr__pfet_01v8_hvt ad=0.405 pd=2.91 as=0.2106 ps=1.47 w=1.08 l=0.15
X4 X.t2 pmos_n6_f1_l150_hvt_0.D0.t3 VGND.t1 VNB.t0 sky130_fd_pr__nfet_01v8 ad=0.08775 pd=0.84 as=0.16875 ps=1.65 w=0.45 l=0.15
X5 VGND.t2 pmos_n6_f1_l150_hvt_0.D0.t2 X.t3 VNB.t1 sky130_fd_pr__nfet_01v8 ad=0.16875 pd=1.65 as=0.08775 ps=0.84 w=0.45 l=0.15
C0 VPB VGND 0.01523f
C1 VPB X 0.00808f
C2 VPB VPWR 0.15293f
C3 VPB A 0.05561f
C4 VGND X 0.12436f
C5 VGND VPWR 0.07646f
C6 VGND A 0.04557f
C7 VPB pmos_n6_f1_l150_hvt_0.D0 0.12607f
C8 VPWR X 0.22621f
C9 VPWR A 0.06598f
C10 VGND pmos_n6_f1_l150_hvt_0.D0 0.19144f
C11 pmos_n6_f1_l150_hvt_0.D0 X 0.12829f
C12 VPWR pmos_n6_f1_l150_hvt_0.D0 0.2974f
C13 pmos_n6_f1_l150_hvt_0.D0 A 0.08603f
R0 VGND VGND.t2 243.4
R1 VGND VGND.t1 243.4
R2 VGND VGND.t0 243.4
R3 VGND.n9 VGND.n8 15.7005
R4 VGND.n2 VGND 14.3698
R5 VGND.n4 VGND.n3 12.8005
R6 VGND.n5 VGND.n4 12.8005
R7 VGND.n5 VGND.n0 12.8005
R8 VGND.n3 VGND 9.6005
R9 VGND VGND.n9 9.6005
R10 VGND.n7 VGND.n0 9.3005
R11 VGND.n6 VGND.n5 9.3005
R12 VGND.n4 VGND.n1 9.3005
R13 VGND.n9 VGND.n0 6.4005
R14 VGND.n3 VGND.n2 6.00163
R15 VGND.n2 VGND.n1 0.319971
R16 VGND.n6 VGND.n1 0.063
R17 VGND.n7 VGND.n6 0.063
R18 VGND.n8 VGND.n7 0.063
R19 VGND.n8 VGND 0.03175
R20 X X.n0 308.5
R21 X.n2 X.n1 185
R22 X.n1 X.t3 52.0005
R23 X.n1 X.t2 52.0005
R24 X.n0 X.t1 35.5699
R25 X.n0 X.t0 35.5699
R26 X X.n2 22.4005
R27 X.n2 X 6.4005
R28 VPWR.n3 VPWR.t1 328.07
R29 VPWR.n2 VPWR.t0 328.07
R30 VPWR.n12 VPWR.t2 328.07
R31 VPWR.n4 VPWR.n3 30.3698
R32 VPWR.n5 VPWR.n2 25.6005
R33 VPWR.n12 VPWR.n11 25.6005
R34 VPWR.n3 VPWR 16.0005
R35 VPWR.n2 VPWR 16.0005
R36 VPWR VPWR.n12 16.0005
R37 VPWR.n11 VPWR.n10 15.7005
R38 VPWR.n6 VPWR.n5 12.8005
R39 VPWR.n7 VPWR.n6 12.8005
R40 VPWR.n7 VPWR.n0 12.8005
R41 VPWR.n9 VPWR.n0 9.3005
R42 VPWR.n8 VPWR.n7 9.3005
R43 VPWR.n6 VPWR.n1 9.3005
R44 VPWR.n11 VPWR.n0 6.4005
R45 VPWR.n5 VPWR.n4 6.00163
R46 VPWR.n4 VPWR.n1 0.319971
R47 VPWR.n8 VPWR.n1 0.063
R48 VPWR.n9 VPWR.n8 0.063
R49 VPWR.n10 VPWR.n9 0.063
R50 VPWR.n10 VPWR 0.03175
R51 A.n0 A.t1 247.428
R52 A.n0 A.t0 223.327
R53 A A.n0 158.4
R54 VPB.t2 VPB.t0 604.545
R55 VPB VPB.t2 302.274
R56 VPB.t0 VPB.t1 259.091
R57 VNB.t2 VNB.t0 2800
R58 VNB VNB.t2 1400
R59 VNB.t0 VNB.t1 1200
R60 pmos_n6_f1_l150_hvt_0.D0.t1 pmos_n6_f1_l150_hvt_0.D0.n3 237
R61 pmos_n6_f1_l150_hvt_0.D0 pmos_n6_f1_l150_hvt_0.D0.n3 6.4005
R62 pmos_n6_f1_l150_hvt_0.D0.n3 pmos_n6_f1_l150_hvt_0.D0.n0 22.4005
R63 pmos_n6_f1_l150_hvt_0.D0.n0 pmos_n6_f1_l150_hvt_0.D0.n2 213.75
R64 pmos_n6_f1_l150_hvt_0.D0.n2 pmos_n6_f1_l150_hvt_0.D0.n1 72.3005
R65 pmos_n6_f1_l150_hvt_0.D0.n2 pmos_n6_f1_l150_hvt_0.D0.t5 231.361
R66 pmos_n6_f1_l150_hvt_0.D0.n2 pmos_n6_f1_l150_hvt_0.D0.t3 207.261
R67 pmos_n6_f1_l150_hvt_0.D0.n1 pmos_n6_f1_l150_hvt_0.D0.t4 231.361
R68 pmos_n6_f1_l150_hvt_0.D0.n1 pmos_n6_f1_l150_hvt_0.D0.t2 207.261
R69 pmos_n6_f1_l150_hvt_0.D0.n0 pmos_n6_f1_l150_hvt_0.D0 9.6005
R70 pmos_n6_f1_l150_hvt_0.D0.t0 pmos_n6_f1_l150_hvt_0.D0 344.07
C14 VGND VNB 0.6057f
C15 X VNB 0.28952f
C16 VPWR VNB 0.4908f
C17 A VNB 0.24086f
C18 VPB VNB 0.80462f
C19 pmos_n6_f1_l150_hvt_0.D0 VNB 0.47459f
C20 pmos_n6_f1_l150_hvt_0.D0.t1 VNB 0.04374f
C21 pmos_n6_f1_l150_hvt_0.D0.t0 VNB 0.1197f
C22 pmos_n6_f1_l150_hvt_0.D0.n0 VNB 0.16917f
C23 pmos_n6_f1_l150_hvt_0.D0.t2 VNB 0.01741f
C24 pmos_n6_f1_l150_hvt_0.D0.t4 VNB 0.03342f
C25 pmos_n6_f1_l150_hvt_0.D0.n1 VNB 0.07449f
C26 pmos_n6_f1_l150_hvt_0.D0.t3 VNB 0.01741f
C27 pmos_n6_f1_l150_hvt_0.D0.t5 VNB 0.03342f
C28 pmos_n6_f1_l150_hvt_0.D0.n2 VNB 0.11586f
C29 pmos_n6_f1_l150_hvt_0.D0.n3 VNB 0.05359f
C30 VPB.t1 VNB 0.11931f
C31 VPB.t0 VNB 0.09942f
C32 VPB.t2 VNB 0.10439f
C33 A.t1 VNB 0.04843f
C34 A.t0 VNB 0.02698f
C35 A.n0 VNB 0.12469f
C36 VPWR.n0 VNB 0.0131f
C37 VPWR.n1 VNB 0.17096f
C38 VPWR.t0 VNB 0.05022f
C39 VPWR.n2 VNB 0.03277f
C40 VPWR.t1 VNB 0.05022f
C41 VPWR.n3 VNB 0.04098f
C42 VPWR.n4 VNB 0.11128f
C43 VPWR.n5 VNB 0.04151f
C44 VPWR.n6 VNB 0.01747f
C45 VPWR.n7 VNB 0.01747f
C46 VPWR.n8 VNB 0.03494f
C47 VPWR.n9 VNB 0.03494f
C48 VPWR.n10 VNB 0.03155f
C49 VPWR.n11 VNB 0.03397f
C50 VPWR.t2 VNB 0.05022f
C51 VPWR.n12 VNB 0.03277f
C52 X.t1 VNB 0.0341f
C53 X.t0 VNB 0.0341f
C54 X.n0 VNB 0.07281f
C55 X.t3 VNB 0.01421f
C56 X.t2 VNB 0.01421f
C57 X.n1 VNB 0.02841f
C58 X.n2 VNB 0.04721f
C59 VGND.t0 VNB 0.01398f
C60 VGND.n0 VNB 0.0094f
C61 VGND.n1 VNB 0.12261f
C62 VGND.t1 VNB 0.01398f
C63 VGND.t2 VNB 0.01398f
C64 VGND.n2 VNB 0.06802f
C65 VGND.n3 VNB 0.02194f
C66 VGND.n4 VNB 0.01253f
C67 VGND.n5 VNB 0.01253f
C68 VGND.n6 VNB 0.02506f
C69 VGND.n7 VNB 0.02506f
C70 VGND.n8 VNB 0.02263f
C71 VGND.n9 VNB 0.01653f
.ends

.subckt sky130_efx_lvdig__clkbuf_4 A X VGND VNB VPB VPWR
X0 nmos_n2f5_f1_l150_0.D0.t0 A.t1 VPWR.t0 VPB.t2 sky130_fd_pr__pfet_01v8_hvt ad=0.405 pd=2.91 as=0.405 ps=2.91 w=1.08 l=0.15
X1 VGND.t4 nmos_n2f5_f1_l150_0.D0.t2 X.t7 VNB.t4 sky130_fd_pr__nfet_01v8 ad=0.16875 pd=1.65 as=0.08775 ps=0.84 w=0.45 l=0.15
X2 X.t3 nmos_n2f5_f1_l150_0.D0.t3 VGND.t1 VNB.t1 sky130_fd_pr__nfet_01v8 ad=0.08775 pd=0.84 as=0.08775 ps=0.84 w=0.45 l=0.15
X3 nmos_n2f5_f1_l150_0.D0.t1 A.t0 VGND.t0 VNB.t0 sky130_fd_pr__nfet_01v8 ad=0.16875 pd=1.65 as=0.16875 ps=1.65 w=0.45 l=0.15
X4 X.t2 nmos_n2f5_f1_l150_0.D0.t9 VPWR.t3 VPB.t3 sky130_fd_pr__pfet_01v8_hvt ad=0.2106 pd=1.47 as=0.405 ps=2.91 w=1.08 l=0.15
X5 VPWR.t2 nmos_n2f5_f1_l150_0.D0.t8 X.t1 VPB.t1 sky130_fd_pr__pfet_01v8_hvt ad=0.2106 pd=1.47 as=0.2106 ps=1.47 w=1.08 l=0.15
X6 X.t4 nmos_n2f5_f1_l150_0.D0.t7 VPWR.t4 VPB.t4 sky130_fd_pr__pfet_01v8_hvt ad=0.2106 pd=1.47 as=0.2106 ps=1.47 w=1.08 l=0.15
X7 X.t5 nmos_n2f5_f1_l150_0.D0.t5 VGND.t2 VNB.t2 sky130_fd_pr__nfet_01v8 ad=0.08775 pd=0.84 as=0.16875 ps=1.65 w=0.45 l=0.15
X8 VGND.t3 nmos_n2f5_f1_l150_0.D0.t4 X.t6 VNB.t3 sky130_fd_pr__nfet_01v8 ad=0.08775 pd=0.84 as=0.08775 ps=0.84 w=0.45 l=0.15
X9 VPWR.t1 nmos_n2f5_f1_l150_0.D0.t6 X.t0 VPB.t0 sky130_fd_pr__pfet_01v8_hvt ad=0.405 pd=2.91 as=0.2106 ps=1.47 w=1.08 l=0.15
C0 nmos_n2f5_f1_l150_0.D0 VPWR 0.35995f
C1 VPB X 0.01594f
C2 VPWR VGND 0.09609f
C3 A VPWR 0.06598f
C4 VPB VPWR 0.18657f
C5 X VPWR 0.48974f
C6 nmos_n2f5_f1_l150_0.D0 VGND 0.23943f
C7 nmos_n2f5_f1_l150_0.D0 A 0.08603f
C8 A VGND 0.04557f
C9 VPB nmos_n2f5_f1_l150_0.D0 0.21827f
C10 nmos_n2f5_f1_l150_0.D0 X 0.258f
C11 VPB VGND 0.0159f
C12 VPB A 0.05561f
C13 X VGND 0.27569f
R0 VGND VGND.t4 243.4
R1 VGND VGND.t2 243.4
R2 VGND VGND.t0 243.4
R3 VGND VGND.n4 191.4
R4 VGND.n4 VGND.t1 52.0005
R5 VGND.n4 VGND.t3 52.0005
R6 VGND.n16 VGND.n15 15.7005
R7 VGND.n3 VGND 14.3698
R8 VGND.n6 VGND.n5 12.8005
R9 VGND.n6 VGND.n2 12.8005
R10 VGND.n10 VGND.n2 12.8005
R11 VGND.n11 VGND.n10 12.8005
R12 VGND.n12 VGND.n11 12.8005
R13 VGND.n12 VGND.n0 12.8005
R14 VGND.n5 VGND 9.6005
R15 VGND.n10 VGND 9.6005
R16 VGND VGND.n16 9.6005
R17 VGND.n14 VGND.n0 9.3005
R18 VGND.n13 VGND.n12 9.3005
R19 VGND.n11 VGND.n1 9.3005
R20 VGND.n10 VGND.n9 9.3005
R21 VGND.n8 VGND.n2 9.3005
R22 VGND.n7 VGND.n6 9.3005
R23 VGND.n16 VGND.n0 6.4005
R24 VGND.n5 VGND.n3 6.00163
R25 VGND.n7 VGND.n3 0.319971
R26 VGND.n8 VGND.n7 0.063
R27 VGND.n9 VGND.n8 0.063
R28 VGND.n9 VGND.n1 0.063
R29 VGND.n13 VGND.n1 0.063
R30 VGND.n14 VGND.n13 0.063
R31 VGND.n15 VGND.n14 0.063
R32 VGND.n15 VGND 0.03175
R33 X X.n3 308.5
R34 X X.n0 308.5
R35 X.n5 X.n4 185
R36 X.n2 X.n1 185
R37 X.n4 X.t7 52.0005
R38 X.n4 X.t3 52.0005
R39 X.n1 X.t6 52.0005
R40 X.n1 X.t5 52.0005
R41 X.n7 X.n6 38.4005
R42 X.n3 X.t0 35.5699
R43 X.n3 X.t4 35.5699
R44 X.n0 X.t1 35.5699
R45 X.n0 X.t2 35.5699
R46 X.n6 X.n5 22.4005
R47 X.n7 X.n2 22.4005
R48 X.n6 X 9.6005
R49 X X.n7 9.6005
R50 X.n5 X 6.4005
R51 X.n2 X 6.4005
R52 X.n7 X 6.4005
R53 VPWR.n4 VPWR.t1 328.07
R54 VPWR.n2 VPWR.t3 328.07
R55 VPWR.n20 VPWR.t0 328.07
R56 VPWR.n7 VPWR.n6 292.5
R57 VPWR.n6 VPWR.t4 35.5699
R58 VPWR.n6 VPWR.t2 35.5699
R59 VPWR.n5 VPWR.n4 30.3698
R60 VPWR.n8 VPWR.n7 25.6005
R61 VPWR.n13 VPWR.n2 25.6005
R62 VPWR.n20 VPWR.n19 25.6005
R63 VPWR.n4 VPWR 16.0005
R64 VPWR.n7 VPWR 16.0005
R65 VPWR.n2 VPWR 16.0005
R66 VPWR VPWR.n20 16.0005
R67 VPWR.n19 VPWR.n18 15.7005
R68 VPWR.n9 VPWR.n8 12.8005
R69 VPWR.n9 VPWR.n3 12.8005
R70 VPWR.n13 VPWR.n3 12.8005
R71 VPWR.n14 VPWR.n13 12.8005
R72 VPWR.n15 VPWR.n14 12.8005
R73 VPWR.n15 VPWR.n0 12.8005
R74 VPWR.n17 VPWR.n0 9.3005
R75 VPWR.n16 VPWR.n15 9.3005
R76 VPWR.n14 VPWR.n1 9.3005
R77 VPWR.n13 VPWR.n12 9.3005
R78 VPWR.n11 VPWR.n3 9.3005
R79 VPWR.n10 VPWR.n9 9.3005
R80 VPWR.n19 VPWR.n0 6.4005
R81 VPWR.n8 VPWR.n5 6.00163
R82 VPWR.n10 VPWR.n5 0.319971
R83 VPWR.n11 VPWR.n10 0.063
R84 VPWR.n12 VPWR.n11 0.063
R85 VPWR.n12 VPWR.n1 0.063
R86 VPWR.n16 VPWR.n1 0.063
R87 VPWR.n17 VPWR.n16 0.063
R88 VPWR.n18 VPWR.n17 0.063
R89 VPWR.n18 VPWR 0.03175
R90 A.n0 A.t1 247.428
R91 A.n0 A.t0 223.327
R92 A A.n0 158.4
R93 VPB.t2 VPB.t3 604.545
R94 VPB VPB.t2 302.274
R95 VPB.t4 VPB.t0 259.091
R96 VPB.t1 VPB.t4 259.091
R97 VPB.t3 VPB.t1 259.091
R98 VNB.t0 VNB.t2 2800
R99 VNB VNB.t0 1400
R100 VNB.t1 VNB.t4 1200
R101 VNB.t3 VNB.t1 1200
R102 VNB.t2 VNB.t3 1200
R103 nmos_n2f5_f1_l150_0.D0.t1 nmos_n2f5_f1_l150_0.D0.n5 237
R104 nmos_n2f5_f1_l150_0.D0 nmos_n2f5_f1_l150_0.D0.n5 6.4005
R105 nmos_n2f5_f1_l150_0.D0.n5 nmos_n2f5_f1_l150_0.D0.n0 22.4005
R106 nmos_n2f5_f1_l150_0.D0.n0 nmos_n2f5_f1_l150_0.D0.n4 213.75
R107 nmos_n2f5_f1_l150_0.D0.n4 nmos_n2f5_f1_l150_0.D0.n3 72.3005
R108 nmos_n2f5_f1_l150_0.D0.n3 nmos_n2f5_f1_l150_0.D0.n2 72.3005
R109 nmos_n2f5_f1_l150_0.D0.n2 nmos_n2f5_f1_l150_0.D0.n1 72.3005
R110 nmos_n2f5_f1_l150_0.D0.n4 nmos_n2f5_f1_l150_0.D0.t9 231.361
R111 nmos_n2f5_f1_l150_0.D0.n4 nmos_n2f5_f1_l150_0.D0.t5 207.261
R112 nmos_n2f5_f1_l150_0.D0.n3 nmos_n2f5_f1_l150_0.D0.t8 231.361
R113 nmos_n2f5_f1_l150_0.D0.n3 nmos_n2f5_f1_l150_0.D0.t4 207.261
R114 nmos_n2f5_f1_l150_0.D0.n2 nmos_n2f5_f1_l150_0.D0.t7 231.361
R115 nmos_n2f5_f1_l150_0.D0.n2 nmos_n2f5_f1_l150_0.D0.t3 207.261
R116 nmos_n2f5_f1_l150_0.D0.n1 nmos_n2f5_f1_l150_0.D0.t6 231.361
R117 nmos_n2f5_f1_l150_0.D0.n1 nmos_n2f5_f1_l150_0.D0.t2 207.261
R118 nmos_n2f5_f1_l150_0.D0.n0 nmos_n2f5_f1_l150_0.D0 9.6005
R119 nmos_n2f5_f1_l150_0.D0.t0 nmos_n2f5_f1_l150_0.D0 344.07
C14 VGND VNB 0.75179f
C15 X VNB 0.36475f
C16 VPWR VNB 0.59333f
C17 A VNB 0.24086f
C18 VPB VNB 1.06233f
C19 nmos_n2f5_f1_l150_0.D0 VNB 0.67667f
C20 nmos_n2f5_f1_l150_0.D0.t1 VNB 0.04537f
C21 nmos_n2f5_f1_l150_0.D0.t0 VNB 0.12416f
C22 nmos_n2f5_f1_l150_0.D0.n0 VNB 0.17547f
C23 nmos_n2f5_f1_l150_0.D0.t2 VNB 0.01806f
C24 nmos_n2f5_f1_l150_0.D0.t6 VNB 0.03466f
C25 nmos_n2f5_f1_l150_0.D0.n1 VNB 0.07726f
C26 nmos_n2f5_f1_l150_0.D0.t3 VNB 0.01806f
C27 nmos_n2f5_f1_l150_0.D0.t7 VNB 0.03466f
C28 nmos_n2f5_f1_l150_0.D0.n2 VNB 0.09806f
C29 nmos_n2f5_f1_l150_0.D0.t4 VNB 0.01806f
C30 nmos_n2f5_f1_l150_0.D0.t8 VNB 0.03466f
C31 nmos_n2f5_f1_l150_0.D0.n3 VNB 0.09806f
C32 nmos_n2f5_f1_l150_0.D0.t5 VNB 0.01806f
C33 nmos_n2f5_f1_l150_0.D0.t9 VNB 0.03466f
C34 nmos_n2f5_f1_l150_0.D0.n4 VNB 0.12018f
C35 nmos_n2f5_f1_l150_0.D0.n5 VNB 0.05559f
C36 VPB.t0 VNB 0.12308f
C37 VPB.t4 VNB 0.06154f
C38 VPB.t1 VNB 0.06154f
C39 VPB.t3 VNB 0.10256f
C40 VPB.t2 VNB 0.10769f
C41 A.t1 VNB 0.04843f
C42 A.t0 VNB 0.02698f
C43 A.n0 VNB 0.12469f
C44 VPWR.n0 VNB 0.01435f
C45 VPWR.n1 VNB 0.03827f
C46 VPWR.t3 VNB 0.055f
C47 VPWR.n2 VNB 0.03589f
C48 VPWR.n3 VNB 0.01914f
C49 VPWR.t1 VNB 0.055f
C50 VPWR.n4 VNB 0.04489f
C51 VPWR.n5 VNB 0.12187f
C52 VPWR.t4 VNB 0.01555f
C53 VPWR.t2 VNB 0.01555f
C54 VPWR.n6 VNB 0.03109f
C55 VPWR.n7 VNB 0.03109f
C56 VPWR.n8 VNB 0.04546f
C57 VPWR.n9 VNB 0.01914f
C58 VPWR.n10 VNB 0.18724f
C59 VPWR.n11 VNB 0.03827f
C60 VPWR.n12 VNB 0.03827f
C61 VPWR.n13 VNB 0.03827f
C62 VPWR.n14 VNB 0.01914f
C63 VPWR.n15 VNB 0.01914f
C64 VPWR.n16 VNB 0.03827f
C65 VPWR.n17 VNB 0.03827f
C66 VPWR.n18 VNB 0.03455f
C67 VPWR.n19 VNB 0.0372f
C68 VPWR.t0 VNB 0.055f
C69 VPWR.n20 VNB 0.03589f
C70 X.t1 VNB 0.0335f
C71 X.t2 VNB 0.0335f
C72 X.n0 VNB 0.07154f
C73 X.t6 VNB 0.01396f
C74 X.t5 VNB 0.01396f
C75 X.n1 VNB 0.02792f
C76 X.n2 VNB 0.04639f
C77 X.t0 VNB 0.0335f
C78 X.t4 VNB 0.0335f
C79 X.n3 VNB 0.07154f
C80 X.t7 VNB 0.01396f
C81 X.t3 VNB 0.01396f
C82 X.n4 VNB 0.02792f
C83 X.n5 VNB 0.04639f
C84 X.n6 VNB 0.134f
C85 X.n7 VNB 0.12369f
C86 VGND.t0 VNB 0.01555f
C87 VGND.n0 VNB 0.01045f
C88 VGND.n1 VNB 0.02788f
C89 VGND.t2 VNB 0.01555f
C90 VGND.n2 VNB 0.01394f
C91 VGND.t4 VNB 0.01555f
C92 VGND.n3 VNB 0.07566f
C93 VGND.t1 VNB 0.00472f
C94 VGND.t3 VNB 0.00472f
C95 VGND.n4 VNB 0.00979f
C96 VGND.n5 VNB 0.02441f
C97 VGND.n6 VNB 0.01394f
C98 VGND.n7 VNB 0.13639f
C99 VGND.n8 VNB 0.02788f
C100 VGND.n9 VNB 0.02788f
C101 VGND.n10 VNB 0.01917f
C102 VGND.n11 VNB 0.01394f
C103 VGND.n12 VNB 0.01394f
C104 VGND.n13 VNB 0.02788f
C105 VGND.n14 VNB 0.02788f
C106 VGND.n15 VNB 0.02517f
C107 VGND.n16 VNB 0.01839f
.ends

.subckt sky130_efx_lvdig__clkbuf_8 A X VGND VNB VPB VPWR
X0 VPWR.t0 nmos_n2f5_f1_l150_0.D0.t16 X.t3 VPB.t0 sky130_fd_pr__pfet_01v8_hvt ad=0.2106 pd=1.47 as=0.2106 ps=1.47 w=1.08 l=0.15
X1 VGND.t8 A.t0 nmos_n2f5_f1_l150_0.D0.t1 VNB.t4 sky130_fd_pr__nfet_01v8 ad=0.16875 pd=1.65 as=0.08775 ps=0.84 w=0.45 l=0.15
X2 nmos_n2f5_f1_l150_0.D0.t2 A.t3 VPWR.t8 VPB.t4 sky130_fd_pr__pfet_01v8_hvt ad=0.2106 pd=1.47 as=0.405 ps=2.91 w=1.08 l=0.15
X3 VGND.t7 nmos_n2f5_f1_l150_0.D0.t6 X.t15 VNB.t9 sky130_fd_pr__nfet_01v8 ad=0.08775 pd=0.84 as=0.08775 ps=0.84 w=0.45 l=0.15
X4 VPWR.t9 A.t2 nmos_n2f5_f1_l150_0.D0.t3 VPB.t5 sky130_fd_pr__pfet_01v8_hvt ad=0.405 pd=2.91 as=0.2106 ps=1.47 w=1.08 l=0.15
X5 X.t7 nmos_n2f5_f1_l150_0.D0.t7 VGND.t3 VNB.t5 sky130_fd_pr__nfet_01v8 ad=0.08775 pd=0.84 as=0.08775 ps=0.84 w=0.45 l=0.15
X6 X.t9 nmos_n2f5_f1_l150_0.D0.t9 VGND.t5 VNB.t7 sky130_fd_pr__nfet_01v8 ad=0.08775 pd=0.84 as=0.08775 ps=0.84 w=0.45 l=0.15
X7 VGND.t4 nmos_n2f5_f1_l150_0.D0.t8 X.t8 VNB.t6 sky130_fd_pr__nfet_01v8 ad=0.08775 pd=0.84 as=0.08775 ps=0.84 w=0.45 l=0.15
X8 VGND.t6 nmos_n2f5_f1_l150_0.D0.t10 X.t10 VNB.t8 sky130_fd_pr__nfet_01v8 ad=0.08775 pd=0.84 as=0.08775 ps=0.84 w=0.45 l=0.15
X9 X.t4 nmos_n2f5_f1_l150_0.D0.t15 VPWR.t1 VPB.t1 sky130_fd_pr__pfet_01v8_hvt ad=0.2106 pd=1.47 as=0.2106 ps=1.47 w=1.08 l=0.15
X10 VPWR.t2 nmos_n2f5_f1_l150_0.D0.t14 X.t5 VPB.t2 sky130_fd_pr__pfet_01v8_hvt ad=0.2106 pd=1.47 as=0.2106 ps=1.47 w=1.08 l=0.15
X11 nmos_n2f5_f1_l150_0.D0.t0 A.t1 VGND.t9 VNB.t3 sky130_fd_pr__nfet_01v8 ad=0.08775 pd=0.84 as=0.16875 ps=1.65 w=0.45 l=0.15
X12 X.t0 nmos_n2f5_f1_l150_0.D0.t5 VGND.t0 VNB.t0 sky130_fd_pr__nfet_01v8 ad=0.08775 pd=0.84 as=0.08775 ps=0.84 w=0.45 l=0.15
X13 VGND.t1 nmos_n2f5_f1_l150_0.D0.t4 X.t1 VNB.t1 sky130_fd_pr__nfet_01v8 ad=0.16875 pd=1.65 as=0.08775 ps=0.84 w=0.45 l=0.15
X14 X.t14 nmos_n2f5_f1_l150_0.D0.t13 VPWR.t7 VPB.t9 sky130_fd_pr__pfet_01v8_hvt ad=0.2106 pd=1.47 as=0.2106 ps=1.47 w=1.08 l=0.15
X15 X.t12 nmos_n2f5_f1_l150_0.D0.t19 VPWR.t5 VPB.t7 sky130_fd_pr__pfet_01v8_hvt ad=0.2106 pd=1.47 as=0.405 ps=2.91 w=1.08 l=0.15
X16 VPWR.t4 nmos_n2f5_f1_l150_0.D0.t12 X.t11 VPB.t6 sky130_fd_pr__pfet_01v8_hvt ad=0.405 pd=2.91 as=0.2106 ps=1.47 w=1.08 l=0.15
X17 VPWR.t6 nmos_n2f5_f1_l150_0.D0.t18 X.t13 VPB.t8 sky130_fd_pr__pfet_01v8_hvt ad=0.2106 pd=1.47 as=0.2106 ps=1.47 w=1.08 l=0.15
X18 X.t2 nmos_n2f5_f1_l150_0.D0.t11 VGND.t2 VNB.t2 sky130_fd_pr__nfet_01v8 ad=0.08775 pd=0.84 as=0.16875 ps=1.65 w=0.45 l=0.15
X19 X.t6 nmos_n2f5_f1_l150_0.D0.t17 VPWR.t3 VPB.t3 sky130_fd_pr__pfet_01v8_hvt ad=0.2106 pd=1.47 as=0.2106 ps=1.47 w=1.08 l=0.15
C0 VGND VPWR 0.14178f
C1 A VPB 0.10171f
C2 X VPB 0.03202f
C3 A VPWR 0.09501f
C4 VGND A 0.06874f
C5 X VPWR 1.01681f
C6 X VGND 0.57834f
C7 VPWR VPB 0.26249f
C8 VGND VPB 0.01485f
R0 VGND VGND.t1 243.4
R1 VGND VGND.t2 243.4
R2 VGND VGND.t8 243.4
R3 VGND VGND.t9 243.4
R4 VGND VGND.n10 191.4
R5 VGND VGND.n7 191.4
R6 VGND VGND.n4 191.4
R7 VGND.n10 VGND.t0 52.0005
R8 VGND.n10 VGND.t7 52.0005
R9 VGND.n7 VGND.t3 52.0005
R10 VGND.n7 VGND.t4 52.0005
R11 VGND.n4 VGND.t5 52.0005
R12 VGND.n4 VGND.t6 52.0005
R13 VGND.n12 VGND 16.2074
R14 VGND.n38 VGND.n37 15.7005
R15 VGND.n15 VGND.n14 12.8005
R16 VGND.n16 VGND.n15 12.8005
R17 VGND.n20 VGND.n19 12.8005
R18 VGND.n21 VGND.n20 12.8005
R19 VGND.n25 VGND.n24 12.8005
R20 VGND.n27 VGND.n25 12.8005
R21 VGND.n31 VGND.n2 12.8005
R22 VGND.n34 VGND.n33 12.8005
R23 VGND.n34 VGND.n0 12.8005
R24 VGND.n12 VGND.n11 12.1406
R25 VGND.n11 VGND 9.6005
R26 VGND.n8 VGND 9.6005
R27 VGND.n5 VGND 9.6005
R28 VGND.n26 VGND 9.6005
R29 VGND.n32 VGND 9.6005
R30 VGND VGND.n38 9.6005
R31 VGND.n36 VGND.n0 9.3005
R32 VGND.n35 VGND.n34 9.3005
R33 VGND.n33 VGND.n1 9.3005
R34 VGND.n31 VGND.n30 9.3005
R35 VGND.n29 VGND.n2 9.3005
R36 VGND.n28 VGND.n27 9.3005
R37 VGND.n25 VGND.n3 9.3005
R38 VGND.n24 VGND.n23 9.3005
R39 VGND.n22 VGND.n21 9.3005
R40 VGND.n20 VGND.n6 9.3005
R41 VGND.n19 VGND.n18 9.3005
R42 VGND.n17 VGND.n16 9.3005
R43 VGND.n15 VGND.n9 9.3005
R44 VGND.n14 VGND.n13 9.3005
R45 VGND.n14 VGND.n11 6.4005
R46 VGND.n16 VGND.n8 6.4005
R47 VGND.n19 VGND.n8 6.4005
R48 VGND.n21 VGND.n5 6.4005
R49 VGND.n24 VGND.n5 6.4005
R50 VGND.n27 VGND.n26 6.4005
R51 VGND.n26 VGND.n2 6.4005
R52 VGND.n32 VGND.n31 6.4005
R53 VGND.n33 VGND.n32 6.4005
R54 VGND.n38 VGND.n0 6.4005
R55 VGND.n13 VGND.n12 0.584022
R56 VGND.n13 VGND.n9 0.063
R57 VGND.n17 VGND.n9 0.063
R58 VGND.n18 VGND.n17 0.063
R59 VGND.n18 VGND.n6 0.063
R60 VGND.n22 VGND.n6 0.063
R61 VGND.n23 VGND.n22 0.063
R62 VGND.n23 VGND.n3 0.063
R63 VGND.n28 VGND.n3 0.063
R64 VGND.n29 VGND.n28 0.063
R65 VGND.n30 VGND.n29 0.063
R66 VGND.n30 VGND.n1 0.063
R67 VGND.n35 VGND.n1 0.063
R68 VGND.n36 VGND.n35 0.063
R69 VGND.n37 VGND.n36 0.063
R70 VGND.n37 VGND 0.03175
R71 X X.n9 308.5
R72 X X.n6 308.5
R73 X X.n3 308.5
R74 X X.n0 308.5
R75 X.n11 X.n10 185
R76 X.n8 X.n7 185
R77 X.n5 X.n4 185
R78 X.n2 X.n1 185
R79 X.n10 X.t1 52.0005
R80 X.n10 X.t0 52.0005
R81 X.n7 X.t15 52.0005
R82 X.n7 X.t7 52.0005
R83 X.n4 X.t8 52.0005
R84 X.n4 X.t9 52.0005
R85 X.n1 X.t10 52.0005
R86 X.n1 X.t2 52.0005
R87 X.n13 X.n12 38.4005
R88 X.n14 X.n13 38.4005
R89 X.n15 X.n14 38.4005
R90 X.n9 X.t11 35.5699
R91 X.n9 X.t14 35.5699
R92 X.n6 X.t5 35.5699
R93 X.n6 X.t4 35.5699
R94 X.n3 X.t3 35.5699
R95 X.n3 X.t6 35.5699
R96 X.n0 X.t13 35.5699
R97 X.n0 X.t12 35.5699
R98 X.n12 X.n11 22.4005
R99 X.n13 X.n8 22.4005
R100 X.n14 X.n5 22.4005
R101 X.n15 X.n2 22.4005
R102 X.n12 X 9.6005
R103 X.n13 X 9.6005
R104 X.n14 X 9.6005
R105 X X.n15 9.6005
R106 X.n11 X 6.4005
R107 X.n8 X 6.4005
R108 X.n5 X 6.4005
R109 X.n2 X 6.4005
R110 X.n15 X 6.4005
R111 VPWR.n18 VPWR.t8 328.07
R112 VPWR.n15 VPWR.t9 328.07
R113 VPWR.n12 VPWR.t5 328.07
R114 VPWR.n45 VPWR.t4 328.07
R115 VPWR.n9 VPWR.n8 292.5
R116 VPWR.n6 VPWR.n5 292.5
R117 VPWR.n2 VPWR.n1 292.5
R118 VPWR.n8 VPWR.t3 35.5699
R119 VPWR.n8 VPWR.t6 35.5699
R120 VPWR.n5 VPWR.t1 35.5699
R121 VPWR.n5 VPWR.t0 35.5699
R122 VPWR.n1 VPWR.t7 35.5699
R123 VPWR.n1 VPWR.t2 35.5699
R124 VPWR.n45 VPWR.n44 32.2074
R125 VPWR.n19 VPWR.n18 25.6005
R126 VPWR.n25 VPWR.n15 25.6005
R127 VPWR.n13 VPWR.n12 25.6005
R128 VPWR.n10 VPWR.n9 25.6005
R129 VPWR.n7 VPWR.n6 25.6005
R130 VPWR.n43 VPWR.n2 25.6005
R131 VPWR.n18 VPWR 16.0005
R132 VPWR.n15 VPWR 16.0005
R133 VPWR.n12 VPWR 16.0005
R134 VPWR.n9 VPWR 16.0005
R135 VPWR.n6 VPWR 16.0005
R136 VPWR.n2 VPWR 16.0005
R137 VPWR VPWR.n45 16.0005
R138 VPWR.n19 VPWR.n17 15.7005
R139 VPWR.n42 VPWR.n41 12.8005
R140 VPWR.n41 VPWR.n3 12.8005
R141 VPWR.n37 VPWR.n36 12.8005
R142 VPWR.n36 VPWR.n35 12.8005
R143 VPWR.n32 VPWR.n31 12.8005
R144 VPWR.n31 VPWR.n30 12.8005
R145 VPWR.n27 VPWR.n26 12.8005
R146 VPWR.n24 VPWR.n16 12.8005
R147 VPWR.n20 VPWR.n16 12.8005
R148 VPWR.n44 VPWR.n43 12.1406
R149 VPWR.n21 VPWR.n20 9.3005
R150 VPWR.n22 VPWR.n16 9.3005
R151 VPWR.n24 VPWR.n23 9.3005
R152 VPWR.n26 VPWR.n14 9.3005
R153 VPWR.n28 VPWR.n27 9.3005
R154 VPWR.n30 VPWR.n29 9.3005
R155 VPWR.n31 VPWR.n11 9.3005
R156 VPWR.n33 VPWR.n32 9.3005
R157 VPWR.n35 VPWR.n34 9.3005
R158 VPWR.n36 VPWR.n4 9.3005
R159 VPWR.n38 VPWR.n37 9.3005
R160 VPWR.n39 VPWR.n3 9.3005
R161 VPWR.n41 VPWR.n40 9.3005
R162 VPWR.n42 VPWR.n0 9.3005
R163 VPWR.n43 VPWR.n42 6.4005
R164 VPWR.n7 VPWR.n3 6.4005
R165 VPWR.n37 VPWR.n7 6.4005
R166 VPWR.n35 VPWR.n10 6.4005
R167 VPWR.n32 VPWR.n10 6.4005
R168 VPWR.n30 VPWR.n13 6.4005
R169 VPWR.n27 VPWR.n13 6.4005
R170 VPWR.n26 VPWR.n25 6.4005
R171 VPWR.n25 VPWR.n24 6.4005
R172 VPWR.n20 VPWR.n19 6.4005
R173 VPWR.n44 VPWR.n0 0.584022
R174 VPWR.n40 VPWR.n0 0.063
R175 VPWR.n40 VPWR.n39 0.063
R176 VPWR.n39 VPWR.n38 0.063
R177 VPWR.n38 VPWR.n4 0.063
R178 VPWR.n34 VPWR.n4 0.063
R179 VPWR.n34 VPWR.n33 0.063
R180 VPWR.n33 VPWR.n11 0.063
R181 VPWR.n29 VPWR.n11 0.063
R182 VPWR.n29 VPWR.n28 0.063
R183 VPWR.n28 VPWR.n14 0.063
R184 VPWR.n23 VPWR.n14 0.063
R185 VPWR.n23 VPWR.n22 0.063
R186 VPWR.n22 VPWR.n21 0.063
R187 VPWR.n21 VPWR.n17 0.063
R188 VPWR.n17 VPWR 0.03175
R189 A.n0 A.t2 231.361
R190 A.n1 A.t3 231.361
R191 A.n0 A.t0 207.261
R192 A.n1 A.t1 207.261
R193 A A.n1 194.55
R194 A.n1 A.n0 72.3005
R195 VPB.t5 VPB.t7 604.545
R196 VPB VPB.t4 302.274
R197 VPB.t9 VPB.t6 259.091
R198 VPB.t2 VPB.t9 259.091
R199 VPB.t1 VPB.t2 259.091
R200 VPB.t0 VPB.t1 259.091
R201 VPB.t3 VPB.t0 259.091
R202 VPB.t8 VPB.t3 259.091
R203 VPB.t7 VPB.t8 259.091
R204 VPB.t4 VPB.t5 259.091
R205 VNB.t4 VNB.t2 2800
R206 VNB VNB.t3 1400
R207 VNB.t0 VNB.t1 1200
R208 VNB.t9 VNB.t0 1200
R209 VNB.t5 VNB.t9 1200
R210 VNB.t6 VNB.t5 1200
R211 VNB.t7 VNB.t6 1200
R212 VNB.t8 VNB.t7 1200
R213 VNB.t2 VNB.t8 1200
R214 VNB.t3 VNB.t4 1200
R215 nmos_n2f5_f1_l150_0.D0.n11 nmos_n2f5_f1_l150_0.D0.n0 185
R216 nmos_n2f5_f1_l150_0.D0.n0 nmos_n2f5_f1_l150_0.D0.t0 52.0005
R217 nmos_n2f5_f1_l150_0.D0.n0 nmos_n2f5_f1_l150_0.D0.t1 52.0005
R218 nmos_n2f5_f1_l150_1.S0 nmos_n2f5_f1_l150_0.D0.n11 6.4005
R219 nmos_n2f5_f1_l150_0.D0.n11 nmos_n2f5_f1_l150_0.D0.n2 22.4005
R220 nmos_n2f5_f1_l150_0.D0.n2 nmos_n2f5_f1_l150_0.D0.n10 232.951
R221 nmos_n2f5_f1_l150_0.D0.n10 nmos_n2f5_f1_l150_0.D0.n9 72.3005
R222 nmos_n2f5_f1_l150_0.D0.n9 nmos_n2f5_f1_l150_0.D0.n8 72.3005
R223 nmos_n2f5_f1_l150_0.D0.n8 nmos_n2f5_f1_l150_0.D0.n7 72.3005
R224 nmos_n2f5_f1_l150_0.D0.n7 nmos_n2f5_f1_l150_0.D0.n6 72.3005
R225 nmos_n2f5_f1_l150_0.D0.n6 nmos_n2f5_f1_l150_0.D0.n5 72.3005
R226 nmos_n2f5_f1_l150_0.D0.n5 nmos_n2f5_f1_l150_0.D0.n4 72.3005
R227 nmos_n2f5_f1_l150_0.D0.n4 nmos_n2f5_f1_l150_0.D0.n3 72.3005
R228 nmos_n2f5_f1_l150_0.D0.n10 nmos_n2f5_f1_l150_0.D0.t19 231.361
R229 nmos_n2f5_f1_l150_0.D0.n10 nmos_n2f5_f1_l150_0.D0.t11 207.261
R230 nmos_n2f5_f1_l150_0.D0.n9 nmos_n2f5_f1_l150_0.D0.t18 231.361
R231 nmos_n2f5_f1_l150_0.D0.n9 nmos_n2f5_f1_l150_0.D0.t10 207.261
R232 nmos_n2f5_f1_l150_0.D0.n8 nmos_n2f5_f1_l150_0.D0.t17 231.361
R233 nmos_n2f5_f1_l150_0.D0.n8 nmos_n2f5_f1_l150_0.D0.t9 207.261
R234 nmos_n2f5_f1_l150_0.D0.n7 nmos_n2f5_f1_l150_0.D0.t16 231.361
R235 nmos_n2f5_f1_l150_0.D0.n7 nmos_n2f5_f1_l150_0.D0.t8 207.261
R236 nmos_n2f5_f1_l150_0.D0.n6 nmos_n2f5_f1_l150_0.D0.t15 231.361
R237 nmos_n2f5_f1_l150_0.D0.n6 nmos_n2f5_f1_l150_0.D0.t7 207.261
R238 nmos_n2f5_f1_l150_0.D0.n5 nmos_n2f5_f1_l150_0.D0.t14 231.361
R239 nmos_n2f5_f1_l150_0.D0.n5 nmos_n2f5_f1_l150_0.D0.t6 207.261
R240 nmos_n2f5_f1_l150_0.D0.n4 nmos_n2f5_f1_l150_0.D0.t13 231.361
R241 nmos_n2f5_f1_l150_0.D0.n4 nmos_n2f5_f1_l150_0.D0.t5 207.261
R242 nmos_n2f5_f1_l150_0.D0.n3 nmos_n2f5_f1_l150_0.D0.t12 231.361
R243 nmos_n2f5_f1_l150_0.D0.n3 nmos_n2f5_f1_l150_0.D0.t4 207.261
R244 nmos_n2f5_f1_l150_0.D0.n2 pmos_n6_f1_l150_hvt_1.S0 9.6005
R245 pmos_n6_f1_l150_hvt_1.S0 nmos_n2f5_f1_l150_0.D0.n1 308.5
R246 nmos_n2f5_f1_l150_0.D0.t2 nmos_n2f5_f1_l150_0.D0.n1 35.5699
R247 nmos_n2f5_f1_l150_0.D0.n1 nmos_n2f5_f1_l150_0.D0.t3 35.5699
C10 VGND VNB 1.09791f
C11 X VNB 0.68526f
C12 VPWR VNB 0.83558f
C13 A VNB 0.34407f
C14 VPB VNB 1.66234f
C15 nmos_n2f5_f1_l150_0.D0.t1 VNB 0.01523f
C16 nmos_n2f5_f1_l150_0.D0.n0 VNB 0.03047f
C17 nmos_n2f5_f1_l150_0.D0.t2 VNB 0.03656f
C18 nmos_n2f5_f1_l150_0.D0.t3 VNB 0.03656f
C19 nmos_n2f5_f1_l150_0.D0.n1 VNB 0.07809f
C20 pmos_n6_f1_l150_hvt_1.S0 VNB 0.13567f
C21 nmos_n2f5_f1_l150_0.D0.n2 VNB 0.2454f
C22 nmos_n2f5_f1_l150_0.D0.t4 VNB 0.01954f
C23 nmos_n2f5_f1_l150_0.D0.t12 VNB 0.0375f
C24 nmos_n2f5_f1_l150_0.D0.n3 VNB 0.08359f
C25 nmos_n2f5_f1_l150_0.D0.t5 VNB 0.01954f
C26 nmos_n2f5_f1_l150_0.D0.t13 VNB 0.0375f
C27 nmos_n2f5_f1_l150_0.D0.n4 VNB 0.10609f
C28 nmos_n2f5_f1_l150_0.D0.t6 VNB 0.01954f
C29 nmos_n2f5_f1_l150_0.D0.t14 VNB 0.0375f
C30 nmos_n2f5_f1_l150_0.D0.n5 VNB 0.10609f
C31 nmos_n2f5_f1_l150_0.D0.t7 VNB 0.01954f
C32 nmos_n2f5_f1_l150_0.D0.t15 VNB 0.0375f
C33 nmos_n2f5_f1_l150_0.D0.n6 VNB 0.10609f
C34 nmos_n2f5_f1_l150_0.D0.t8 VNB 0.01954f
C35 nmos_n2f5_f1_l150_0.D0.t16 VNB 0.0375f
C36 nmos_n2f5_f1_l150_0.D0.n7 VNB 0.10609f
C37 nmos_n2f5_f1_l150_0.D0.t9 VNB 0.01954f
C38 nmos_n2f5_f1_l150_0.D0.t17 VNB 0.0375f
C39 nmos_n2f5_f1_l150_0.D0.n8 VNB 0.10609f
C40 nmos_n2f5_f1_l150_0.D0.t10 VNB 0.01954f
C41 nmos_n2f5_f1_l150_0.D0.t18 VNB 0.0375f
C42 nmos_n2f5_f1_l150_0.D0.n9 VNB 0.10609f
C43 nmos_n2f5_f1_l150_0.D0.t11 VNB 0.01954f
C44 nmos_n2f5_f1_l150_0.D0.t19 VNB 0.0375f
C45 nmos_n2f5_f1_l150_0.D0.n10 VNB 0.14195f
C46 nmos_n2f5_f1_l150_1.S0 VNB 0.0225f
C47 nmos_n2f5_f1_l150_0.D0.n11 VNB 0.05063f
C48 nmos_n2f5_f1_l150_0.D0.t0 VNB 0.01523f
C49 VPB.t6 VNB 0.10616f
C50 VPB.t9 VNB 0.0637f
C51 VPB.t2 VNB 0.0637f
C52 VPB.t1 VNB 0.0637f
C53 VPB.t0 VNB 0.0637f
C54 VPB.t3 VNB 0.0637f
C55 VPB.t8 VNB 0.0637f
C56 VPB.t7 VNB 0.10616f
C57 VPB.t5 VNB 0.10616f
C58 VPB.t4 VNB 0.06901f
C59 A.t3 VNB 0.04252f
C60 A.t1 VNB 0.02216f
C61 A.t2 VNB 0.04252f
C62 A.t0 VNB 0.02216f
C63 A.n0 VNB 0.09478f
C64 A.n1 VNB 0.13876f
C65 VPWR.n0 VNB 0.18208f
C66 VPWR.t7 VNB 0.01619f
C67 VPWR.t2 VNB 0.01619f
C68 VPWR.n1 VNB 0.03238f
C69 VPWR.n2 VNB 0.03238f
C70 VPWR.n3 VNB 0.01494f
C71 VPWR.n4 VNB 0.03985f
C72 VPWR.t1 VNB 0.01619f
C73 VPWR.t0 VNB 0.01619f
C74 VPWR.n5 VNB 0.03238f
C75 VPWR.n6 VNB 0.03238f
C76 VPWR.n7 VNB 0.02989f
C77 VPWR.t3 VNB 0.01619f
C78 VPWR.t6 VNB 0.01619f
C79 VPWR.n8 VNB 0.03238f
C80 VPWR.n9 VNB 0.03238f
C81 VPWR.n10 VNB 0.02989f
C82 VPWR.n11 VNB 0.03985f
C83 VPWR.t5 VNB 0.05727f
C84 VPWR.n12 VNB 0.03737f
C85 VPWR.n13 VNB 0.02989f
C86 VPWR.n14 VNB 0.03985f
C87 VPWR.t9 VNB 0.05727f
C88 VPWR.n15 VNB 0.03737f
C89 VPWR.n16 VNB 0.01992f
C90 VPWR.n17 VNB 0.03598f
C91 VPWR.t8 VNB 0.05727f
C92 VPWR.n18 VNB 0.03737f
C93 VPWR.n19 VNB 0.03874f
C94 VPWR.n20 VNB 0.01494f
C95 VPWR.n21 VNB 0.03985f
C96 VPWR.n22 VNB 0.03985f
C97 VPWR.n23 VNB 0.03985f
C98 VPWR.n24 VNB 0.01494f
C99 VPWR.n25 VNB 0.02989f
C100 VPWR.n26 VNB 0.01494f
C101 VPWR.n27 VNB 0.01494f
C102 VPWR.n28 VNB 0.03985f
C103 VPWR.n29 VNB 0.03985f
C104 VPWR.n30 VNB 0.01494f
C105 VPWR.n31 VNB 0.01992f
C106 VPWR.n32 VNB 0.01494f
C107 VPWR.n33 VNB 0.03985f
C108 VPWR.n34 VNB 0.03985f
C109 VPWR.n35 VNB 0.01494f
C110 VPWR.n36 VNB 0.01992f
C111 VPWR.n37 VNB 0.01494f
C112 VPWR.n38 VNB 0.03985f
C113 VPWR.n39 VNB 0.03985f
C114 VPWR.n40 VNB 0.03985f
C115 VPWR.n41 VNB 0.01992f
C116 VPWR.n42 VNB 0.01494f
C117 VPWR.n43 VNB 0.03975f
C118 VPWR.n44 VNB 0.09182f
C119 VPWR.t4 VNB 0.05727f
C120 VPWR.n45 VNB 0.04748f
C121 X.t13 VNB 0.03317f
C122 X.t12 VNB 0.03317f
C123 X.n0 VNB 0.07085f
C124 X.t10 VNB 0.01382f
C125 X.t2 VNB 0.01382f
C126 X.n1 VNB 0.02764f
C127 X.n2 VNB 0.04593f
C128 X.t3 VNB 0.03317f
C129 X.t6 VNB 0.03317f
C130 X.n3 VNB 0.07085f
C131 X.t8 VNB 0.01382f
C132 X.t9 VNB 0.01382f
C133 X.n4 VNB 0.02764f
C134 X.n5 VNB 0.04593f
C135 X.t5 VNB 0.03317f
C136 X.t4 VNB 0.03317f
C137 X.n6 VNB 0.07085f
C138 X.t15 VNB 0.01382f
C139 X.t7 VNB 0.01382f
C140 X.n7 VNB 0.02764f
C141 X.n8 VNB 0.04593f
C142 X.t11 VNB 0.03317f
C143 X.t14 VNB 0.03317f
C144 X.n9 VNB 0.07085f
C145 X.t1 VNB 0.01382f
C146 X.t0 VNB 0.01382f
C147 X.n10 VNB 0.02764f
C148 X.n11 VNB 0.04593f
C149 X.n12 VNB 0.1327f
C150 X.n13 VNB 0.17352f
C151 X.n14 VNB 0.17352f
C152 X.n15 VNB 0.12249f
C153 VGND.t9 VNB 0.0167f
C154 VGND.n0 VNB 0.01122f
C155 VGND.n1 VNB 0.02993f
C156 VGND.t8 VNB 0.0167f
C157 VGND.n2 VNB 0.01122f
C158 VGND.n3 VNB 0.02993f
C159 VGND.t5 VNB 0.00507f
C160 VGND.t6 VNB 0.00507f
C161 VGND.n4 VNB 0.01051f
C162 VGND.n5 VNB 0.01309f
C163 VGND.n6 VNB 0.02993f
C164 VGND.t3 VNB 0.00507f
C165 VGND.t4 VNB 0.00507f
C166 VGND.n7 VNB 0.01051f
C167 VGND.n8 VNB 0.01309f
C168 VGND.n9 VNB 0.02993f
C169 VGND.t0 VNB 0.00507f
C170 VGND.t7 VNB 0.00507f
C171 VGND.n10 VNB 0.01051f
C172 VGND.n11 VNB 0.0205f
C173 VGND.t1 VNB 0.0167f
C174 VGND.n12 VNB 0.05592f
C175 VGND.n13 VNB 0.13674f
C176 VGND.n14 VNB 0.01122f
C177 VGND.n15 VNB 0.01496f
C178 VGND.n16 VNB 0.01122f
C179 VGND.n17 VNB 0.02993f
C180 VGND.n18 VNB 0.02993f
C181 VGND.n19 VNB 0.01122f
C182 VGND.n20 VNB 0.01496f
C183 VGND.n21 VNB 0.01122f
C184 VGND.n22 VNB 0.02993f
C185 VGND.n23 VNB 0.02993f
C186 VGND.n24 VNB 0.01122f
C187 VGND.n25 VNB 0.01496f
C188 VGND.t2 VNB 0.0167f
C189 VGND.n26 VNB 0.01309f
C190 VGND.n27 VNB 0.01122f
C191 VGND.n28 VNB 0.02993f
C192 VGND.n29 VNB 0.02993f
C193 VGND.n30 VNB 0.02993f
C194 VGND.n31 VNB 0.01122f
C195 VGND.n32 VNB 0.01309f
C196 VGND.n33 VNB 0.01122f
C197 VGND.n34 VNB 0.01496f
C198 VGND.n35 VNB 0.02993f
C199 VGND.n36 VNB 0.02993f
C200 VGND.n37 VNB 0.02702f
C201 VGND.n38 VNB 0.01974f
.ends

.subckt sky130_efx_lvdig__clkdlybuf4s50_1 A X VGND VNB VPB VPWR
X0 a_141_36.t0 A.t1 VPWR.t0 VPB.t0 sky130_fd_pr__pfet_01v8_hvt ad=0.405 pd=2.91 as=0.405 ps=2.91 w=1.08 l=0.15
X1 X.t1 a_788_36.t2 VGND.t2 VNB.t2 sky130_fd_pr__nfet_01v8 ad=0.16875 pd=1.65 as=0.16875 ps=1.65 w=0.45 l=0.15
X2 a_788_36.t0 a_464_36.t2 VGND.t1 VNB.t1 sky130_fd_pr__nfet_01v8 ad=0.2394 pd=2.02 as=0.2394 ps=2.02 w=0.63 l=0.5
X3 X.t0 a_788_36.t3 VPWR.t1 VPB.t1 sky130_fd_pr__pfet_01v8_hvt ad=0.405 pd=2.91 as=0.405 ps=2.91 w=1.08 l=0.15
X4 a_141_36.t1 A.t0 VGND.t0 VNB.t0 sky130_fd_pr__nfet_01v8 ad=0.16875 pd=1.65 as=0.16875 ps=1.65 w=0.45 l=0.15
X5 a_464_36.t0 a_141_36.t3 VPWR.t3 VPB.t3 sky130_fd_pr__pfet_01v8_hvt ad=0.3078 pd=2.38 as=0.3078 ps=2.38 w=0.81 l=0.5
X6 a_464_36.t1 a_141_36.t2 VGND.t3 VNB.t3 sky130_fd_pr__nfet_01v8 ad=0.2394 pd=2.02 as=0.2394 ps=2.02 w=0.63 l=0.5
X7 a_788_36.t1 a_464_36.t3 VPWR.t2 VPB.t2 sky130_fd_pr__pfet_01v8_hvt ad=0.3078 pd=2.38 as=0.3078 ps=2.38 w=0.81 l=0.5
C0 X VPB 0.01018f
C1 VGND VPB 0.02028f
C2 VPB VPWR 0.25551f
C3 VGND A 0.04596f
C4 VPWR A 0.06592f
C5 VPB A 0.05563f
C6 VGND X 0.08761f
C7 X VPWR 0.13854f
C8 VGND VPWR 0.11658f
R0 VGND.n4 VGND.t2 257.837
R1 VGND.n18 VGND.t0 253
R2 VGND.n12 VGND.t3 242.296
R3 VGND.n5 VGND.t1 242.296
R4 VGND.n19 VGND.n18 15.7005
R5 VGND.n6 VGND.n3 12.8005
R6 VGND.n10 VGND.n3 12.8005
R7 VGND.n11 VGND.n10 12.8005
R8 VGND.n12 VGND.n11 12.8005
R9 VGND.n12 VGND.n1 12.8005
R10 VGND.n16 VGND.n1 12.8005
R11 VGND.n17 VGND.n16 12.8005
R12 VGND.n5 VGND.n4 12.5554
R13 VGND.n17 VGND.n0 9.3005
R14 VGND.n16 VGND.n15 9.3005
R15 VGND.n14 VGND.n1 9.3005
R16 VGND.n13 VGND.n12 9.3005
R17 VGND.n11 VGND.n2 9.3005
R18 VGND.n10 VGND.n9 9.3005
R19 VGND.n8 VGND.n3 9.3005
R20 VGND.n7 VGND.n6 9.3005
R21 VGND.n6 VGND.n5 6.4005
R22 VGND.n18 VGND.n17 6.4005
R23 VGND.n7 VGND.n4 0.165806
R24 VGND.n8 VGND.n7 0.063
R25 VGND.n9 VGND.n8 0.063
R26 VGND.n9 VGND.n2 0.063
R27 VGND.n13 VGND.n2 0.063
R28 VGND.n14 VGND.n13 0.063
R29 VGND.n15 VGND.n14 0.063
R30 VGND.n15 VGND.n0 0.063
R31 VGND.n19 VGND.n0 0.063
R32 VGND VGND.n19 0.03175
R33 X X.t0 366.469
R34 X X.t1 259.401
R35 VPWR.n12 VPWR.t3 360.342
R36 VPWR.n5 VPWR.t2 360.342
R37 VPWR.n4 VPWR.t1 358.507
R38 VPWR.n18 VPWR.t0 353.67
R39 VPWR.n19 VPWR.n18 15.7005
R40 VPWR.n6 VPWR.n3 12.8005
R41 VPWR.n10 VPWR.n3 12.8005
R42 VPWR.n11 VPWR.n10 12.8005
R43 VPWR.n12 VPWR.n11 12.8005
R44 VPWR.n12 VPWR.n1 12.8005
R45 VPWR.n16 VPWR.n1 12.8005
R46 VPWR.n17 VPWR.n16 12.8005
R47 VPWR.n5 VPWR.n4 12.5554
R48 VPWR.n17 VPWR.n0 9.3005
R49 VPWR.n16 VPWR.n15 9.3005
R50 VPWR.n14 VPWR.n1 9.3005
R51 VPWR.n13 VPWR.n12 9.3005
R52 VPWR.n11 VPWR.n2 9.3005
R53 VPWR.n10 VPWR.n9 9.3005
R54 VPWR.n8 VPWR.n3 9.3005
R55 VPWR.n7 VPWR.n6 9.3005
R56 VPWR.n6 VPWR.n5 6.4005
R57 VPWR.n18 VPWR.n17 6.4005
R58 VPWR.n7 VPWR.n4 0.165806
R59 VPWR.n8 VPWR.n7 0.063
R60 VPWR.n9 VPWR.n8 0.063
R61 VPWR.n9 VPWR.n2 0.063
R62 VPWR.n13 VPWR.n2 0.063
R63 VPWR.n14 VPWR.n13 0.063
R64 VPWR.n15 VPWR.n14 0.063
R65 VPWR.n15 VPWR.n0 0.063
R66 VPWR.n19 VPWR.n0 0.063
R67 VPWR VPWR.n19 0.03175
R68 A.n0 A.t1 247.428
R69 A.n0 A.t0 232.968
R70 A A.n0 158.4
R71 VPB.t3 VPB.t2 777.274
R72 VPB.t2 VPB.t1 690.909
R73 VPB.t0 VPB.t3 690.909
R74 VPB VPB.t0 302.274
R75 VNB.t3 VNB.t1 3600
R76 VNB.t1 VNB.t2 3200
R77 VNB.t0 VNB.t3 3200
R78 VNB VNB.t0 1400
R79 a_788_36.t0 a_788_36.n0 242.296
R80 a_788_36.n0 a_788_36.n1 177.601
R81 a_788_36.n1 a_788_36.t2 232.968
R82 a_788_36.n1 a_788_36.t3 247.428
R83 a_788_36.n0 a_788_36.t1 373.142
R84 a_464_36.t1 a_464_36.n0 242.296
R85 a_464_36.n0 a_464_36.n1 204.379
R86 a_464_36.n1 a_464_36.t2 73.7465
R87 a_464_36.n1 a_464_36.t3 99.7745
R88 a_464_36.n0 a_464_36.t0 373.142
R89 a_141_36.t1 a_141_36.n0 259.401
R90 a_141_36.n0 a_141_36.n1 204.379
R91 a_141_36.n1 a_141_36.t2 73.7465
R92 a_141_36.n1 a_141_36.t3 99.7745
R93 a_141_36.n0 a_141_36.t0 353.67
C9 VGND VNB 0.80322f
C10 X VNB 0.30686f
C11 VPWR VNB 0.59703f
C12 A VNB 0.24232f
C13 VPB VNB 1.40844f
C14 a_141_36.t1 VNB 0.04804f
C15 a_141_36.t0 VNB 0.11819f
C16 a_141_36.n0 VNB 0.34681f
C17 a_141_36.n1 VNB 0.17529f
C18 a_141_36.t3 VNB 0.11016f
C19 a_141_36.t2 VNB 0.07678f
C20 a_464_36.t1 VNB 0.06696f
C21 a_464_36.t0 VNB 0.08843f
C22 a_464_36.n0 VNB 0.34105f
C23 a_464_36.n1 VNB 0.17226f
C24 a_464_36.t3 VNB 0.10826f
C25 a_464_36.t2 VNB 0.07545f
C26 a_788_36.t0 VNB 0.06814f
C27 a_788_36.t1 VNB 0.08998f
C28 a_788_36.n0 VNB 0.34204f
C29 a_788_36.t3 VNB 0.03402f
C30 a_788_36.t2 VNB 0.01906f
C31 a_788_36.n1 VNB 0.09304f
C32 VPB.t1 VNB 0.17083f
C33 VPB.t2 VNB 0.1936f
C34 VPB.t3 VNB 0.1936f
C35 VPB.t0 VNB 0.13097f
C36 A.t1 VNB 0.04852f
C37 A.t0 VNB 0.02717f
C38 A.n0 VNB 0.12247f
C39 VPWR.n0 VNB 0.0365f
C40 VPWR.t0 VNB 0.0561f
C41 VPWR.n1 VNB 0.01825f
C42 VPWR.n2 VNB 0.0365f
C43 VPWR.t3 VNB 0.04098f
C44 VPWR.n3 VNB 0.01825f
C45 VPWR.t1 VNB 0.05756f
C46 VPWR.n4 VNB 0.29761f
C47 VPWR.t2 VNB 0.04098f
C48 VPWR.n5 VNB 0.07233f
C49 VPWR.n6 VNB 0.01369f
C50 VPWR.n7 VNB 0.17034f
C51 VPWR.n8 VNB 0.0365f
C52 VPWR.n9 VNB 0.0365f
C53 VPWR.n10 VNB 0.01825f
C54 VPWR.n11 VNB 0.01825f
C55 VPWR.n12 VNB 0.07081f
C56 VPWR.n13 VNB 0.0365f
C57 VPWR.n14 VNB 0.0365f
C58 VPWR.n15 VNB 0.0365f
C59 VPWR.n16 VNB 0.01825f
C60 VPWR.n17 VNB 0.01369f
C61 VPWR.n18 VNB 0.08206f
C62 VPWR.n19 VNB 0.03296f
C63 X.t0 VNB 0.0882f
C64 X.t1 VNB 0.03427f
C65 VGND.n0 VNB 0.0282f
C66 VGND.t0 VNB 0.01657f
C67 VGND.n1 VNB 0.0141f
C68 VGND.n2 VNB 0.0282f
C69 VGND.t3 VNB 0.0247f
C70 VGND.n3 VNB 0.0141f
C71 VGND.t2 VNB 0.0177f
C72 VGND.n4 VNB 0.2063f
C73 VGND.t1 VNB 0.0247f
C74 VGND.n5 VNB 0.04834f
C75 VGND.n6 VNB 0.01057f
C76 VGND.n7 VNB 0.13159f
C77 VGND.n8 VNB 0.0282f
C78 VGND.n9 VNB 0.0282f
C79 VGND.n10 VNB 0.0141f
C80 VGND.n11 VNB 0.0141f
C81 VGND.n12 VNB 0.04717f
C82 VGND.n13 VNB 0.0282f
C83 VGND.n14 VNB 0.0282f
C84 VGND.n15 VNB 0.0282f
C85 VGND.n16 VNB 0.0141f
C86 VGND.n17 VNB 0.01057f
C87 VGND.n18 VNB 0.03978f
C88 VGND.n19 VNB 0.02546f
.ends

.subckt sky130_efx_lvdig__clkinv_1 A Y VGND VNB VPB VPWR
X0 Y.t2 A.t2 VPWR.t1 VPB.t0 sky130_fd_pr__pfet_01v8_hvt ad=0.15795 pd=1.2 as=0.30375 ps=2.37 w=0.81 l=0.15
X1 VPWR.t0 A.t1 Y.t1 VPB.t1 sky130_fd_pr__pfet_01v8_hvt ad=0.30375 pd=2.37 as=0.15795 ps=1.2 w=0.81 l=0.15
X2 Y.t0 A.t0 VGND.t0 VNB.t0 sky130_fd_pr__nfet_01v8 ad=0.16875 pd=1.65 as=0.16875 ps=1.65 w=0.45 l=0.15
C0 A VPWR 0.07453f
C1 A VGND 0.05057f
C2 VPWR VGND 0.04265f
C3 VPB Y 0.01586f
C4 A VPB 0.13829f
C5 VPB VPWR 0.08051f
C6 VPB VGND 0.01034f
C7 A Y 0.10592f
C8 VPWR Y 0.18243f
C9 VGND Y 0.08768f
R0 VGND VGND.t0 243.4
R1 Y Y.n0 305.3
R2 Y.n1 Y.t0 237
R3 Y.n0 Y.t1 47.4264
R4 Y.n0 Y.t2 47.4264
R5 Y Y.n1 22.4005
R6 Y.n1 Y 6.4005
R7 VPWR.n0 VPWR.t0 369.183
R8 VPWR.n0 VPWR.t1 369.033
R9 VPWR VPWR.n0 0.354563
R10 A.n0 A.t1 337.401
R11 A.n0 A.t2 265.101
R12 A.n0 A.t0 207.261
R13 A A.n0 194.55
R14 VPB VPB.t0 302.274
R15 VPB.t0 VPB.t1 259.091
R16 VNB VNB.t0 1400
C10 VGND VNB 0.52205f
C11 Y VNB 0.31112f
C12 VPWR VNB 0.44322f
C13 A VNB 0.3404f
C14 VPB VNB 0.47055f
C15 VPB.t1 VNB 0.1225f
C16 VPB.t0 VNB 0.07962f
C17 A.t2 VNB 0.03688f
C18 A.t0 VNB 0.0215f
C19 A.t1 VNB 0.05329f
C20 A.n0 VNB 0.20129f
C21 VPWR.t1 VNB 0.03487f
C22 VPWR.t0 VNB 0.03494f
C23 VPWR.n0 VNB 0.17969f
C24 Y.t1 VNB 0.02224f
C25 Y.t2 VNB 0.02224f
C26 Y.n0 VNB 0.04715f
C27 Y.t0 VNB 0.0398f
C28 Y.n1 VNB 0.04877f
C29 VGND.t0 VNB 0.01182f
.ends

.subckt sky130_efx_lvdig__clkinv_2 A Y VGND VNB VPB VPWR
X0 VGND.t1 A.t0 Y.t2 VNB.t1 sky130_fd_pr__nfet_01v8 ad=0.16875 pd=1.65 as=0.08775 ps=0.84 w=0.45 l=0.15
X1 Y.t0 A.t4 VPWR.t0 VPB.t0 sky130_fd_pr__pfet_01v8_hvt ad=0.2106 pd=1.47 as=0.405 ps=2.91 w=1.08 l=0.15
X2 VPWR.t2 A.t3 Y.t4 VPB.t1 sky130_fd_pr__pfet_01v8_hvt ad=0.2106 pd=1.47 as=0.2106 ps=1.47 w=1.08 l=0.15
X3 Y.t3 A.t2 VPWR.t1 VPB.t2 sky130_fd_pr__pfet_01v8_hvt ad=0.405 pd=2.91 as=0.2106 ps=1.47 w=1.08 l=0.15
X4 Y.t1 A.t1 VGND.t0 VNB.t0 sky130_fd_pr__nfet_01v8 ad=0.08775 pd=0.84 as=0.16875 ps=1.65 w=0.45 l=0.15
C0 VPB VGND 0.0105f
C1 VGND VPWR 0.05128f
C2 VPB VPWR 0.10048f
C3 VGND Y 0.16327f
C4 VPB Y 0.02176f
C5 VPWR Y 0.40078f
C6 A VGND 0.07387f
C7 VPB A 0.14568f
C8 A VPWR 0.12664f
C9 A Y 0.16914f
R0 VGND VGND.t1 243.4
R1 VGND VGND.t0 243.4
R2 VGND VGND.n0 16.3315
R3 VGND.n0 VGND 15.8178
R4 VGND.n0 VGND 0.328693
R5 Y Y.t3 344.07
R6 Y Y.n0 308.5
R7 Y.n2 Y.n1 185
R8 Y.n1 Y.t2 52.0005
R9 Y.n1 Y.t1 52.0005
R10 Y.n3 Y 48.0005
R11 Y.n0 Y.t4 35.5699
R12 Y.n0 Y.t0 35.5699
R13 Y.n3 Y.n2 22.4005
R14 Y Y.n3 9.6005
R15 Y.n2 Y 6.4005
R16 Y.n3 Y 6.4005
R17 VPWR.n0 VPWR.t0 328.07
R18 VPWR.n3 VPWR.n2 292.5
R19 VPWR.n2 VPWR.t1 35.5699
R20 VPWR.n2 VPWR.t2 35.5699
R21 VPWR.n1 VPWR.n0 32.3315
R22 VPWR.n3 VPWR.n1 31.8178
R23 VPWR.n0 VPWR 16.0005
R24 VPWR VPWR.n3 16.0005
R25 VPWR.n1 VPWR 0.328693
R26 A.n0 A.t2 303.661
R27 A.n0 A.t3 231.361
R28 A.n1 A.t4 231.361
R29 A.n0 A.t0 207.261
R30 A.n1 A.t1 207.261
R31 A A.n1 194.55
R32 A.n1 A.n0 72.3005
R33 VPB VPB.t0 302.274
R34 VPB.t1 VPB.t2 259.091
R35 VPB.t0 VPB.t1 259.091
R36 VNB VNB.t0 1400
R37 VNB.t0 VNB.t1 1200
C10 VGND VNB 0.64042f
C11 Y VNB 0.43856f
C12 VPWR VNB 0.62939f
C13 A VNB 0.4203f
C14 VPB VNB 0.63355f
C15 VPB.t2 VNB 0.11932f
C16 VPB.t1 VNB 0.05966f
C17 VPB.t0 VNB 0.06463f
C18 A.t4 VNB 0.03904f
C19 A.t1 VNB 0.02034f
C20 A.t3 VNB 0.03904f
C21 A.t0 VNB 0.02034f
C22 A.t2 VNB 0.05484f
C23 A.n0 VNB 0.16101f
C24 A.n1 VNB 0.1274f
C25 VPWR.t0 VNB 0.05679f
C26 VPWR.n0 VNB 0.04712f
C27 VPWR.n1 VNB 0.17895f
C28 VPWR.t1 VNB 0.01605f
C29 VPWR.t2 VNB 0.01605f
C30 VPWR.n2 VNB 0.03211f
C31 VPWR.n3 VNB 0.04332f
C32 Y.t4 VNB 0.02889f
C33 Y.t0 VNB 0.02889f
C34 Y.n0 VNB 0.06171f
C35 Y.t2 VNB 0.01204f
C36 Y.t1 VNB 0.01204f
C37 Y.n1 VNB 0.02408f
C38 Y.n2 VNB 0.04001f
C39 Y.t3 VNB 0.10614f
C40 Y.n3 VNB 0.12358f
C41 VGND.t0 VNB 0.01231f
C42 VGND.t1 VNB 0.01231f
C43 VGND.n0 VNB 0.07982f
.ends

.subckt sky130_efx_lvdig__clkinv_4 A Y VGND VNB VPB VPWR
X0 VGND.t2 A.t2 Y.t5 VNB.t1 sky130_fd_pr__nfet_01v8 ad=0.08775 pd=0.84 as=0.08775 ps=0.84 w=0.45 l=0.15
X1 Y.t3 A.t1 VGND.t1 VNB.t2 sky130_fd_pr__nfet_01v8 ad=0.08775 pd=0.84 as=0.08775 ps=0.84 w=0.45 l=0.15
X2 VGND.t0 A.t0 Y.t1 VNB.t3 sky130_fd_pr__nfet_01v8 ad=0.16875 pd=1.65 as=0.08775 ps=0.84 w=0.45 l=0.15
X3 Y.t9 A.t9 VPWR.t5 VPB.t0 sky130_fd_pr__pfet_01v8_hvt ad=0.2106 pd=1.47 as=0.405 ps=2.91 w=1.08 l=0.15
X4 VPWR.t4 A.t8 Y.t7 VPB.t1 sky130_fd_pr__pfet_01v8_hvt ad=0.2106 pd=1.47 as=0.2106 ps=1.47 w=1.08 l=0.15
X5 Y.t2 A.t7 VPWR.t1 VPB.t2 sky130_fd_pr__pfet_01v8_hvt ad=0.2106 pd=1.47 as=0.2106 ps=1.47 w=1.08 l=0.15
X6 VPWR.t0 A.t6 Y.t0 VPB.t3 sky130_fd_pr__pfet_01v8_hvt ad=0.2106 pd=1.47 as=0.2106 ps=1.47 w=1.08 l=0.15
X7 Y.t4 A.t5 VPWR.t2 VPB.t4 sky130_fd_pr__pfet_01v8_hvt ad=0.2106 pd=1.47 as=0.2106 ps=1.47 w=1.08 l=0.15
X8 Y.t8 A.t3 VGND.t3 VNB.t0 sky130_fd_pr__nfet_01v8 ad=0.08775 pd=0.84 as=0.16875 ps=1.65 w=0.45 l=0.15
X9 VPWR.t3 A.t4 Y.t6 VPB.t5 sky130_fd_pr__pfet_01v8_hvt ad=0.405 pd=2.91 as=0.2106 ps=1.47 w=1.08 l=0.15
C0 VGND Y 0.31478f
C1 VPB A 0.28229f
C2 VPWR A 0.21866f
C3 VGND A 0.12756f
C4 VPB VPWR 0.14389f
C5 Y A 0.3313f
C6 VPB VGND 0.00938f
C7 VGND VPWR 0.08396f
C8 VPB Y 0.02289f
C9 Y VPWR 0.75192f
R0 VGND VGND.t0 243.4
R1 VGND VGND.t3 243.4
R2 VGND VGND.n2 191.4
R3 VGND.n2 VGND.t1 52.0005
R4 VGND.n2 VGND.t2 52.0005
R5 VGND.n10 VGND.n9 15.7005
R6 VGND.n3 VGND 15.5809
R7 VGND.n6 VGND.n5 12.8005
R8 VGND.n6 VGND.n0 12.8005
R9 VGND.n4 VGND.n3 12.1846
R10 VGND.n4 VGND 9.6005
R11 VGND VGND.n10 9.6005
R12 VGND.n8 VGND.n0 9.3005
R13 VGND.n7 VGND.n6 9.3005
R14 VGND.n5 VGND.n1 9.3005
R15 VGND.n5 VGND.n4 6.4005
R16 VGND.n10 VGND.n0 6.4005
R17 VGND.n3 VGND.n1 0.536639
R18 VGND.n7 VGND.n1 0.063
R19 VGND.n8 VGND.n7 0.063
R20 VGND.n9 VGND.n8 0.063
R21 VGND.n9 VGND 0.03175
R22 Y Y.n6 308.5
R23 Y Y.n3 308.5
R24 Y Y.n0 308.5
R25 Y.n5 Y.n4 185
R26 Y.n2 Y.n1 185
R27 Y.n4 Y.t1 52.0005
R28 Y.n4 Y.t3 52.0005
R29 Y.n1 Y.t5 52.0005
R30 Y.n1 Y.t8 52.0005
R31 Y.n7 Y 48.0005
R32 Y.n8 Y.n7 38.4005
R33 Y.n6 Y.t6 35.5699
R34 Y.n6 Y.t4 35.5699
R35 Y.n3 Y.t0 35.5699
R36 Y.n3 Y.t2 35.5699
R37 Y.n0 Y.t7 35.5699
R38 Y.n0 Y.t9 35.5699
R39 Y.n7 Y.n5 22.4005
R40 Y.n8 Y.n2 22.4005
R41 Y.n7 Y 9.6005
R42 Y Y.n8 9.6005
R43 Y.n5 Y 6.4005
R44 Y.n2 Y 6.4005
R45 Y.n8 Y 6.4005
R46 VPWR.n8 VPWR.t5 328.07
R47 VPWR.n22 VPWR.t3 328.07
R48 VPWR.n6 VPWR.n5 292.5
R49 VPWR.n2 VPWR.n1 292.5
R50 VPWR.n5 VPWR.t1 35.5699
R51 VPWR.n5 VPWR.t4 35.5699
R52 VPWR.n1 VPWR.t2 35.5699
R53 VPWR.n1 VPWR.t0 35.5699
R54 VPWR.n22 VPWR.n21 32.2074
R55 VPWR.n9 VPWR.n8 25.6005
R56 VPWR.n7 VPWR.n6 25.6005
R57 VPWR.n20 VPWR.n2 25.6005
R58 VPWR.n8 VPWR 16.0005
R59 VPWR.n6 VPWR 16.0005
R60 VPWR.n2 VPWR 16.0005
R61 VPWR VPWR.n22 16.0005
R62 VPWR.n10 VPWR.n9 15.7005
R63 VPWR.n19 VPWR.n18 12.8005
R64 VPWR.n18 VPWR.n3 12.8005
R65 VPWR.n14 VPWR.n13 12.8005
R66 VPWR.n13 VPWR.n12 12.8005
R67 VPWR.n21 VPWR.n20 12.1406
R68 VPWR.n12 VPWR.n11 9.3005
R69 VPWR.n13 VPWR.n4 9.3005
R70 VPWR.n15 VPWR.n14 9.3005
R71 VPWR.n16 VPWR.n3 9.3005
R72 VPWR.n18 VPWR.n17 9.3005
R73 VPWR.n19 VPWR.n0 9.3005
R74 VPWR.n20 VPWR.n19 6.4005
R75 VPWR.n7 VPWR.n3 6.4005
R76 VPWR.n14 VPWR.n7 6.4005
R77 VPWR.n12 VPWR.n9 6.4005
R78 VPWR.n21 VPWR.n0 0.584022
R79 VPWR.n17 VPWR.n0 0.063
R80 VPWR.n17 VPWR.n16 0.063
R81 VPWR.n16 VPWR.n15 0.063
R82 VPWR.n15 VPWR.n4 0.063
R83 VPWR.n11 VPWR.n4 0.063
R84 VPWR.n11 VPWR.n10 0.063
R85 VPWR.n10 VPWR 0.03175
R86 A.n0 A.t4 303.661
R87 A.n0 A.t5 231.361
R88 A.n1 A.t6 231.361
R89 A.n2 A.t7 231.361
R90 A.n3 A.t8 231.361
R91 A.n4 A.t9 231.361
R92 A.n1 A.t0 207.261
R93 A.n2 A.t1 207.261
R94 A.n3 A.t2 207.261
R95 A.n4 A.t3 207.261
R96 A A.n4 194.55
R97 A.n1 A.n0 72.3005
R98 A.n2 A.n1 72.3005
R99 A.n3 A.n2 72.3005
R100 A.n4 A.n3 72.3005
R101 VPB VPB.t0 302.274
R102 VPB.t4 VPB.t5 259.091
R103 VPB.t3 VPB.t4 259.091
R104 VPB.t2 VPB.t3 259.091
R105 VPB.t1 VPB.t2 259.091
R106 VPB.t0 VPB.t1 259.091
R107 VNB VNB.t0 1400
R108 VNB.t2 VNB.t3 1200
R109 VNB.t1 VNB.t2 1200
R110 VNB.t0 VNB.t1 1200
C10 VGND VNB 0.68772f
C11 Y VNB 0.58986f
C12 VPWR VNB 0.57611f
C13 A VNB 0.67464f
C14 VPB VNB 0.97736f
C15 VPB.t5 VNB 0.10419f
C16 VPB.t4 VNB 0.06252f
C17 VPB.t3 VNB 0.06252f
C18 VPB.t2 VNB 0.06252f
C19 VPB.t1 VNB 0.06252f
C20 VPB.t0 VNB 0.06773f
C21 A.t9 VNB 0.03809f
C22 A.t3 VNB 0.01985f
C23 A.t8 VNB 0.03809f
C24 A.t2 VNB 0.01985f
C25 A.t7 VNB 0.03809f
C26 A.t1 VNB 0.01985f
C27 A.t6 VNB 0.03809f
C28 A.t0 VNB 0.01985f
C29 A.t5 VNB 0.03809f
C30 A.t4 VNB 0.0535f
C31 A.n0 VNB 0.13693f
C32 A.n1 VNB 0.10775f
C33 A.n2 VNB 0.10775f
C34 A.n3 VNB 0.10775f
C35 A.n4 VNB 0.1243f
C36 VPWR.n0 VNB 0.18329f
C37 VPWR.t2 VNB 0.0163f
C38 VPWR.t0 VNB 0.0163f
C39 VPWR.n1 VNB 0.03259f
C40 VPWR.n2 VNB 0.03259f
C41 VPWR.n3 VNB 0.01504f
C42 VPWR.n4 VNB 0.04011f
C43 VPWR.t1 VNB 0.0163f
C44 VPWR.t4 VNB 0.0163f
C45 VPWR.n5 VNB 0.03259f
C46 VPWR.n6 VNB 0.03259f
C47 VPWR.n7 VNB 0.03009f
C48 VPWR.t5 VNB 0.05765f
C49 VPWR.n8 VNB 0.03762f
C50 VPWR.n9 VNB 0.039f
C51 VPWR.n10 VNB 0.03622f
C52 VPWR.n11 VNB 0.04011f
C53 VPWR.n12 VNB 0.01504f
C54 VPWR.n13 VNB 0.02006f
C55 VPWR.n14 VNB 0.01504f
C56 VPWR.n15 VNB 0.04011f
C57 VPWR.n16 VNB 0.04011f
C58 VPWR.n17 VNB 0.04011f
C59 VPWR.n18 VNB 0.02006f
C60 VPWR.n19 VNB 0.01504f
C61 VPWR.n20 VNB 0.04002f
C62 VPWR.n21 VNB 0.09244f
C63 VPWR.t3 VNB 0.05765f
C64 VPWR.n22 VNB 0.0478f
C65 Y.t7 VNB 0.03302f
C66 Y.t9 VNB 0.03302f
C67 Y.n0 VNB 0.07053f
C68 Y.t5 VNB 0.01376f
C69 Y.t8 VNB 0.01376f
C70 Y.n1 VNB 0.02752f
C71 Y.n2 VNB 0.04573f
C72 Y.t0 VNB 0.03302f
C73 Y.t2 VNB 0.03302f
C74 Y.n3 VNB 0.07053f
C75 Y.t1 VNB 0.01376f
C76 Y.t3 VNB 0.01376f
C77 Y.n4 VNB 0.02752f
C78 Y.n5 VNB 0.04573f
C79 Y.t6 VNB 0.03302f
C80 Y.t4 VNB 0.03302f
C81 Y.n6 VNB 0.07053f
C82 Y.n7 VNB 0.19205f
C83 Y.n8 VNB 0.12194f
C84 VGND.t3 VNB 0.01416f
C85 VGND.n0 VNB 0.00952f
C86 VGND.n1 VNB 0.20735f
C87 VGND.t1 VNB 0.0043f
C88 VGND.t2 VNB 0.0043f
C89 VGND.n2 VNB 0.00891f
C90 VGND.t0 VNB 0.01416f
C91 VGND.n3 VNB 0.069f
C92 VGND.n4 VNB 0.01746f
C93 VGND.n5 VNB 0.00952f
C94 VGND.n6 VNB 0.01269f
C95 VGND.n7 VNB 0.02538f
C96 VGND.n8 VNB 0.02538f
C97 VGND.n9 VNB 0.02292f
C98 VGND.n10 VNB 0.01674f
.ends

.subckt sky130_efx_lvdig__clkinv_8 A Y VGND VNB VPB VPWR
X0 Y.t6 A.t3 VGND.t0 VNB.t4 sky130_fd_pr__nfet_01v8 ad=0.08775 pd=0.84 as=0.08775 ps=0.84 w=0.45 l=0.15
X1 VGND.t5 A.t2 Y.t13 VNB.t5 sky130_fd_pr__nfet_01v8 ad=0.08775 pd=0.84 as=0.08775 ps=0.84 w=0.45 l=0.15
X2 VGND.t7 A.t6 Y.t18 VNB.t1 sky130_fd_pr__nfet_01v8 ad=0.08775 pd=0.84 as=0.08775 ps=0.84 w=0.45 l=0.15
X3 Y.t10 A.t5 VGND.t3 VNB.t2 sky130_fd_pr__nfet_01v8 ad=0.08775 pd=0.84 as=0.08775 ps=0.84 w=0.45 l=0.15
X4 VGND.t1 A.t4 Y.t8 VNB.t3 sky130_fd_pr__nfet_01v8 ad=0.08775 pd=0.84 as=0.08775 ps=0.84 w=0.45 l=0.15
X5 VPWR.t4 A.t10 Y.t4 VPB.t9 sky130_fd_pr__pfet_01v8_hvt ad=0.2106 pd=1.47 as=0.2106 ps=1.47 w=1.08 l=0.15
X6 Y.t3 A.t19 VPWR.t3 VPB.t0 sky130_fd_pr__pfet_01v8_hvt ad=0.2106 pd=1.47 as=0.405 ps=2.91 w=1.08 l=0.15
X7 Y.t15 A.t9 VPWR.t9 VPB.t10 sky130_fd_pr__pfet_01v8_hvt ad=0.2106 pd=1.47 as=0.2106 ps=1.47 w=1.08 l=0.15
X8 VPWR.t2 A.t18 Y.t2 VPB.t1 sky130_fd_pr__pfet_01v8_hvt ad=0.2106 pd=1.47 as=0.2106 ps=1.47 w=1.08 l=0.15
X9 VPWR.t11 A.t8 Y.t19 VPB.t11 sky130_fd_pr__pfet_01v8_hvt ad=0.405 pd=2.91 as=0.2106 ps=1.47 w=1.08 l=0.15
X10 Y.t1 A.t17 VPWR.t1 VPB.t2 sky130_fd_pr__pfet_01v8_hvt ad=0.2106 pd=1.47 as=0.2106 ps=1.47 w=1.08 l=0.15
X11 VPWR.t0 A.t16 Y.t0 VPB.t3 sky130_fd_pr__pfet_01v8_hvt ad=0.2106 pd=1.47 as=0.2106 ps=1.47 w=1.08 l=0.15
X12 Y.t17 A.t1 VGND.t6 VNB.t6 sky130_fd_pr__nfet_01v8 ad=0.08775 pd=0.84 as=0.08775 ps=0.84 w=0.45 l=0.15
X13 VGND.t4 A.t0 Y.t12 VNB.t7 sky130_fd_pr__nfet_01v8 ad=0.16875 pd=1.65 as=0.08775 ps=0.84 w=0.45 l=0.15
X14 Y.t14 A.t15 VPWR.t8 VPB.t4 sky130_fd_pr__pfet_01v8_hvt ad=0.2106 pd=1.47 as=0.2106 ps=1.47 w=1.08 l=0.15
X15 Y.t9 A.t7 VGND.t2 VNB.t0 sky130_fd_pr__nfet_01v8 ad=0.08775 pd=0.84 as=0.16875 ps=1.65 w=0.45 l=0.15
X16 VPWR.t6 A.t14 Y.t7 VPB.t5 sky130_fd_pr__pfet_01v8_hvt ad=0.2106 pd=1.47 as=0.2106 ps=1.47 w=1.08 l=0.15
X17 Y.t5 A.t13 VPWR.t5 VPB.t6 sky130_fd_pr__pfet_01v8_hvt ad=0.2106 pd=1.47 as=0.2106 ps=1.47 w=1.08 l=0.15
X18 VPWR.t7 A.t12 Y.t11 VPB.t7 sky130_fd_pr__pfet_01v8_hvt ad=0.2106 pd=1.47 as=0.2106 ps=1.47 w=1.08 l=0.15
X19 Y.t16 A.t11 VPWR.t10 VPB.t8 sky130_fd_pr__pfet_01v8_hvt ad=0.2106 pd=1.47 as=0.2106 ps=1.47 w=1.08 l=0.15
C0 VPWR VPB 0.24483f
C1 VGND A 0.23015f
C2 Y VPWR 1.54119f
C3 VGND VPB 0.01141f
C4 A VPB 0.5589f
C5 Y VGND 0.6489f
C6 Y A 0.67362f
C7 VPWR VGND 0.14227f
C8 Y VPB 0.04648f
C9 VPWR A 0.40455f
R0 VGND VGND.t4 243.4
R1 VGND VGND.t2 243.4
R2 VGND VGND.n7 191.4
R3 VGND VGND.n5 191.4
R4 VGND VGND.n2 191.4
R5 VGND.n7 VGND.t6 52.0005
R6 VGND.n7 VGND.t5 52.0005
R7 VGND.n5 VGND.t0 52.0005
R8 VGND.n5 VGND.t1 52.0005
R9 VGND.n2 VGND.t3 52.0005
R10 VGND.n2 VGND.t7 52.0005
R11 VGND.n26 VGND.n25 15.7005
R12 VGND.n9 VGND 15.5801
R13 VGND.n12 VGND.n6 12.8005
R14 VGND.n13 VGND.n12 12.8005
R15 VGND.n15 VGND.n3 12.8005
R16 VGND.n19 VGND.n3 12.8005
R17 VGND.n22 VGND.n21 12.8005
R18 VGND.n22 VGND.n0 12.8005
R19 VGND.n9 VGND.n8 12.1847
R20 VGND.n8 VGND 9.6005
R21 VGND.n14 VGND 9.6005
R22 VGND.n20 VGND 9.6005
R23 VGND VGND.n26 9.6005
R24 VGND.n24 VGND.n0 9.3005
R25 VGND.n23 VGND.n22 9.3005
R26 VGND.n21 VGND.n1 9.3005
R27 VGND.n19 VGND.n18 9.3005
R28 VGND.n17 VGND.n3 9.3005
R29 VGND.n16 VGND.n15 9.3005
R30 VGND.n13 VGND.n4 9.3005
R31 VGND.n12 VGND.n11 9.3005
R32 VGND.n10 VGND.n6 9.3005
R33 VGND.n8 VGND.n6 6.4005
R34 VGND.n14 VGND.n13 6.4005
R35 VGND.n15 VGND.n14 6.4005
R36 VGND.n20 VGND.n19 6.4005
R37 VGND.n21 VGND.n20 6.4005
R38 VGND.n26 VGND.n0 6.4005
R39 VGND.n10 VGND.n9 0.53658
R40 VGND.n11 VGND.n10 0.063
R41 VGND.n11 VGND.n4 0.063
R42 VGND.n16 VGND.n4 0.063
R43 VGND.n17 VGND.n16 0.063
R44 VGND.n18 VGND.n17 0.063
R45 VGND.n18 VGND.n1 0.063
R46 VGND.n23 VGND.n1 0.063
R47 VGND.n24 VGND.n23 0.063
R48 VGND.n25 VGND.n24 0.063
R49 VGND.n25 VGND 0.03175
R50 Y Y.n13 308.5
R51 Y Y.n12 308.5
R52 Y Y.n9 308.5
R53 Y Y.n6 308.5
R54 Y Y.n3 308.5
R55 Y Y.n0 308.5
R56 Y.n11 Y.n10 185
R57 Y.n8 Y.n7 185
R58 Y.n5 Y.n4 185
R59 Y.n2 Y.n1 185
R60 Y.n10 Y.t12 52.0005
R61 Y.n10 Y.t17 52.0005
R62 Y.n7 Y.t13 52.0005
R63 Y.n7 Y.t6 52.0005
R64 Y.n4 Y.t8 52.0005
R65 Y.n4 Y.t10 52.0005
R66 Y.n1 Y.t18 52.0005
R67 Y.n1 Y.t9 52.0005
R68 Y.n14 Y 48.0005
R69 Y.n15 Y.n14 38.4005
R70 Y.n16 Y.n15 38.4005
R71 Y.n17 Y.n16 38.4005
R72 Y.n18 Y.n17 38.4005
R73 Y.n13 Y.t19 35.5699
R74 Y.n13 Y.t15 35.5699
R75 Y.n12 Y.t4 35.5699
R76 Y.n12 Y.t16 35.5699
R77 Y.n9 Y.t11 35.5699
R78 Y.n9 Y.t5 35.5699
R79 Y.n6 Y.t7 35.5699
R80 Y.n6 Y.t14 35.5699
R81 Y.n3 Y.t0 35.5699
R82 Y.n3 Y.t1 35.5699
R83 Y.n0 Y.t2 35.5699
R84 Y.n0 Y.t3 35.5699
R85 Y.n15 Y.n11 22.4005
R86 Y.n16 Y.n8 22.4005
R87 Y.n17 Y.n5 22.4005
R88 Y.n18 Y.n2 22.4005
R89 Y.n14 Y 9.6005
R90 Y.n15 Y 9.6005
R91 Y.n16 Y 9.6005
R92 Y.n17 Y 9.6005
R93 Y Y.n18 9.6005
R94 Y.n11 Y 6.4005
R95 Y.n8 Y 6.4005
R96 Y.n5 Y 6.4005
R97 Y.n2 Y 6.4005
R98 Y.n18 Y 6.4005
R99 VPWR.n20 VPWR.t3 328.07
R100 VPWR.n49 VPWR.t11 328.07
R101 VPWR.n17 VPWR.n16 292.5
R102 VPWR.n13 VPWR.n12 292.5
R103 VPWR.n9 VPWR.n8 292.5
R104 VPWR.n6 VPWR.n5 292.5
R105 VPWR.n2 VPWR.n1 292.5
R106 VPWR.n16 VPWR.t1 35.5699
R107 VPWR.n16 VPWR.t2 35.5699
R108 VPWR.n12 VPWR.t8 35.5699
R109 VPWR.n12 VPWR.t0 35.5699
R110 VPWR.n8 VPWR.t5 35.5699
R111 VPWR.n8 VPWR.t6 35.5699
R112 VPWR.n5 VPWR.t10 35.5699
R113 VPWR.n5 VPWR.t7 35.5699
R114 VPWR.n1 VPWR.t9 35.5699
R115 VPWR.n1 VPWR.t4 35.5699
R116 VPWR.n49 VPWR.n48 32.2074
R117 VPWR.n21 VPWR.n20 25.6005
R118 VPWR.n18 VPWR.n17 25.6005
R119 VPWR.n14 VPWR.n13 25.6005
R120 VPWR.n10 VPWR.n9 25.6005
R121 VPWR.n7 VPWR.n6 25.6005
R122 VPWR.n47 VPWR.n2 25.6005
R123 VPWR.n20 VPWR 16.0005
R124 VPWR.n17 VPWR 16.0005
R125 VPWR.n13 VPWR 16.0005
R126 VPWR.n9 VPWR 16.0005
R127 VPWR.n6 VPWR 16.0005
R128 VPWR.n2 VPWR 16.0005
R129 VPWR VPWR.n49 16.0005
R130 VPWR.n22 VPWR.n21 15.7005
R131 VPWR.n46 VPWR.n45 12.8005
R132 VPWR.n45 VPWR.n3 12.8005
R133 VPWR.n41 VPWR.n40 12.8005
R134 VPWR.n40 VPWR.n39 12.8005
R135 VPWR.n36 VPWR.n35 12.8005
R136 VPWR.n35 VPWR.n34 12.8005
R137 VPWR.n31 VPWR.n30 12.8005
R138 VPWR.n30 VPWR.n29 12.8005
R139 VPWR.n26 VPWR.n25 12.8005
R140 VPWR.n25 VPWR.n24 12.8005
R141 VPWR.n48 VPWR.n47 12.1406
R142 VPWR.n24 VPWR.n23 9.3005
R143 VPWR.n25 VPWR.n19 9.3005
R144 VPWR.n27 VPWR.n26 9.3005
R145 VPWR.n29 VPWR.n28 9.3005
R146 VPWR.n30 VPWR.n15 9.3005
R147 VPWR.n32 VPWR.n31 9.3005
R148 VPWR.n34 VPWR.n33 9.3005
R149 VPWR.n35 VPWR.n11 9.3005
R150 VPWR.n37 VPWR.n36 9.3005
R151 VPWR.n39 VPWR.n38 9.3005
R152 VPWR.n40 VPWR.n4 9.3005
R153 VPWR.n42 VPWR.n41 9.3005
R154 VPWR.n43 VPWR.n3 9.3005
R155 VPWR.n45 VPWR.n44 9.3005
R156 VPWR.n46 VPWR.n0 9.3005
R157 VPWR.n47 VPWR.n46 6.4005
R158 VPWR.n7 VPWR.n3 6.4005
R159 VPWR.n41 VPWR.n7 6.4005
R160 VPWR.n39 VPWR.n10 6.4005
R161 VPWR.n36 VPWR.n10 6.4005
R162 VPWR.n34 VPWR.n14 6.4005
R163 VPWR.n31 VPWR.n14 6.4005
R164 VPWR.n29 VPWR.n18 6.4005
R165 VPWR.n26 VPWR.n18 6.4005
R166 VPWR.n24 VPWR.n21 6.4005
R167 VPWR.n48 VPWR.n0 0.584022
R168 VPWR.n44 VPWR.n0 0.063
R169 VPWR.n44 VPWR.n43 0.063
R170 VPWR.n43 VPWR.n42 0.063
R171 VPWR.n42 VPWR.n4 0.063
R172 VPWR.n38 VPWR.n4 0.063
R173 VPWR.n38 VPWR.n37 0.063
R174 VPWR.n37 VPWR.n11 0.063
R175 VPWR.n33 VPWR.n11 0.063
R176 VPWR.n33 VPWR.n32 0.063
R177 VPWR.n32 VPWR.n15 0.063
R178 VPWR.n28 VPWR.n15 0.063
R179 VPWR.n28 VPWR.n27 0.063
R180 VPWR.n27 VPWR.n19 0.063
R181 VPWR.n23 VPWR.n19 0.063
R182 VPWR.n23 VPWR.n22 0.063
R183 VPWR.n22 VPWR 0.03175
R184 A.n0 A.t8 303.661
R185 A.n0 A.t9 231.361
R186 A.n1 A.t10 231.361
R187 A.n2 A.t11 231.361
R188 A.n3 A.t12 231.361
R189 A.n4 A.t13 231.361
R190 A.n5 A.t14 231.361
R191 A.n6 A.t15 231.361
R192 A.n7 A.t16 231.361
R193 A.n8 A.t17 231.361
R194 A.n9 A.t18 231.361
R195 A.n10 A.t19 231.361
R196 A.n3 A.t0 207.261
R197 A.n4 A.t1 207.261
R198 A.n5 A.t2 207.261
R199 A.n6 A.t3 207.261
R200 A.n7 A.t4 207.261
R201 A.n8 A.t5 207.261
R202 A.n9 A.t6 207.261
R203 A.n10 A.t7 207.261
R204 A A.n10 194.55
R205 A.n1 A.n0 72.3005
R206 A.n2 A.n1 72.3005
R207 A.n3 A.n2 72.3005
R208 A.n4 A.n3 72.3005
R209 A.n5 A.n4 72.3005
R210 A.n6 A.n5 72.3005
R211 A.n7 A.n6 72.3005
R212 A.n8 A.n7 72.3005
R213 A.n9 A.n8 72.3005
R214 A.n10 A.n9 72.3005
R215 VPB VPB.t0 302.274
R216 VPB.t10 VPB.t11 259.091
R217 VPB.t9 VPB.t10 259.091
R218 VPB.t8 VPB.t9 259.091
R219 VPB.t7 VPB.t8 259.091
R220 VPB.t6 VPB.t7 259.091
R221 VPB.t5 VPB.t6 259.091
R222 VPB.t4 VPB.t5 259.091
R223 VPB.t3 VPB.t4 259.091
R224 VPB.t2 VPB.t3 259.091
R225 VPB.t1 VPB.t2 259.091
R226 VPB.t0 VPB.t1 259.091
R227 VNB VNB.t0 1400
R228 VNB.t6 VNB.t7 1200
R229 VNB.t5 VNB.t6 1200
R230 VNB.t4 VNB.t5 1200
R231 VNB.t3 VNB.t4 1200
R232 VNB.t2 VNB.t3 1200
R233 VNB.t1 VNB.t2 1200
R234 VNB.t0 VNB.t1 1200
C10 VGND VNB 1.11243f
C11 Y VNB 1.04698f
C12 VPWR VNB 0.88694f
C13 A VNB 1.18232f
C14 VPB VNB 1.74842f
C15 VPB.t11 VNB 0.1077f
C16 VPB.t10 VNB 0.06462f
C17 VPB.t9 VNB 0.06462f
C18 VPB.t8 VNB 0.06462f
C19 VPB.t7 VNB 0.06462f
C20 VPB.t6 VNB 0.06462f
C21 VPB.t5 VNB 0.06462f
C22 VPB.t4 VNB 0.06462f
C23 VPB.t3 VNB 0.06462f
C24 VPB.t2 VNB 0.06462f
C25 VPB.t1 VNB 0.06462f
C26 VPB.t0 VNB 0.07001f
C27 A.t19 VNB 0.03795f
C28 A.t7 VNB 0.01978f
C29 A.t18 VNB 0.03795f
C30 A.t6 VNB 0.01978f
C31 A.t17 VNB 0.03795f
C32 A.t5 VNB 0.01978f
C33 A.t16 VNB 0.03795f
C34 A.t4 VNB 0.01978f
C35 A.t15 VNB 0.03795f
C36 A.t3 VNB 0.01978f
C37 A.t14 VNB 0.03795f
C38 A.t2 VNB 0.01978f
C39 A.t13 VNB 0.03795f
C40 A.t1 VNB 0.01978f
C41 A.t12 VNB 0.03795f
C42 A.t0 VNB 0.01978f
C43 A.t11 VNB 0.03795f
C44 A.t10 VNB 0.03795f
C45 A.t9 VNB 0.03795f
C46 A.t8 VNB 0.05331f
C47 A.n0 VNB 0.13645f
C48 A.n1 VNB 0.08729f
C49 A.n2 VNB 0.08729f
C50 A.n3 VNB 0.10736f
C51 A.n4 VNB 0.10736f
C52 A.n5 VNB 0.10736f
C53 A.n6 VNB 0.10736f
C54 A.n7 VNB 0.10736f
C55 A.n8 VNB 0.10736f
C56 A.n9 VNB 0.10736f
C57 A.n10 VNB 0.12385f
C58 VPWR.n0 VNB 0.19924f
C59 VPWR.t9 VNB 0.01771f
C60 VPWR.t4 VNB 0.01771f
C61 VPWR.n1 VNB 0.03543f
C62 VPWR.n2 VNB 0.03543f
C63 VPWR.n3 VNB 0.01635f
C64 VPWR.n4 VNB 0.0436f
C65 VPWR.t10 VNB 0.01771f
C66 VPWR.t7 VNB 0.01771f
C67 VPWR.n5 VNB 0.03543f
C68 VPWR.n6 VNB 0.03543f
C69 VPWR.n7 VNB 0.0327f
C70 VPWR.t5 VNB 0.01771f
C71 VPWR.t6 VNB 0.01771f
C72 VPWR.n8 VNB 0.03543f
C73 VPWR.n9 VNB 0.03543f
C74 VPWR.n10 VNB 0.0327f
C75 VPWR.n11 VNB 0.0436f
C76 VPWR.t8 VNB 0.01771f
C77 VPWR.t0 VNB 0.01771f
C78 VPWR.n12 VNB 0.03543f
C79 VPWR.n13 VNB 0.03543f
C80 VPWR.n14 VNB 0.0327f
C81 VPWR.n15 VNB 0.0436f
C82 VPWR.t1 VNB 0.01771f
C83 VPWR.t2 VNB 0.01771f
C84 VPWR.n16 VNB 0.03543f
C85 VPWR.n17 VNB 0.03543f
C86 VPWR.n18 VNB 0.0327f
C87 VPWR.n19 VNB 0.0436f
C88 VPWR.t3 VNB 0.06267f
C89 VPWR.n20 VNB 0.0409f
C90 VPWR.n21 VNB 0.04239f
C91 VPWR.n22 VNB 0.03937f
C92 VPWR.n23 VNB 0.0436f
C93 VPWR.n24 VNB 0.01635f
C94 VPWR.n25 VNB 0.0218f
C95 VPWR.n26 VNB 0.01635f
C96 VPWR.n27 VNB 0.0436f
C97 VPWR.n28 VNB 0.0436f
C98 VPWR.n29 VNB 0.01635f
C99 VPWR.n30 VNB 0.0218f
C100 VPWR.n31 VNB 0.01635f
C101 VPWR.n32 VNB 0.0436f
C102 VPWR.n33 VNB 0.0436f
C103 VPWR.n34 VNB 0.01635f
C104 VPWR.n35 VNB 0.0218f
C105 VPWR.n36 VNB 0.01635f
C106 VPWR.n37 VNB 0.0436f
C107 VPWR.n38 VNB 0.0436f
C108 VPWR.n39 VNB 0.01635f
C109 VPWR.n40 VNB 0.0218f
C110 VPWR.n41 VNB 0.01635f
C111 VPWR.n42 VNB 0.0436f
C112 VPWR.n43 VNB 0.0436f
C113 VPWR.n44 VNB 0.0436f
C114 VPWR.n45 VNB 0.0218f
C115 VPWR.n46 VNB 0.01635f
C116 VPWR.n47 VNB 0.0435f
C117 VPWR.n48 VNB 0.10048f
C118 VPWR.t11 VNB 0.06267f
C119 VPWR.n49 VNB 0.05196f
C120 Y.t2 VNB 0.03288f
C121 Y.t3 VNB 0.03288f
C122 Y.n0 VNB 0.07022f
C123 Y.t18 VNB 0.0137f
C124 Y.t9 VNB 0.0137f
C125 Y.n1 VNB 0.0274f
C126 Y.n2 VNB 0.04552f
C127 Y.t0 VNB 0.03288f
C128 Y.t1 VNB 0.03288f
C129 Y.n3 VNB 0.07022f
C130 Y.t8 VNB 0.0137f
C131 Y.t10 VNB 0.0137f
C132 Y.n4 VNB 0.0274f
C133 Y.n5 VNB 0.04552f
C134 Y.t7 VNB 0.03288f
C135 Y.t14 VNB 0.03288f
C136 Y.n6 VNB 0.07022f
C137 Y.t13 VNB 0.0137f
C138 Y.t6 VNB 0.0137f
C139 Y.n7 VNB 0.0274f
C140 Y.n8 VNB 0.04552f
C141 Y.t11 VNB 0.03288f
C142 Y.t5 VNB 0.03288f
C143 Y.n9 VNB 0.07022f
C144 Y.t12 VNB 0.0137f
C145 Y.t17 VNB 0.0137f
C146 Y.n10 VNB 0.0274f
C147 Y.n11 VNB 0.04552f
C148 Y.t4 VNB 0.03288f
C149 Y.t16 VNB 0.03288f
C150 Y.n12 VNB 0.07022f
C151 Y.t19 VNB 0.03288f
C152 Y.t15 VNB 0.03288f
C153 Y.n13 VNB 0.07022f
C154 Y.n14 VNB 0.15579f
C155 Y.n15 VNB 0.17198f
C156 Y.n16 VNB 0.17198f
C157 Y.n17 VNB 0.17198f
C158 Y.n18 VNB 0.1214f
C159 VGND.t2 VNB 0.01528f
C160 VGND.n0 VNB 0.01027f
C161 VGND.n1 VNB 0.02739f
C162 VGND.t3 VNB 0.00464f
C163 VGND.t7 VNB 0.00464f
C164 VGND.n2 VNB 0.00962f
C165 VGND.n3 VNB 0.01369f
C166 VGND.n4 VNB 0.02739f
C167 VGND.t0 VNB 0.00464f
C168 VGND.t1 VNB 0.00464f
C169 VGND.n5 VNB 0.00962f
C170 VGND.n6 VNB 0.01027f
C171 VGND.t4 VNB 0.01528f
C172 VGND.t6 VNB 0.00464f
C173 VGND.t5 VNB 0.00464f
C174 VGND.n7 VNB 0.00962f
C175 VGND.n8 VNB 0.01884f
C176 VGND.n9 VNB 0.09482f
C177 VGND.n10 VNB 0.32559f
C178 VGND.n11 VNB 0.02739f
C179 VGND.n12 VNB 0.01369f
C180 VGND.n13 VNB 0.01027f
C181 VGND.n14 VNB 0.01198f
C182 VGND.n15 VNB 0.01027f
C183 VGND.n16 VNB 0.02739f
C184 VGND.n17 VNB 0.02739f
C185 VGND.n18 VNB 0.02739f
C186 VGND.n19 VNB 0.01027f
C187 VGND.n20 VNB 0.01198f
C188 VGND.n21 VNB 0.01027f
C189 VGND.n22 VNB 0.01369f
C190 VGND.n23 VNB 0.02739f
C191 VGND.n24 VNB 0.02739f
C192 VGND.n25 VNB 0.02473f
C193 VGND.n26 VNB 0.01807f
.ends

.subckt sky130_efx_lvdig__conb_1 HI LO VGND VNB VPB VPWR
X0 LO.t0 VGND.t0 sky130_fd_pr__res_generic_po w=0.45 l=0.54
X1 VPWR.t0 HI.t0 sky130_fd_pr__res_generic_po w=0.45 l=0.54
C0 VPWR LO 0.00121f
C1 VPB LO 0.00575f
C2 VGND LO 0.01662f
C3 HI LO 0.03836f
C4 VPWR VPB 0.09955f
C5 VPWR VGND 0.0242f
C6 VPWR HI 0.01662f
C7 VPB VGND 0.01152f
C8 HI VPB 0.04337f
C9 HI VGND 0.00121f
R0 VGND VGND.t0 182.804
R1 LO LO.t0 177.68
R2 HI HI.t0 177.68
R3 VPWR VPWR.t0 182.804
C10 VGND VNB 0.38784f
C11 LO VNB 0.12581f
C12 HI VNB 0.10616f
C13 VPWR VNB 0.37798f
C14 VPB VNB 0.41679f
C15 VPWR.t0 VNB 0.01585f
C16 HI.t0 VNB 0.05201f
C17 LO.t0 VNB 0.03235f
C18 VGND.t0 VNB 0.006f
.ends

.subckt sky130_efx_lvdig__decap10 VGND VNB VPB VPWR
X0 VPWR.t1 VGND.t2 VPWR.t0 VPB.t0 sky130_fd_pr__pfet_01v8_hvt ad=0.324 pd=2.52 as=0 ps=0 w=0.9 l=0.72
X1 VGND.t1 VPWR.t2 VGND.t0 VNB.t0 sky130_fd_pr__nfet_01v8 ad=0.2268 pd=1.98 as=0 ps=0 w=0.63 l=0.72
C0 VPWR VPB 0.09704f
C1 VGND VPB 0.12613f
C2 VGND VPWR 0.42724f
R0 VPWR.n1 VPWR.t1 361.007
R1 VPWR.n0 VPWR.t0 331.901
R2 VPWR.n0 VPWR.t2 319.938
R3 VPWR.n1 VPWR.n0 29.2571
R4 VPWR VPWR.n1 0.354563
R5 VGND.n0 VGND.t2 322.575
R6 VGND.n1 VGND.t0 245.343
R7 VGND.n0 VGND.t1 219.286
R8 VGND.n1 VGND.n0 25.9067
R9 VGND VGND.n1 0.354563
R10 VPB VPB.t0 431.818
R11 VNB VNB.t0 2000
C3 VPWR VNB 0.69168f
C4 VGND VNB 0.65819f
C5 VPB VNB 0.48347f
C6 VPB.t0 VNB 0.16738f
C7 VGND.t2 VNB 0.10142f
C8 VGND.t1 VNB 0.02692f
C9 VGND.n0 VNB 0.09068f
C10 VGND.t0 VNB 0.03121f
C11 VGND.n1 VNB 0.15229f
C12 VPWR.t1 VNB 0.03957f
C13 VPWR.t2 VNB 0.0711f
C14 VPWR.t0 VNB 0.03591f
C15 VPWR.n0 VNB 0.08927f
C16 VPWR.n1 VNB 0.15196f
.ends

.subckt sky130_efx_lvdig__decap20 VGND VNB VPB VPWR
X0 VPWR.t1 VGND.t2 VPWR.t0 VPB.t0 sky130_fd_pr__pfet_01v8_hvt ad=0.324 pd=2.52 as=0 ps=0 w=0.9 l=2.52
X1 VGND.t1 VPWR.t2 VGND.t0 VNB.t0 sky130_fd_pr__nfet_01v8 ad=0.2268 pd=1.98 as=0 ps=0 w=0.63 l=2.52
C0 VPWR VPB 0.13934f
C1 VGND VPB 0.26411f
C2 VGND VPWR 0.97973f
R0 VPWR.n1 VPWR.t1 361.276
R1 VPWR.n0 VPWR.t0 331.901
R2 VPWR.n0 VPWR.t2 151.746
R3 VPWR.n1 VPWR.n0 29.84
R4 VPWR VPWR.n1 0.0849957
R5 VGND.n1 VGND.t0 245.925
R6 VGND.n0 VGND.t1 219.286
R7 VGND.n0 VGND.t2 133.714
R8 VGND.n1 VGND.n0 26.1752
R9 VGND VGND.n1 0.0849957
R10 VPB VPB.t0 863.636
R11 VNB VNB.t0 4000
C3 VPWR VNB 0.9367f
C4 VGND VNB 0.79709f
C5 VPB VNB 0.95622f
C6 VPB.t0 VNB 0.30259f
C7 VGND.t2 VNB 0.36492f
C8 VGND.t1 VNB 0.03014f
C9 VGND.n0 VNB 0.18274f
C10 VGND.t0 VNB 0.0356f
C11 VGND.n1 VNB 0.58199f
C12 VPWR.t1 VNB 0.04577f
C13 VPWR.t2 VNB 0.2462f
C14 VPWR.t0 VNB 0.04144f
C15 VPWR.n0 VNB 0.18434f
C16 VPWR.n1 VNB 0.55613f
.ends

.subckt sky130_efx_lvdig__dfbbp_1 CLK D RESET_B SET_B Q Q_N VGND VNB VPB VPWR
X0 a_3093_378.t1 a_2229_36.t5 a_2583_327.t1 VPB.t14 sky130_fd_pr__pfet_01v8_hvt ad=0.15795 pd=1.2 as=0.13725 ps=1.2 w=0.81 l=0.15
X1 a_3813_36.t1 a_2583_327.t4 VGND.t11 VNB.t19 sky130_fd_pr__nfet_01v8 ad=0.16875 pd=1.65 as=0.16875 ps=1.65 w=0.45 l=0.15
X2 Q.t0 a_3813_36.t3 VPWR.t6 VPB.t8 sky130_fd_pr__pfet_01v8_hvt ad=0.405 pd=2.91 as=0.405 ps=2.91 w=1.08 l=0.15
X3 a_1509_378.t1 a_1296_440.t5 VPWR.t12 VPB.t18 sky130_fd_pr__pfet_01v8_hvt ad=0.15795 pd=1.2 as=0.30375 ps=2.37 w=0.81 l=0.15
X4 VPWR.t3 a_1296_440.t3 a_3093_378.t0 VPB.t3 sky130_fd_pr__pfet_01v8_hvt ad=0.30375 pd=2.37 as=0.15795 ps=1.2 w=0.81 l=0.15
X5 Q_N.t0 a_2583_327.t8 VPWR.t5 VPB.t6 sky130_fd_pr__pfet_01v8_hvt ad=0.405 pd=2.91 as=0.405 ps=2.91 w=1.08 l=0.15
X6 a_969_450.t1 a_141_36.t6 a_753_36.t3 VPB.t13 sky130_fd_pr__pfet_01v8_hvt ad=0.16875 pd=1.2 as=0.20925 ps=1.38 w=0.45 l=0.15
X7 VPWR.t7 a_1088_165.t7 a_969_450.t0 VPB.t9 sky130_fd_pr__pfet_01v8_hvt ad=0.16875 pd=1.65 as=0.16875 ps=1.2 w=0.45 l=0.15
X8 a_2985_36.t0 SET_B.t0 VGND.t7 VNB.t1 sky130_fd_pr__nfet_01v8 ad=0.1125 pd=1.02 as=0.16875 ps=1.65 w=0.45 l=0.15
X9 a_141_36.t1 CLK.t1 VPWR.t9 VPB.t16 sky130_fd_pr__pfet_01v8_hvt ad=0.23625 pd=2.01 as=0.23625 ps=2.01 w=0.63 l=0.15
X10 a_1088_165.t3 a_753_36.t5 a_1509_378.t0 VPB.t2 sky130_fd_pr__pfet_01v8_hvt ad=0.13725 pd=1.2 as=0.15795 ps=1.2 w=0.81 l=0.15
X11 a_645_36.t1 D.t0 VGND.t10 VNB.t8 sky130_fd_pr__nfet_01v8 ad=0.08258 pd=0.84 as=0.16875 ps=1.65 w=0.45 l=0.15
X12 a_753_36.t2 a_141_36.t3 a_645_36.t3 VNB.t9 sky130_fd_pr__special_nfet_01v8 ad=0.1674 pd=1.29 as=0.08258 ps=0.84 w=0.36 l=0.15
X13 a_2445_450.t0 a_393_36.t4 a_2229_36.t2 VPB.t15 sky130_fd_pr__pfet_01v8_hvt ad=0.16875 pd=1.2 as=0.20925 ps=1.38 w=0.45 l=0.15
X14 a_2583_327.t0 a_2229_36.t4 a_2985_36.t2 VNB.t15 sky130_fd_pr__nfet_01v8 ad=0.12285 pd=1.02 as=0.1125 ps=1.02 w=0.63 l=0.15
X15 a_2985_36.t1 a_1296_440.t2 a_2583_327.t3 VNB.t6 sky130_fd_pr__nfet_01v8 ad=0.23625 pd=2.01 as=0.12285 ps=1.02 w=0.63 l=0.15
X16 a_2085_36.t1 a_1088_165.t4 VGND.t8 VNB.t16 sky130_fd_pr__nfet_01v8 ad=0.13972 pd=1.2 as=0.23625 ps=2.01 w=0.63 l=0.15
X17 Q.t1 a_3813_36.t2 VGND.t5 VNB.t14 sky130_fd_pr__nfet_01v8 ad=0.23625 pd=2.01 as=0.23625 ps=2.01 w=0.63 l=0.15
X18 a_1296_440.t1 RESET_B.t1 VPWR.t11 VPB.t17 sky130_fd_pr__pfet_01v8_hvt ad=0.23625 pd=2.01 as=0.23625 ps=2.01 w=0.63 l=0.15
X19 a_3813_36.t0 a_2583_327.t7 VPWR.t10 VPB.t12 sky130_fd_pr__pfet_01v8_hvt ad=0.23625 pd=2.01 as=0.23625 ps=2.01 w=0.63 l=0.15
X20 a_141_36.t0 CLK.t0 VGND.t0 VNB.t11 sky130_fd_pr__nfet_01v8 ad=0.16875 pd=1.65 as=0.16875 ps=1.65 w=0.45 l=0.15
X21 a_393_36.t0 a_141_36.t7 VPWR.t8 VPB.t10 sky130_fd_pr__pfet_01v8_hvt ad=0.23625 pd=2.01 as=0.23625 ps=2.01 w=0.63 l=0.15
X22 a_969_36.t0 a_393_36.t3 a_753_36.t1 VNB.t7 sky130_fd_pr__special_nfet_01v8 ad=0.15593 pd=1.2 as=0.1674 ps=1.29 w=0.36 l=0.15
X23 VGND.t9 a_1088_165.t5 a_969_36.t1 VNB.t17 sky130_fd_pr__nfet_01v8 ad=0.16875 pd=1.65 as=0.15593 ps=1.2 w=0.45 l=0.15
X24 Q_N.t1 a_2583_327.t5 VGND.t2 VNB.t4 sky130_fd_pr__nfet_01v8 ad=0.23625 pd=2.01 as=0.23625 ps=2.01 w=0.63 l=0.15
X25 a_2583_327.t2 SET_B.t2 VPWR.t1 VPB.t1 sky130_fd_pr__pfet_01v8_hvt ad=0.13725 pd=1.2 as=0.16875 ps=1.65 w=0.45 l=0.15
X26 a_2445_36.t1 a_141_36.t2 a_2229_36.t3 VNB.t10 sky130_fd_pr__special_nfet_01v8 ad=0.15593 pd=1.2 as=0.1674 ps=1.29 w=0.36 l=0.15
X27 a_645_36.t2 D.t1 VPWR.t2 VPB.t11 sky130_fd_pr__pfet_01v8_hvt ad=0.08775 pd=0.84 as=0.16875 ps=1.65 w=0.45 l=0.15
X28 a_2229_36.t1 a_393_36.t2 a_2085_36.t0 VNB.t5 sky130_fd_pr__special_nfet_01v8 ad=0.1674 pd=1.29 as=0.13972 ps=1.2 w=0.36 l=0.15
X29 a_1296_440.t0 RESET_B.t0 VGND.t4 VNB.t13 sky130_fd_pr__nfet_01v8 ad=0.16875 pd=1.65 as=0.16875 ps=1.65 w=0.45 l=0.15
X30 a_2085_378.t0 a_1088_165.t6 VPWR.t4 VPB.t4 sky130_fd_pr__pfet_01v8_hvt ad=0.17775 pd=1.38 as=0.30375 ps=2.37 w=0.81 l=0.15
X31 a_2229_36.t0 a_141_36.t4 a_2085_378.t1 VPB.t7 sky130_fd_pr__pfet_01v8_hvt ad=0.20925 pd=1.38 as=0.17775 ps=1.38 w=0.45 l=0.15
X32 VPWR.t0 SET_B.t3 a_1088_165.t0 VPB.t0 sky130_fd_pr__pfet_01v8_hvt ad=0.16875 pd=1.65 as=0.13725 ps=1.2 w=0.45 l=0.15
X33 a_753_36.t0 a_393_36.t5 a_645_36.t0 VPB.t5 sky130_fd_pr__pfet_01v8_hvt ad=0.20925 pd=1.38 as=0.08775 ps=0.84 w=0.45 l=0.15
X34 a_393_36.t1 a_141_36.t5 VGND.t3 VNB.t12 sky130_fd_pr__nfet_01v8 ad=0.16875 pd=1.65 as=0.16875 ps=1.65 w=0.45 l=0.15
X35 VGND.t1 a_2583_327.t6 a_2445_36.t0 VNB.t2 sky130_fd_pr__nfet_01v8 ad=0.16875 pd=1.65 as=0.15593 ps=1.2 w=0.45 l=0.15
X36 VPWR.t13 a_2583_327.t9 a_2445_450.t1 VPB.t19 sky130_fd_pr__pfet_01v8_hvt ad=0.16875 pd=1.65 as=0.16875 ps=1.2 w=0.45 l=0.15
X37 VGND.t6 SET_B.t1 a_1404_36.t0 VNB.t0 sky130_fd_pr__nfet_01v8 ad=0.16875 pd=1.65 as=0.1125 ps=1.02 w=0.45 l=0.15
X38 a_1088_165.t1 a_1296_440.t4 a_1404_36.t1 VNB.t3 sky130_fd_pr__nfet_01v8 ad=0.12285 pd=1.02 as=0.23625 ps=2.01 w=0.63 l=0.15
X39 a_1404_36.t2 a_753_36.t4 a_1088_165.t2 VNB.t18 sky130_fd_pr__nfet_01v8 ad=0.1125 pd=1.02 as=0.12285 ps=1.02 w=0.63 l=0.15
C0 VGND CLK 0.04537f
C1 CLK VPB 0.09785f
C2 VGND VPWR 0.06538f
C4 VPB VPWR 0.97198f
C5 CLK VPWR 0.04196f
C6 VGND Q 0.12455f
C7 VGND RESET_B 0.0448f
C8 VGND SET_B 0.8464f
C9 VPB Q 0.01836f
C10 D VGND 0.03533f
C11 VPB RESET_B 0.10492f
C12 VPB SET_B 0.24074f
C13 D VPB 0.11625f
C14 Q VPWR 0.15785f
C15 RESET_B VPWR 0.03681f
C16 SET_B VPWR 0.0429f
C17 VGND Q_N 0.12455f
C18 D VPWR 0.03564f
C19 VPB Q_N 0.01998f
C20 Q_N VPWR 0.15785f
C21 RESET_B Q 0.02636f
C23 VGND VPB 0.05087f
R0 Q Q.t0 344.07
R1 Q.n0 Q.t1 222.143
R2 Q Q.n0 19.2005
R3 Q.n0 Q 9.6005
R4 Q_N Q_N.t0 344.07
R5 Q_N.n0 Q_N.t1 222.143
R6 Q_N Q_N.n0 19.2005
R7 Q_N.n0 Q_N 9.6005
R8 RESET_B.n0 RESET_B.t1 319.728
R9 RESET_B.n0 RESET_B.t0 232.968
R10 RESET_B RESET_B.n0 158.4
R11 VGND.n4 VGND.t4 259.339
R12 VGND.n103 VGND.t7 253
R13 VGND.n27 VGND.t6 253
R14 VGND.n38 VGND.t3 253
R15 VGND.n11 VGND.t11 253
R16 VGND.n97 VGND.t1 253
R17 VGND.n37 VGND.t10 253
R18 VGND.n40 VGND.t0 253
R19 VGND.n31 VGND.t9 249.8
R20 VGND.n25 VGND.t8 241.344
R21 VGND VGND.t5 231.744
R22 VGND VGND.t2 231.744
R23 VGND.n41 VGND.n40 15.7005
R24 VGND.n6 VGND.n5 12.8005
R25 VGND.n6 VGND.n3 12.8005
R26 VGND.n10 VGND.n3 12.8005
R27 VGND.n13 VGND.n12 12.8005
R28 VGND.n13 VGND.n0 12.8005
R29 VGND.n115 VGND.n0 12.8005
R30 VGND.n115 VGND.n1 12.8005
R31 VGND.n111 VGND.n1 12.8005
R32 VGND.n111 VGND.n110 12.8005
R33 VGND.n110 VGND.n109 12.8005
R34 VGND.n109 VGND.n17 12.8005
R35 VGND.n105 VGND.n17 12.8005
R36 VGND.n105 VGND.n104 12.8005
R37 VGND.n104 VGND.n103 12.8005
R38 VGND.n103 VGND.n19 12.8005
R39 VGND.n99 VGND.n19 12.8005
R40 VGND.n99 VGND.n98 12.8005
R41 VGND.n96 VGND.n21 12.8005
R42 VGND.n92 VGND.n21 12.8005
R43 VGND.n92 VGND.n91 12.8005
R44 VGND.n91 VGND.n90 12.8005
R45 VGND.n90 VGND.n23 12.8005
R46 VGND.n86 VGND.n23 12.8005
R47 VGND.n86 VGND.n85 12.8005
R48 VGND.n85 VGND.n84 12.8005
R49 VGND.n81 VGND.n80 12.8005
R50 VGND.n80 VGND.n79 12.8005
R51 VGND.n79 VGND.n27 12.8005
R52 VGND.n75 VGND.n27 12.8005
R53 VGND.n75 VGND.n74 12.8005
R54 VGND.n74 VGND.n73 12.8005
R55 VGND.n73 VGND.n29 12.8005
R56 VGND.n69 VGND.n29 12.8005
R57 VGND.n69 VGND.n68 12.8005
R58 VGND.n68 VGND.n67 12.8005
R59 VGND.n67 VGND.n31 12.8005
R60 VGND.n63 VGND.n31 12.8005
R61 VGND.n63 VGND.n62 12.8005
R62 VGND.n62 VGND.n61 12.8005
R63 VGND.n61 VGND.n33 12.8005
R64 VGND.n57 VGND.n33 12.8005
R65 VGND.n57 VGND.n56 12.8005
R66 VGND.n56 VGND.n55 12.8005
R67 VGND.n55 VGND.n35 12.8005
R68 VGND.n51 VGND.n50 12.8005
R69 VGND.n50 VGND.n49 12.8005
R70 VGND.n49 VGND.n38 12.8005
R71 VGND.n45 VGND.n38 12.8005
R72 VGND.n45 VGND.n44 12.8005
R73 VGND.n44 VGND.n43 12.8005
R74 VGND.n5 VGND 9.6005
R75 VGND VGND.n115 9.6005
R76 VGND.n43 VGND.n42 9.3005
R77 VGND.n44 VGND.n39 9.3005
R78 VGND.n46 VGND.n45 9.3005
R79 VGND.n47 VGND.n38 9.3005
R80 VGND.n49 VGND.n48 9.3005
R81 VGND.n50 VGND.n36 9.3005
R82 VGND.n52 VGND.n51 9.3005
R83 VGND.n53 VGND.n35 9.3005
R84 VGND.n55 VGND.n54 9.3005
R85 VGND.n56 VGND.n34 9.3005
R86 VGND.n58 VGND.n57 9.3005
R87 VGND.n59 VGND.n33 9.3005
R88 VGND.n61 VGND.n60 9.3005
R89 VGND.n62 VGND.n32 9.3005
R90 VGND.n64 VGND.n63 9.3005
R91 VGND.n65 VGND.n31 9.3005
R92 VGND.n67 VGND.n66 9.3005
R93 VGND.n68 VGND.n30 9.3005
R94 VGND.n70 VGND.n69 9.3005
R95 VGND.n71 VGND.n29 9.3005
R96 VGND.n73 VGND.n72 9.3005
R97 VGND.n74 VGND.n28 9.3005
R98 VGND.n76 VGND.n75 9.3005
R99 VGND.n77 VGND.n27 9.3005
R100 VGND.n79 VGND.n78 9.3005
R101 VGND.n80 VGND.n26 9.3005
R102 VGND.n82 VGND.n81 9.3005
R103 VGND.n84 VGND.n83 9.3005
R104 VGND.n85 VGND.n24 9.3005
R105 VGND.n87 VGND.n86 9.3005
R106 VGND.n88 VGND.n23 9.3005
R107 VGND.n90 VGND.n89 9.3005
R108 VGND.n91 VGND.n22 9.3005
R109 VGND.n93 VGND.n92 9.3005
R110 VGND.n94 VGND.n21 9.3005
R111 VGND.n96 VGND.n95 9.3005
R112 VGND.n98 VGND.n20 9.3005
R113 VGND.n100 VGND.n99 9.3005
R114 VGND.n101 VGND.n19 9.3005
R115 VGND.n103 VGND.n102 9.3005
R116 VGND.n104 VGND.n18 9.3005
R117 VGND.n106 VGND.n105 9.3005
R118 VGND.n107 VGND.n17 9.3005
R119 VGND.n109 VGND.n108 9.3005
R120 VGND.n110 VGND.n16 9.3005
R121 VGND.n112 VGND.n111 9.3005
R122 VGND.n113 VGND.n1 9.3005
R123 VGND.n115 VGND.n114 9.3005
R124 VGND.n15 VGND.n0 9.3005
R125 VGND.n14 VGND.n13 9.3005
R126 VGND.n12 VGND.n2 9.3005
R127 VGND.n10 VGND.n9 9.3005
R128 VGND.n8 VGND.n3 9.3005
R129 VGND.n7 VGND.n6 9.3005
R130 VGND.n11 VGND.n10 6.4005
R131 VGND.n12 VGND.n11 6.4005
R132 VGND.n98 VGND.n97 6.4005
R133 VGND.n97 VGND.n96 6.4005
R134 VGND.n84 VGND.n25 6.4005
R135 VGND.n81 VGND.n25 6.4005
R136 VGND.n37 VGND.n35 6.4005
R137 VGND.n51 VGND.n37 6.4005
R138 VGND.n43 VGND.n40 6.4005
R139 VGND.n5 VGND.n4 6.08215
R140 VGND.n7 VGND.n4 0.2391
R141 VGND.n8 VGND.n7 0.063
R142 VGND.n9 VGND.n8 0.063
R143 VGND.n9 VGND.n2 0.063
R144 VGND.n14 VGND.n2 0.063
R145 VGND.n15 VGND.n14 0.063
R146 VGND.n114 VGND.n15 0.063
R147 VGND.n114 VGND.n113 0.063
R148 VGND.n113 VGND.n112 0.063
R149 VGND.n112 VGND.n16 0.063
R150 VGND.n108 VGND.n16 0.063
R151 VGND.n108 VGND.n107 0.063
R152 VGND.n107 VGND.n106 0.063
R153 VGND.n106 VGND.n18 0.063
R154 VGND.n102 VGND.n18 0.063
R155 VGND.n102 VGND.n101 0.063
R156 VGND.n101 VGND.n100 0.063
R157 VGND.n100 VGND.n20 0.063
R158 VGND.n95 VGND.n20 0.063
R159 VGND.n95 VGND.n94 0.063
R160 VGND.n94 VGND.n93 0.063
R161 VGND.n93 VGND.n22 0.063
R162 VGND.n89 VGND.n22 0.063
R163 VGND.n89 VGND.n88 0.063
R164 VGND.n88 VGND.n87 0.063
R165 VGND.n87 VGND.n24 0.063
R166 VGND.n83 VGND.n24 0.063
R167 VGND.n83 VGND.n82 0.063
R168 VGND.n82 VGND.n26 0.063
R169 VGND.n78 VGND.n26 0.063
R170 VGND.n78 VGND.n77 0.063
R171 VGND.n77 VGND.n76 0.063
R172 VGND.n76 VGND.n28 0.063
R173 VGND.n72 VGND.n28 0.063
R174 VGND.n72 VGND.n71 0.063
R175 VGND.n71 VGND.n70 0.063
R176 VGND.n70 VGND.n30 0.063
R177 VGND.n66 VGND.n30 0.063
R178 VGND.n66 VGND.n65 0.063
R179 VGND.n65 VGND.n64 0.063
R180 VGND.n64 VGND.n32 0.063
R181 VGND.n60 VGND.n32 0.063
R182 VGND.n60 VGND.n59 0.063
R183 VGND.n59 VGND.n58 0.063
R184 VGND.n58 VGND.n34 0.063
R185 VGND.n54 VGND.n34 0.063
R186 VGND.n54 VGND.n53 0.063
R187 VGND.n53 VGND.n52 0.063
R188 VGND.n52 VGND.n36 0.063
R189 VGND.n48 VGND.n36 0.063
R190 VGND.n48 VGND.n47 0.063
R191 VGND.n47 VGND.n46 0.063
R192 VGND.n46 VGND.n39 0.063
R193 VGND.n42 VGND.n39 0.063
R194 VGND.n42 VGND.n41 0.063
R195 VGND.n41 VGND 0.03175
R196 SET_B.n1 SET_B.t2 520.561
R197 SET_B.n0 SET_B.t3 520.561
R198 SET_B.n2 SET_B.n0 475.733
R199 SET_B.n2 SET_B.n1 397.284
R200 SET_B.n1 SET_B.t0 96.4005
R201 SET_B.n0 SET_B.t1 96.4005
R202 SET_B SET_B.n2 9.24494
R203 VPWR.n32 VPWR.t12 716
R204 VPWR.n112 VPWR.t3 716
R205 VPWR.n105 VPWR.t1 683.168
R206 VPWR.n28 VPWR.t0 683.168
R207 VPWR.n33 VPWR.t7 683.168
R208 VPWR.n39 VPWR.t2 683.168
R209 VPWR.n99 VPWR.t13 683.168
R210 VPWR.n4 VPWR.t11 668.314
R211 VPWR.n40 VPWR.t8 661.976
R212 VPWR.n42 VPWR.t9 661.976
R213 VPWR.n12 VPWR.t10 661.976
R214 VPWR.n26 VPWR.t4 359.127
R215 VPWR.n5 VPWR.t6 328.07
R216 VPWR.n119 VPWR.t5 328.07
R217 VPWR.n6 VPWR.n5 25.6005
R218 VPWR.n119 VPWR.n118 25.6005
R219 VPWR.n5 VPWR 16.0005
R220 VPWR VPWR.n119 16.0005
R221 VPWR.n43 VPWR.n42 15.7005
R222 VPWR.n7 VPWR.n6 12.8005
R223 VPWR.n7 VPWR.n3 12.8005
R224 VPWR.n11 VPWR.n3 12.8005
R225 VPWR.n14 VPWR.n13 12.8005
R226 VPWR.n14 VPWR.n0 12.8005
R227 VPWR.n118 VPWR.n0 12.8005
R228 VPWR.n118 VPWR.n1 12.8005
R229 VPWR.n114 VPWR.n1 12.8005
R230 VPWR.n114 VPWR.n113 12.8005
R231 VPWR.n111 VPWR.n18 12.8005
R232 VPWR.n107 VPWR.n18 12.8005
R233 VPWR.n107 VPWR.n106 12.8005
R234 VPWR.n106 VPWR.n105 12.8005
R235 VPWR.n105 VPWR.n20 12.8005
R236 VPWR.n101 VPWR.n20 12.8005
R237 VPWR.n101 VPWR.n100 12.8005
R238 VPWR.n98 VPWR.n22 12.8005
R239 VPWR.n94 VPWR.n22 12.8005
R240 VPWR.n94 VPWR.n93 12.8005
R241 VPWR.n93 VPWR.n92 12.8005
R242 VPWR.n92 VPWR.n24 12.8005
R243 VPWR.n88 VPWR.n24 12.8005
R244 VPWR.n88 VPWR.n87 12.8005
R245 VPWR.n87 VPWR.n86 12.8005
R246 VPWR.n83 VPWR.n82 12.8005
R247 VPWR.n82 VPWR.n81 12.8005
R248 VPWR.n81 VPWR.n28 12.8005
R249 VPWR.n77 VPWR.n28 12.8005
R250 VPWR.n77 VPWR.n76 12.8005
R251 VPWR.n76 VPWR.n75 12.8005
R252 VPWR.n75 VPWR.n30 12.8005
R253 VPWR.n71 VPWR.n70 12.8005
R254 VPWR.n70 VPWR.n69 12.8005
R255 VPWR.n69 VPWR.n33 12.8005
R256 VPWR.n65 VPWR.n33 12.8005
R257 VPWR.n65 VPWR.n64 12.8005
R258 VPWR.n64 VPWR.n63 12.8005
R259 VPWR.n63 VPWR.n35 12.8005
R260 VPWR.n59 VPWR.n35 12.8005
R261 VPWR.n59 VPWR.n58 12.8005
R262 VPWR.n58 VPWR.n57 12.8005
R263 VPWR.n57 VPWR.n37 12.8005
R264 VPWR.n53 VPWR.n52 12.8005
R265 VPWR.n52 VPWR.n51 12.8005
R266 VPWR.n51 VPWR.n40 12.8005
R267 VPWR.n47 VPWR.n40 12.8005
R268 VPWR.n47 VPWR.n46 12.8005
R269 VPWR.n46 VPWR.n45 12.8005
R270 VPWR.n45 VPWR.n44 9.3005
R271 VPWR.n46 VPWR.n41 9.3005
R272 VPWR.n48 VPWR.n47 9.3005
R273 VPWR.n49 VPWR.n40 9.3005
R274 VPWR.n51 VPWR.n50 9.3005
R275 VPWR.n52 VPWR.n38 9.3005
R276 VPWR.n54 VPWR.n53 9.3005
R277 VPWR.n55 VPWR.n37 9.3005
R278 VPWR.n57 VPWR.n56 9.3005
R279 VPWR.n58 VPWR.n36 9.3005
R280 VPWR.n60 VPWR.n59 9.3005
R281 VPWR.n61 VPWR.n35 9.3005
R282 VPWR.n63 VPWR.n62 9.3005
R283 VPWR.n64 VPWR.n34 9.3005
R284 VPWR.n66 VPWR.n65 9.3005
R285 VPWR.n67 VPWR.n33 9.3005
R286 VPWR.n69 VPWR.n68 9.3005
R287 VPWR.n70 VPWR.n31 9.3005
R288 VPWR.n72 VPWR.n71 9.3005
R289 VPWR.n73 VPWR.n30 9.3005
R290 VPWR.n75 VPWR.n74 9.3005
R291 VPWR.n76 VPWR.n29 9.3005
R292 VPWR.n78 VPWR.n77 9.3005
R293 VPWR.n79 VPWR.n28 9.3005
R294 VPWR.n81 VPWR.n80 9.3005
R295 VPWR.n82 VPWR.n27 9.3005
R296 VPWR.n84 VPWR.n83 9.3005
R297 VPWR.n86 VPWR.n85 9.3005
R298 VPWR.n87 VPWR.n25 9.3005
R299 VPWR.n89 VPWR.n88 9.3005
R300 VPWR.n90 VPWR.n24 9.3005
R301 VPWR.n92 VPWR.n91 9.3005
R302 VPWR.n93 VPWR.n23 9.3005
R303 VPWR.n95 VPWR.n94 9.3005
R304 VPWR.n96 VPWR.n22 9.3005
R305 VPWR.n98 VPWR.n97 9.3005
R306 VPWR.n100 VPWR.n21 9.3005
R307 VPWR.n102 VPWR.n101 9.3005
R308 VPWR.n103 VPWR.n20 9.3005
R309 VPWR.n105 VPWR.n104 9.3005
R310 VPWR.n106 VPWR.n19 9.3005
R311 VPWR.n108 VPWR.n107 9.3005
R312 VPWR.n109 VPWR.n18 9.3005
R313 VPWR.n111 VPWR.n110 9.3005
R314 VPWR.n113 VPWR.n17 9.3005
R315 VPWR.n115 VPWR.n114 9.3005
R316 VPWR.n116 VPWR.n1 9.3005
R317 VPWR.n118 VPWR.n117 9.3005
R318 VPWR.n16 VPWR.n0 9.3005
R319 VPWR.n15 VPWR.n14 9.3005
R320 VPWR.n13 VPWR.n2 9.3005
R321 VPWR.n11 VPWR.n10 9.3005
R322 VPWR.n9 VPWR.n3 9.3005
R323 VPWR.n8 VPWR.n7 9.3005
R324 VPWR.n12 VPWR.n11 6.4005
R325 VPWR.n13 VPWR.n12 6.4005
R326 VPWR.n113 VPWR.n112 6.4005
R327 VPWR.n112 VPWR.n111 6.4005
R328 VPWR.n100 VPWR.n99 6.4005
R329 VPWR.n99 VPWR.n98 6.4005
R330 VPWR.n86 VPWR.n26 6.4005
R331 VPWR.n83 VPWR.n26 6.4005
R332 VPWR.n32 VPWR.n30 6.4005
R333 VPWR.n71 VPWR.n32 6.4005
R334 VPWR.n39 VPWR.n37 6.4005
R335 VPWR.n53 VPWR.n39 6.4005
R336 VPWR.n45 VPWR.n42 6.4005
R337 VPWR.n6 VPWR.n4 6.08215
R338 VPWR.n8 VPWR.n4 0.2391
R339 VPWR.n9 VPWR.n8 0.063
R340 VPWR.n10 VPWR.n9 0.063
R341 VPWR.n10 VPWR.n2 0.063
R342 VPWR.n15 VPWR.n2 0.063
R343 VPWR.n16 VPWR.n15 0.063
R344 VPWR.n117 VPWR.n16 0.063
R345 VPWR.n117 VPWR.n116 0.063
R346 VPWR.n116 VPWR.n115 0.063
R347 VPWR.n115 VPWR.n17 0.063
R348 VPWR.n110 VPWR.n17 0.063
R349 VPWR.n110 VPWR.n109 0.063
R350 VPWR.n109 VPWR.n108 0.063
R351 VPWR.n108 VPWR.n19 0.063
R352 VPWR.n104 VPWR.n19 0.063
R353 VPWR.n104 VPWR.n103 0.063
R354 VPWR.n103 VPWR.n102 0.063
R355 VPWR.n102 VPWR.n21 0.063
R356 VPWR.n97 VPWR.n21 0.063
R357 VPWR.n97 VPWR.n96 0.063
R358 VPWR.n96 VPWR.n95 0.063
R359 VPWR.n95 VPWR.n23 0.063
R360 VPWR.n91 VPWR.n23 0.063
R361 VPWR.n91 VPWR.n90 0.063
R362 VPWR.n90 VPWR.n89 0.063
R363 VPWR.n89 VPWR.n25 0.063
R364 VPWR.n85 VPWR.n25 0.063
R365 VPWR.n85 VPWR.n84 0.063
R366 VPWR.n84 VPWR.n27 0.063
R367 VPWR.n80 VPWR.n27 0.063
R368 VPWR.n80 VPWR.n79 0.063
R369 VPWR.n79 VPWR.n78 0.063
R370 VPWR.n78 VPWR.n29 0.063
R371 VPWR.n74 VPWR.n29 0.063
R372 VPWR.n74 VPWR.n73 0.063
R373 VPWR.n73 VPWR.n72 0.063
R374 VPWR.n72 VPWR.n31 0.063
R375 VPWR.n68 VPWR.n31 0.063
R376 VPWR.n68 VPWR.n67 0.063
R377 VPWR.n67 VPWR.n66 0.063
R378 VPWR.n66 VPWR.n34 0.063
R379 VPWR.n62 VPWR.n34 0.063
R380 VPWR.n62 VPWR.n61 0.063
R381 VPWR.n61 VPWR.n60 0.063
R382 VPWR.n60 VPWR.n36 0.063
R383 VPWR.n56 VPWR.n36 0.063
R384 VPWR.n56 VPWR.n55 0.063
R385 VPWR.n55 VPWR.n54 0.063
R386 VPWR.n54 VPWR.n38 0.063
R387 VPWR.n50 VPWR.n38 0.063
R388 VPWR.n50 VPWR.n49 0.063
R389 VPWR.n49 VPWR.n48 0.063
R390 VPWR.n48 VPWR.n41 0.063
R391 VPWR.n44 VPWR.n41 0.063
R392 VPWR.n44 VPWR.n43 0.063
R393 VPWR.n43 VPWR 0.03175
R394 D.n0 D.t1 290.808
R395 D.n0 D.t0 290.808
R396 D D.n0 158.4
R397 CLK.n0 CLK.t1 319.728
R398 CLK.n0 CLK.t0 232.968
R399 CLK CLK.n0 158.4
R400 VPB.t3 VPB.t6 863.636
R401 VPB.t19 VPB.t1 863.636
R402 VPB.t0 VPB.t4 863.636
R403 VPB.t9 VPB.t18 863.636
R404 VPB.t8 VPB.t17 604.545
R405 VPB.t12 VPB.t8 604.545
R406 VPB.t6 VPB.t12 604.545
R407 VPB.t10 VPB.t11 604.545
R408 VPB.t16 VPB.t10 604.545
R409 VPB.t7 VPB.t15 518.183
R410 VPB.t5 VPB.t13 518.183
R411 VPB.t15 VPB.t19 431.818
R412 VPB.t13 VPB.t9 431.818
R413 VPB.t4 VPB.t7 345.455
R414 VPB VPB.t16 302.274
R415 VPB.t14 VPB.t3 259.091
R416 VPB.t1 VPB.t14 259.091
R417 VPB.t2 VPB.t0 259.091
R418 VPB.t18 VPB.t2 259.091
R419 VPB.t11 VPB.t5 259.091
R420 VNB.t6 VNB.t4 4000
R421 VNB.t2 VNB.t1 4000
R422 VNB.t0 VNB.t16 4000
R423 VNB.t17 VNB.t3 4000
R424 VNB.t14 VNB.t13 2800
R425 VNB.t19 VNB.t14 2800
R426 VNB.t4 VNB.t19 2800
R427 VNB.t12 VNB.t8 2800
R428 VNB.t11 VNB.t12 2800
R429 VNB.t5 VNB.t10 2400
R430 VNB.t9 VNB.t7 2400
R431 VNB.t10 VNB.t2 2000
R432 VNB.t7 VNB.t17 2000
R433 VNB.t16 VNB.t5 1600
R434 VNB VNB.t11 1400
R435 VNB.t15 VNB.t6 1200
R436 VNB.t1 VNB.t15 1200
R437 VNB.t18 VNB.t0 1200
R438 VNB.t3 VNB.t18 1200
R439 VNB.t8 VNB.t9 1200
R440 a_2985_36.t0 a_2985_36.n0 52.0005
R441 a_2985_36.n0 a_2985_36.t2 41.3338
R442 a_2985_36.n0 a_2985_36.t1 433.337
R443 a_2445_36.t1 a_2445_36.t0 219
R444 a_3813_36.t1 a_3813_36.n0 259.401
R445 a_3813_36.n0 a_3813_36.n1 177.601
R446 a_3813_36.n1 a_3813_36.t2 204.048
R447 a_3813_36.n1 a_3813_36.t3 247.428
R448 a_3813_36.n0 a_3813_36.t0 681.177
R449 a_3093_378.t0 a_3093_378.t1 94.8524
R450 a_2085_36.t0 a_2085_36.t1 170.714
R451 a_1404_36.n0 a_1404_36.t2 41.7148
R452 a_1404_36.t0 a_1404_36.n0 52.0005
R453 a_1404_36.n0 a_1404_36.t1 433.337
R454 a_969_36.t0 a_969_36.t1 219
R455 a_2445_450.t0 a_2445_450.t1 328.334
R456 a_2085_378.t1 a_2085_378.t0 223.268
R457 a_1509_378.t0 a_1509_378.t1 94.8524
R458 a_2229_36.t1 a_2229_36.n0 245
R459 a_2229_36.n0 a_2229_36.t3 65.0005
R460 a_2229_36.n0 a_2229_36.n2 242.601
R461 a_2229_36.n2 a_2229_36.n3 395.2
R462 a_2229_36.n3 a_2229_36.t4 222.256
R463 a_2229_36.n3 a_2229_36.t5 309.017
R464 a_2229_36.n2 a_2229_36.n1 652.201
R465 a_2229_36.n1 a_2229_36.t0 321.767
R466 a_2229_36.n1 a_2229_36.t2 85.3672
R467 a_2583_327.t2 a_2583_327.n0 85.3672
R468 a_2583_327.n0 a_2583_327.t1 58.1277
R469 a_2583_327.n0 a_2583_327.n6 613.801
R470 a_2583_327.n6 a_2583_327.n1 228.8
R471 a_2583_327.n6 a_2583_327.n3 32.0005
R472 a_2583_327.n3 a_2583_327.n5 248.951
R473 a_2583_327.n5 a_2583_327.n4 168.701
R474 a_2583_327.n5 a_2583_327.t8 231.361
R475 a_2583_327.n5 a_2583_327.t5 187.981
R476 a_2583_327.n4 a_2583_327.t7 303.661
R477 a_2583_327.n4 a_2583_327.t4 216.9
R478 a_2583_327.n3 a_2583_327.n2 213.8
R479 a_2583_327.n2 a_2583_327.t0 37.1434
R480 a_2583_327.n2 a_2583_327.t3 37.1434
R481 a_2583_327.n1 a_2583_327.t6 424.697
R482 a_2583_327.n1 a_2583_327.t9 193.337
R483 a_969_450.t0 a_969_450.t1 328.334
R484 a_753_36.n0 a_753_36.t2 245
R485 a_753_36.t1 a_753_36.n0 65.0005
R486 a_753_36.n0 a_753_36.n2 242.601
R487 a_753_36.n2 a_753_36.n3 395.2
R488 a_753_36.n3 a_753_36.t4 222.256
R489 a_753_36.n3 a_753_36.t5 309.017
R490 a_753_36.n2 a_753_36.n1 652.201
R491 a_753_36.n1 a_753_36.t0 321.767
R492 a_753_36.n1 a_753_36.t3 85.3672
R493 a_645_36.n0 a_645_36.t1 56.0005
R494 a_645_36.t3 a_645_36.n0 65.0005
R495 a_645_36.n0 a_645_36.n1 907.601
R496 a_645_36.n1 a_645_36.t2 85.3672
R497 a_645_36.n1 a_645_36.t0 85.3672
R498 a_1296_440.t0 a_1296_440.n0 304.022
R499 a_1296_440.n0 a_1296_440.n1 11.5505
R500 a_1296_440.n1 a_1296_440.t3 586.933
R501 a_1296_440.t3 a_1296_440.t2 578.4
R502 a_1296_440.n1 a_1296_440.t5 591.433
R503 a_1296_440.t5 a_1296_440.t4 578.4
R504 a_1296_440.n0 a_1296_440.t1 649.355
R505 a_1088_165.n0 a_1088_165.t3 59.1005
R506 a_1088_165.t0 a_1088_165.n0 85.3672
R507 a_1088_165.n0 a_1088_165.n4 652.201
R508 a_1088_165.n4 a_1088_165.n5 292.8
R509 a_1088_165.n5 a_1088_165.t4 222.256
R510 a_1088_165.n5 a_1088_165.t6 309.017
R511 a_1088_165.n2 a_1088_165.n1 185
R512 a_1088_165.n4 a_1088_165.n2 60.8005
R513 a_1088_165.n2 a_1088_165.n3 289.779
R514 a_1088_165.n3 a_1088_165.t5 161.036
R515 a_1088_165.n3 a_1088_165.t7 450.236
R516 a_1088_165.n1 a_1088_165.t1 37.1434
R517 a_1088_165.n1 a_1088_165.t2 37.1434
R518 a_393_36.t1 a_393_36.n0 253
R519 a_393_36.n0 a_393_36.n1 10.2246
R520 a_393_36.n1 a_393_36.n2 0.321929
R521 a_393_36.n2 a_393_36.n3 12.0326
R522 a_393_36.n3 a_393_36.t4 425.334
R523 a_393_36.n3 a_393_36.t2 301.957
R524 a_393_36.n2 a_393_36.t3 308.091
R525 a_393_36.n1 a_393_36.t5 680.521
R526 a_393_36.n0 a_393_36.t0 700.376
R527 a_141_36.t0 a_141_36.n4 259.401
R528 a_141_36.n4 a_141_36.n5 177.601
R529 a_141_36.n5 a_141_36.t5 232.968
R530 a_141_36.n5 a_141_36.t7 319.728
R531 a_141_36.n4 a_141_36.n0 12.8005
R532 a_141_36.n0 a_141_36.n1 10.45
R533 a_141_36.n1 a_141_36.n2 0.561253
R534 a_141_36.n2 a_141_36.n3 3.1255
R535 a_141_36.n3 a_141_36.t2 308.413
R536 a_141_36.n3 a_141_36.t4 680.521
R537 a_141_36.n2 a_141_36.t6 351.471
R538 a_141_36.n1 a_141_36.t3 375.257
R539 a_141_36.n0 a_141_36.t1 668.376
C24 Q VNB 0.26045f
C25 Q_N VNB 0.26564f
C26 RESET_B VNB 0.24982f
C27 VGND VNB 2.85886f
C28 SET_B VNB 0.70244f
C29 VPWR VNB 1.9162f
C30 D VNB 0.22213f
C31 CLK VNB 0.25869f
C32 VPB VNB 5.36019f
C33 a_141_36.t0 VNB 0.09058f
C34 a_141_36.t1 VNB 0.1272f
C35 a_141_36.n0 VNB 0.24999f
C36 a_141_36.t3 VNB 0.07129f
C37 a_141_36.n1 VNB 0.72535f
C38 a_141_36.t6 VNB 0.07288f
C39 a_141_36.n2 VNB 0.77122f
C40 a_141_36.t4 VNB 0.12279f
C41 a_141_36.n3 VNB 0.96248f
C42 a_141_36.t2 VNB 0.06687f
C43 a_141_36.n4 VNB 0.42319f
C44 a_141_36.t7 VNB 0.05434f
C45 a_141_36.t5 VNB 0.03593f
C46 a_141_36.n5 VNB 0.18523f
C47 a_393_36.t1 VNB 0.09888f
C48 a_393_36.t0 VNB 0.16013f
C49 a_393_36.n0 VNB 0.6008f
C50 a_393_36.t5 VNB 0.14059f
C51 a_393_36.n1 VNB 0.62669f
C52 a_393_36.t3 VNB 0.07638f
C53 a_393_36.n2 VNB 1.14208f
C54 a_393_36.n3 VNB 0.60819f
C55 a_393_36.t2 VNB 0.05897f
C56 a_393_36.t4 VNB 0.15908f
C57 a_1088_165.t0 VNB 0.02558f
C58 a_1088_165.n0 VNB 0.08492f
C59 a_1088_165.t1 VNB 0.03581f
C60 a_1088_165.t2 VNB 0.03581f
C61 a_1088_165.n1 VNB 0.07162f
C62 a_1088_165.n2 VNB 0.3781f
C63 a_1088_165.t7 VNB 0.06584f
C64 a_1088_165.t5 VNB 0.02765f
C65 a_1088_165.n3 VNB 0.20489f
C66 a_1088_165.n4 VNB 0.38093f
C67 a_1088_165.t6 VNB 0.06258f
C68 a_1088_165.t4 VNB 0.04324f
C69 a_1088_165.n5 VNB 0.15157f
C70 a_1088_165.t3 VNB 0.0626f
C71 a_1296_440.t0 VNB 0.14133f
C72 a_1296_440.t1 VNB 0.12788f
C73 a_1296_440.n0 VNB 0.57653f
C74 a_1296_440.t5 VNB 0.20932f
C75 a_1296_440.t4 VNB 0.09007f
C76 a_1296_440.t3 VNB 0.20133f
C77 a_1296_440.t2 VNB 0.09007f
C78 a_1296_440.n1 VNB 2.82573f
C79 a_645_36.t3 VNB 0.01931f
C80 a_645_36.n0 VNB 0.2809f
C81 a_645_36.t2 VNB 0.02414f
C82 a_645_36.t0 VNB 0.02414f
C83 a_645_36.n1 VNB 0.14137f
C84 a_645_36.t1 VNB 0.02727f
C85 a_753_36.t1 VNB 0.01885f
C86 a_753_36.n0 VNB 0.11332f
C87 a_753_36.t0 VNB 0.08882f
C88 a_753_36.t3 VNB 0.02356f
C89 a_753_36.n1 VNB 0.12442f
C90 a_753_36.n2 VNB 0.50331f
C91 a_753_36.t5 VNB 0.05765f
C92 a_753_36.t4 VNB 0.03983f
C93 a_753_36.n3 VNB 0.19417f
C94 a_753_36.t2 VNB 0.07105f
C95 a_969_450.t0 VNB 0.02132f
C96 a_969_450.t1 VNB 0.02132f
C97 a_2583_327.t2 VNB 0.0194f
C98 a_2583_327.n0 VNB 0.05871f
C99 a_2583_327.t9 VNB 0.02397f
C100 a_2583_327.t6 VNB 0.04728f
C101 a_2583_327.n1 VNB 0.15201f
C102 a_2583_327.t0 VNB 0.02716f
C103 a_2583_327.t3 VNB 0.02716f
C104 a_2583_327.n2 VNB 0.06782f
C105 a_2583_327.n3 VNB 0.43628f
C106 a_2583_327.t4 VNB 0.02537f
C107 a_2583_327.t7 VNB 0.04029f
C108 a_2583_327.n4 VNB 0.16832f
C109 a_2583_327.t5 VNB 0.02835f
C110 a_2583_327.t8 VNB 0.04775f
C111 a_2583_327.n5 VNB 0.24812f
C112 a_2583_327.n6 VNB 0.45412f
C113 a_2583_327.t1 VNB 0.04662f
C114 a_2229_36.t1 VNB 0.07197f
C115 a_2229_36.n0 VNB 0.11478f
C116 a_2229_36.t0 VNB 0.08996f
C117 a_2229_36.t2 VNB 0.02387f
C118 a_2229_36.n1 VNB 0.12602f
C119 a_2229_36.n2 VNB 0.50979f
C120 a_2229_36.t5 VNB 0.05839f
C121 a_2229_36.t4 VNB 0.04034f
C122 a_2229_36.n3 VNB 0.19667f
C123 a_2229_36.t3 VNB 0.01909f
C124 a_1509_378.t0 VNB 0.01834f
C125 a_1509_378.t1 VNB 0.01834f
C126 a_2085_378.t1 VNB 0.01328f
C127 a_2085_378.t0 VNB 0.02369f
C128 a_2445_450.t0 VNB 0.02078f
C129 a_2445_450.t1 VNB 0.02078f
C130 a_969_36.t0 VNB 0.01824f
C131 a_969_36.t1 VNB 0.02252f
C132 a_1404_36.t0 VNB 0.0248f
C133 a_1404_36.n0 VNB 0.2668f
C134 a_1404_36.t1 VNB 0.29147f
C135 a_1404_36.t2 VNB 0.04165f
C136 a_2085_36.t0 VNB 0.01074f
C137 a_2085_36.t1 VNB 0.01864f
C138 a_3093_378.t0 VNB 0.01891f
C139 a_3093_378.t1 VNB 0.01891f
C140 a_3813_36.t1 VNB 0.05886f
C141 a_3813_36.t0 VNB 0.08538f
C142 a_3813_36.n0 VNB 0.4169f
C143 a_3813_36.t3 VNB 0.04169f
C144 a_3813_36.t2 VNB 0.02596f
C145 a_3813_36.n1 VNB 0.11138f
C146 a_2445_36.t1 VNB 0.01745f
C147 a_2445_36.t0 VNB 0.02154f
C148 a_2985_36.t0 VNB 0.01978f
C149 a_2985_36.n0 VNB 0.21315f
C150 a_2985_36.t1 VNB 0.23241f
C151 a_2985_36.t2 VNB 0.0328f
C152 VPB.t17 VNB 0.26037f
C153 VPB.t8 VNB 0.22782f
C154 VPB.t12 VNB 0.22782f
C155 VPB.t6 VNB 0.27664f
C156 VPB.t3 VNB 0.21155f
C157 VPB.t14 VNB 0.09764f
C158 VPB.t1 VNB 0.21155f
C159 VPB.t19 VNB 0.2441f
C160 VPB.t15 VNB 0.179f
C161 VPB.t7 VNB 0.16273f
C162 VPB.t4 VNB 0.22782f
C163 VPB.t0 VNB 0.21155f
C164 VPB.t2 VNB 0.09764f
C165 VPB.t18 VNB 0.21155f
C166 VPB.t9 VNB 0.2441f
C167 VPB.t13 VNB 0.179f
C168 VPB.t5 VNB 0.14646f
C169 VPB.t11 VNB 0.16273f
C170 VPB.t10 VNB 0.22782f
C171 VPB.t16 VNB 0.17087f
C172 CLK.t1 VNB 0.04659f
C173 CLK.t0 VNB 0.03081f
C174 CLK.n0 VNB 0.14726f
C175 D.t1 VNB 0.05527f
C176 D.t0 VNB 0.05527f
C177 D.n0 VNB 0.22517f
C178 VPWR.n0 VNB 0.02237f
C179 VPWR.n1 VNB 0.02237f
C180 VPWR.n2 VNB 0.04473f
C181 VPWR.t10 VNB 0.03887f
C182 VPWR.n3 VNB 0.02237f
C183 VPWR.t11 VNB 0.03979f
C184 VPWR.n4 VNB 0.26072f
C185 VPWR.t6 VNB 0.06428f
C186 VPWR.n5 VNB 0.04195f
C187 VPWR.n6 VNB 0.05381f
C188 VPWR.n7 VNB 0.02237f
C189 VPWR.n8 VNB 0.27355f
C190 VPWR.n9 VNB 0.04473f
C191 VPWR.n10 VNB 0.04473f
C192 VPWR.n11 VNB 0.01677f
C193 VPWR.n12 VNB 0.06341f
C194 VPWR.n13 VNB 0.01677f
C195 VPWR.n14 VNB 0.02237f
C196 VPWR.n15 VNB 0.04473f
C197 VPWR.n16 VNB 0.04473f
C198 VPWR.n17 VNB 0.04473f
C199 VPWR.t3 VNB 0.04969f
C200 VPWR.n18 VNB 0.02237f
C201 VPWR.n19 VNB 0.04473f
C202 VPWR.t1 VNB 0.02695f
C203 VPWR.n20 VNB 0.02237f
C204 VPWR.n21 VNB 0.04473f
C205 VPWR.t13 VNB 0.02695f
C206 VPWR.n22 VNB 0.02237f
C207 VPWR.n23 VNB 0.04473f
C208 VPWR.n24 VNB 0.02237f
C209 VPWR.n25 VNB 0.04473f
C210 VPWR.t4 VNB 0.04969f
C211 VPWR.n26 VNB 0.07542f
C212 VPWR.n27 VNB 0.04473f
C213 VPWR.t0 VNB 0.02695f
C214 VPWR.n28 VNB 0.06367f
C215 VPWR.n29 VNB 0.04473f
C216 VPWR.n30 VNB 0.01677f
C217 VPWR.n31 VNB 0.04473f
C218 VPWR.t12 VNB 0.04969f
C219 VPWR.n32 VNB 0.04746f
C220 VPWR.t7 VNB 0.02695f
C221 VPWR.n33 VNB 0.06367f
C222 VPWR.n34 VNB 0.04473f
C223 VPWR.n35 VNB 0.02237f
C224 VPWR.n36 VNB 0.04473f
C225 VPWR.n37 VNB 0.01677f
C226 VPWR.n38 VNB 0.04473f
C227 VPWR.t2 VNB 0.02695f
C228 VPWR.n39 VNB 0.05249f
C229 VPWR.t8 VNB 0.03887f
C230 VPWR.n40 VNB 0.07459f
C231 VPWR.n41 VNB 0.04473f
C232 VPWR.t9 VNB 0.03887f
C233 VPWR.n42 VNB 0.07334f
C234 VPWR.n43 VNB 0.04039f
C235 VPWR.n44 VNB 0.04473f
C236 VPWR.n45 VNB 0.01677f
C237 VPWR.n46 VNB 0.02237f
C238 VPWR.n47 VNB 0.02237f
C239 VPWR.n48 VNB 0.04473f
C240 VPWR.n49 VNB 0.04473f
C241 VPWR.n50 VNB 0.04473f
C242 VPWR.n51 VNB 0.02237f
C243 VPWR.n52 VNB 0.02237f
C244 VPWR.n53 VNB 0.01677f
C245 VPWR.n54 VNB 0.04473f
C246 VPWR.n55 VNB 0.04473f
C247 VPWR.n56 VNB 0.04473f
C248 VPWR.n57 VNB 0.02237f
C249 VPWR.n58 VNB 0.02237f
C250 VPWR.n59 VNB 0.02237f
C251 VPWR.n60 VNB 0.04473f
C252 VPWR.n61 VNB 0.04473f
C253 VPWR.n62 VNB 0.04473f
C254 VPWR.n63 VNB 0.02237f
C255 VPWR.n64 VNB 0.02237f
C256 VPWR.n65 VNB 0.02237f
C257 VPWR.n66 VNB 0.04473f
C258 VPWR.n67 VNB 0.04473f
C259 VPWR.n68 VNB 0.04473f
C260 VPWR.n69 VNB 0.02237f
C261 VPWR.n70 VNB 0.02237f
C262 VPWR.n71 VNB 0.01677f
C263 VPWR.n72 VNB 0.04473f
C264 VPWR.n73 VNB 0.04473f
C265 VPWR.n74 VNB 0.04473f
C266 VPWR.n75 VNB 0.02237f
C267 VPWR.n76 VNB 0.02237f
C268 VPWR.n77 VNB 0.02237f
C269 VPWR.n78 VNB 0.04473f
C270 VPWR.n79 VNB 0.04473f
C271 VPWR.n80 VNB 0.04473f
C272 VPWR.n81 VNB 0.02237f
C273 VPWR.n82 VNB 0.02237f
C274 VPWR.n83 VNB 0.01677f
C275 VPWR.n84 VNB 0.04473f
C276 VPWR.n85 VNB 0.04473f
C277 VPWR.n86 VNB 0.01677f
C278 VPWR.n87 VNB 0.02237f
C279 VPWR.n88 VNB 0.02237f
C280 VPWR.n89 VNB 0.04473f
C281 VPWR.n90 VNB 0.04473f
C282 VPWR.n91 VNB 0.04473f
C283 VPWR.n92 VNB 0.02237f
C284 VPWR.n93 VNB 0.02237f
C285 VPWR.n94 VNB 0.02237f
C286 VPWR.n95 VNB 0.04473f
C287 VPWR.n96 VNB 0.04473f
C288 VPWR.n97 VNB 0.04473f
C289 VPWR.n98 VNB 0.01677f
C290 VPWR.n99 VNB 0.05249f
C291 VPWR.n100 VNB 0.01677f
C292 VPWR.n101 VNB 0.02237f
C293 VPWR.n102 VNB 0.04473f
C294 VPWR.n103 VNB 0.04473f
C295 VPWR.n104 VNB 0.04473f
C296 VPWR.n105 VNB 0.06367f
C297 VPWR.n106 VNB 0.02237f
C298 VPWR.n107 VNB 0.02237f
C299 VPWR.n108 VNB 0.04473f
C300 VPWR.n109 VNB 0.04473f
C301 VPWR.n110 VNB 0.04473f
C302 VPWR.n111 VNB 0.01677f
C303 VPWR.n112 VNB 0.04746f
C304 VPWR.n113 VNB 0.01677f
C305 VPWR.n114 VNB 0.02237f
C306 VPWR.n115 VNB 0.04473f
C307 VPWR.n116 VNB 0.04473f
C308 VPWR.n117 VNB 0.04473f
C309 VPWR.n118 VNB 0.04473f
C310 VPWR.t5 VNB 0.06428f
C311 VPWR.n119 VNB 0.04195f
C312 SET_B.t3 VNB 0.08734f
C313 SET_B.t1 VNB 0.01992f
C314 SET_B.n0 VNB 0.24448f
C315 SET_B.t2 VNB 0.08734f
C316 SET_B.t0 VNB 0.01992f
C317 SET_B.n1 VNB 0.21243f
C318 SET_B.n2 VNB 1.23615f
C319 VGND.t2 VNB 0.02827f
C320 VGND.n0 VNB 0.0171f
C321 VGND.n1 VNB 0.0171f
C322 VGND.n2 VNB 0.0342f
C323 VGND.t11 VNB 0.0201f
C324 VGND.n3 VNB 0.0171f
C325 VGND.t4 VNB 0.02171f
C326 VGND.n4 VNB 0.19059f
C327 VGND.t5 VNB 0.02827f
C328 VGND.n5 VNB 0.03046f
C329 VGND.n6 VNB 0.0171f
C330 VGND.n7 VNB 0.20914f
C331 VGND.n8 VNB 0.0342f
C332 VGND.n9 VNB 0.0342f
C333 VGND.n10 VNB 0.01282f
C334 VGND.n11 VNB 0.04064f
C335 VGND.n12 VNB 0.01282f
C336 VGND.n13 VNB 0.0171f
C337 VGND.n14 VNB 0.0342f
C338 VGND.n15 VNB 0.0342f
C339 VGND.n16 VNB 0.0342f
C340 VGND.n17 VNB 0.0171f
C341 VGND.n18 VNB 0.0342f
C342 VGND.t7 VNB 0.0201f
C343 VGND.n19 VNB 0.0171f
C344 VGND.n20 VNB 0.0342f
C345 VGND.t1 VNB 0.0201f
C346 VGND.n21 VNB 0.0171f
C347 VGND.n22 VNB 0.0342f
C348 VGND.n23 VNB 0.0171f
C349 VGND.n24 VNB 0.0342f
C350 VGND.t8 VNB 0.02966f
C351 VGND.n25 VNB 0.04853f
C352 VGND.n26 VNB 0.0342f
C353 VGND.t6 VNB 0.0201f
C354 VGND.n27 VNB 0.04919f
C355 VGND.n28 VNB 0.0342f
C356 VGND.n29 VNB 0.0171f
C357 VGND.n30 VNB 0.0342f
C358 VGND.t9 VNB 0.01971f
C359 VGND.n31 VNB 0.0453f
C360 VGND.n32 VNB 0.0342f
C361 VGND.n33 VNB 0.0171f
C362 VGND.n34 VNB 0.0342f
C363 VGND.n35 VNB 0.01282f
C364 VGND.n36 VNB 0.0342f
C365 VGND.t10 VNB 0.0201f
C366 VGND.n37 VNB 0.04064f
C367 VGND.t3 VNB 0.0201f
C368 VGND.n38 VNB 0.04919f
C369 VGND.n39 VNB 0.0342f
C370 VGND.t0 VNB 0.0201f
C371 VGND.n40 VNB 0.04824f
C372 VGND.n41 VNB 0.03088f
C373 VGND.n42 VNB 0.0342f
C374 VGND.n43 VNB 0.01282f
C375 VGND.n44 VNB 0.0171f
C376 VGND.n45 VNB 0.0171f
C377 VGND.n46 VNB 0.0342f
C378 VGND.n47 VNB 0.0342f
C379 VGND.n48 VNB 0.0342f
C380 VGND.n49 VNB 0.0171f
C381 VGND.n50 VNB 0.0171f
C382 VGND.n51 VNB 0.01282f
C383 VGND.n52 VNB 0.0342f
C384 VGND.n53 VNB 0.0342f
C385 VGND.n54 VNB 0.0342f
C386 VGND.n55 VNB 0.0171f
C387 VGND.n56 VNB 0.0171f
C388 VGND.n57 VNB 0.0171f
C389 VGND.n58 VNB 0.0342f
C390 VGND.n59 VNB 0.0342f
C391 VGND.n60 VNB 0.0342f
C392 VGND.n61 VNB 0.0171f
C393 VGND.n62 VNB 0.0171f
C394 VGND.n63 VNB 0.0171f
C395 VGND.n64 VNB 0.0342f
C396 VGND.n65 VNB 0.0342f
C397 VGND.n66 VNB 0.0342f
C398 VGND.n67 VNB 0.0171f
C399 VGND.n68 VNB 0.0171f
C400 VGND.n69 VNB 0.0171f
C401 VGND.n70 VNB 0.0342f
C402 VGND.n71 VNB 0.0342f
C403 VGND.n72 VNB 0.0342f
C404 VGND.n73 VNB 0.0171f
C405 VGND.n74 VNB 0.0171f
C406 VGND.n75 VNB 0.0171f
C407 VGND.n76 VNB 0.0342f
C408 VGND.n77 VNB 0.0342f
C409 VGND.n78 VNB 0.0342f
C410 VGND.n79 VNB 0.0171f
C411 VGND.n80 VNB 0.0171f
C412 VGND.n81 VNB 0.01282f
C413 VGND.n82 VNB 0.0342f
C414 VGND.n83 VNB 0.0342f
C415 VGND.n84 VNB 0.01282f
C416 VGND.n85 VNB 0.0171f
C417 VGND.n86 VNB 0.0171f
C418 VGND.n87 VNB 0.0342f
C419 VGND.n88 VNB 0.0342f
C420 VGND.n89 VNB 0.0342f
C421 VGND.n90 VNB 0.0171f
C422 VGND.n91 VNB 0.0171f
C423 VGND.n92 VNB 0.0171f
C424 VGND.n93 VNB 0.0342f
C425 VGND.n94 VNB 0.0342f
C426 VGND.n95 VNB 0.0342f
C427 VGND.n96 VNB 0.01282f
C428 VGND.n97 VNB 0.04064f
C429 VGND.n98 VNB 0.01282f
C430 VGND.n99 VNB 0.0171f
C431 VGND.n100 VNB 0.0342f
C432 VGND.n101 VNB 0.0342f
C433 VGND.n102 VNB 0.0342f
C434 VGND.n103 VNB 0.04919f
C435 VGND.n104 VNB 0.0171f
C436 VGND.n105 VNB 0.0171f
C437 VGND.n106 VNB 0.0342f
C438 VGND.n107 VNB 0.0342f
C439 VGND.n108 VNB 0.0342f
C440 VGND.n109 VNB 0.0171f
C441 VGND.n110 VNB 0.0171f
C442 VGND.n111 VNB 0.0171f
C443 VGND.n112 VNB 0.0342f
C444 VGND.n113 VNB 0.0342f
C445 VGND.n114 VNB 0.0342f
C446 VGND.n115 VNB 0.02351f
C447 RESET_B.t1 VNB 0.05113f
C448 RESET_B.t0 VNB 0.0338f
C449 RESET_B.n0 VNB 0.16159f
C450 Q_N.t0 VNB 0.12212f
C451 Q_N.t1 VNB 0.06536f
C452 Q_N.n0 VNB 0.05526f
C453 Q.t0 VNB 0.11716f
C454 Q.t1 VNB 0.0627f
C455 Q.n0 VNB 0.05302f
.ends

.subckt sky130_efx_lvdig__dfrbp_1 CLK D RESET_B Q Q_N VGND VNB VPB VPWR
X0 Q.t0 a_2060_165.t4 VGND.t5 VNB.t3 sky130_fd_pr__nfet_01v8 ad=0.23625 pd=2.01 as=0.23625 ps=2.01 w=0.63 l=0.15
X1 a_969_450.t1 a_141_36.t6 a_753_36.t2 VPB.t7 sky130_fd_pr__pfet_01v8_hvt ad=0.16875 pd=1.2 as=0.20925 ps=1.38 w=0.45 l=0.15
X2 VPWR.t7 a_1088_165.t5 a_969_450.t0 VPB.t3 sky130_fd_pr__pfet_01v8_hvt ad=0.08775 pd=0.84 as=0.16875 ps=1.2 w=0.45 l=0.15
X3 a_141_36.t1 CLK.t1 VPWR.t6 VPB.t13 sky130_fd_pr__pfet_01v8_hvt ad=0.23625 pd=2.01 as=0.23625 ps=2.01 w=0.63 l=0.15
X4 VPWR.t3 a_1725_36.t5 a_2060_165.t1 VPB.t0 sky130_fd_pr__pfet_01v8_hvt ad=0.16875 pd=1.65 as=0.08775 ps=0.84 w=0.45 l=0.15
X5 a_645_36.t2 D.t0 VGND.t2 VNB.t12 sky130_fd_pr__nfet_01v8 ad=0.08258 pd=0.84 as=0.16875 ps=1.65 w=0.45 l=0.15
X6 a_753_36.t0 a_141_36.t3 a_645_36.t0 VNB.t6 sky130_fd_pr__special_nfet_01v8 ad=0.1674 pd=1.29 as=0.08258 ps=0.84 w=0.36 l=0.15
X7 Q_N.t1 a_2841_36.t3 VPWR.t4 VPB.t1 sky130_fd_pr__pfet_01v8_hvt ad=0.405 pd=2.91 as=0.405 ps=2.91 w=1.08 l=0.15
X8 a_969_450.t2 RESET_B.t3 VPWR.t2 VPB.t14 sky130_fd_pr__pfet_01v8_hvt ad=0.16875 pd=1.65 as=0.08775 ps=0.84 w=0.45 l=0.15
X9 Q.t1 a_2060_165.t7 VPWR.t8 VPB.t4 sky130_fd_pr__pfet_01v8_hvt ad=0.405 pd=2.91 as=0.405 ps=2.91 w=1.08 l=0.15
X10 a_1941_450.t1 a_393_36.t4 a_1725_36.t3 VPB.t8 sky130_fd_pr__pfet_01v8_hvt ad=0.16875 pd=1.2 as=0.20925 ps=1.38 w=0.45 l=0.15
X11 VGND.t6 a_2060_165.t5 a_1941_36.t1 VNB.t4 sky130_fd_pr__nfet_01v8 ad=0.08775 pd=0.84 as=0.15593 ps=1.2 w=0.45 l=0.15
X12 Q_N.t0 a_2841_36.t2 VGND.t4 VNB.t2 sky130_fd_pr__nfet_01v8 ad=0.23625 pd=2.01 as=0.23625 ps=2.01 w=0.63 l=0.15
X13 a_141_36.t0 CLK.t0 VGND.t3 VNB.t13 sky130_fd_pr__nfet_01v8 ad=0.16875 pd=1.65 as=0.16875 ps=1.65 w=0.45 l=0.15
X14 a_1088_165.t2 a_753_36.t4 VGND.t9 VNB.t10 sky130_fd_pr__nfet_01v8 ad=0.13702 pd=1.2 as=0.23625 ps=2.01 w=0.63 l=0.15
X15 a_393_36.t1 a_141_36.t7 VPWR.t10 VPB.t10 sky130_fd_pr__pfet_01v8_hvt ad=0.23625 pd=2.01 as=0.23625 ps=2.01 w=0.63 l=0.15
X16 a_969_36.t0 a_393_36.t3 a_753_36.t1 VNB.t9 sky130_fd_pr__special_nfet_01v8 ad=0.15593 pd=1.2 as=0.1674 ps=1.29 w=0.36 l=0.15
X17 a_1149_36.t0 a_1088_165.t4 a_969_36.t1 VNB.t11 sky130_fd_pr__nfet_01v8 ad=0.08775 pd=0.84 as=0.15593 ps=1.2 w=0.45 l=0.15
X18 VGND.t1 RESET_B.t1 a_1149_36.t1 VNB.t14 sky130_fd_pr__nfet_01v8 ad=0.16875 pd=1.65 as=0.08775 ps=0.84 w=0.45 l=0.15
X19 VPWR.t5 a_2060_165.t8 a_1941_450.t0 VPB.t2 sky130_fd_pr__pfet_01v8_hvt ad=0.08775 pd=0.84 as=0.16875 ps=1.2 w=0.45 l=0.15
X20 a_2060_165.t0 a_1725_36.t4 a_2229_36.t0 VNB.t1 sky130_fd_pr__nfet_01v8 ad=0.16875 pd=1.65 as=0.08775 ps=0.84 w=0.45 l=0.15
X21 a_2229_36.t1 RESET_B.t0 VGND.t0 VNB.t15 sky130_fd_pr__nfet_01v8 ad=0.08775 pd=0.84 as=0.08775 ps=0.84 w=0.45 l=0.15
X22 a_645_36.t3 D.t1 VPWR.t1 VPB.t12 sky130_fd_pr__pfet_01v8_hvt ad=0.08775 pd=0.84 as=0.16875 ps=1.65 w=0.45 l=0.15
X23 a_2060_165.t2 RESET_B.t2 VPWR.t0 VPB.t15 sky130_fd_pr__pfet_01v8_hvt ad=0.08775 pd=0.84 as=0.08775 ps=0.84 w=0.45 l=0.15
X24 a_2841_36.t0 a_2060_165.t3 VGND.t7 VNB.t5 sky130_fd_pr__nfet_01v8 ad=0.16875 pd=1.65 as=0.16875 ps=1.65 w=0.45 l=0.15
X25 a_1725_36.t2 a_141_36.t5 a_1088_165.t1 VPB.t6 sky130_fd_pr__pfet_01v8_hvt ad=0.20925 pd=1.38 as=0.17415 ps=1.38 w=0.45 l=0.15
X26 a_753_36.t3 a_393_36.t5 a_645_36.t1 VPB.t9 sky130_fd_pr__pfet_01v8_hvt ad=0.20925 pd=1.38 as=0.08775 ps=0.84 w=0.45 l=0.15
X27 a_1088_165.t3 a_753_36.t5 VPWR.t9 VPB.t5 sky130_fd_pr__pfet_01v8_hvt ad=0.17415 pd=1.38 as=0.30375 ps=2.37 w=0.81 l=0.15
X28 a_393_36.t0 a_141_36.t4 VGND.t8 VNB.t7 sky130_fd_pr__nfet_01v8 ad=0.16875 pd=1.65 as=0.16875 ps=1.65 w=0.45 l=0.15
X29 a_2841_36.t1 a_2060_165.t6 VPWR.t11 VPB.t11 sky130_fd_pr__pfet_01v8_hvt ad=0.23625 pd=2.01 as=0.23625 ps=2.01 w=0.63 l=0.15
X30 a_1941_36.t0 a_141_36.t2 a_1725_36.t0 VNB.t0 sky130_fd_pr__special_nfet_01v8 ad=0.15593 pd=1.2 as=0.1674 ps=1.29 w=0.36 l=0.15
X31 a_1725_36.t1 a_393_36.t2 a_1088_165.t0 VNB.t8 sky130_fd_pr__special_nfet_01v8 ad=0.1674 pd=1.29 as=0.13702 ps=1.2 w=0.36 l=0.15
C0 VGND Q 0.12516f
C1 VGND Q_N 0.10221f
C2 VGND VPWR 0.13306f
C4 VGND CLK 0.04537f
C5 VGND RESET_B 0.064f
C6 Q VPB 0.01836f
C7 Q_N VPB 0.01435f
C8 VPWR VPB 0.69688f
C9 VPWR Q 0.1707f
C10 VPWR Q_N 0.13857f
C11 VPB CLK 0.09785f
C12 RESET_B VPB 0.26969f
C13 VGND D 0.03531f
C14 VPWR CLK 0.04196f
C15 Q RESET_B 0.00136f
C17 VPWR RESET_B 0.58229f
C18 D VPB 0.11625f
C19 VPWR D 0.03564f
C20 VGND VPB 0.04601f
R0 Q_N Q_N.t1 344.07
R1 Q_N.n0 Q_N.t0 222.143
R2 Q_N Q_N.n0 19.2005
R3 Q_N.n0 Q_N 9.6005
R4 Q Q.t1 344.07
R5 Q.n0 Q.t0 222.143
R6 Q Q.n0 19.2005
R7 Q.n0 Q 9.6005
R8 VGND.n4 VGND.t7 253
R9 VGND.n34 VGND.t8 253
R10 VGND.n40 VGND.t2 253
R11 VGND.n28 VGND.t3 253
R12 VGND.n19 VGND.t1 249.8
R13 VGND.n60 VGND.t9 234.944
R14 VGND VGND.t4 231.744
R15 VGND VGND.t5 231.744
R16 VGND.n11 VGND.n10 197.8
R17 VGND.n10 VGND.t0 52.0005
R18 VGND.n10 VGND.t6 52.0005
R19 VGND.n3 VGND 15.9387
R20 VGND.n28 VGND.n27 15.7005
R21 VGND.n5 VGND.n4 12.8005
R22 VGND.n6 VGND.n5 12.8005
R23 VGND.n6 VGND.n0 12.8005
R24 VGND.n82 VGND.n1 12.8005
R25 VGND.n78 VGND.n1 12.8005
R26 VGND.n78 VGND.n77 12.8005
R27 VGND.n77 VGND.n76 12.8005
R28 VGND.n73 VGND.n72 12.8005
R29 VGND.n72 VGND.n71 12.8005
R30 VGND.n71 VGND.n13 12.8005
R31 VGND.n67 VGND.n13 12.8005
R32 VGND.n67 VGND.n66 12.8005
R33 VGND.n66 VGND.n65 12.8005
R34 VGND.n65 VGND.n15 12.8005
R35 VGND.n61 VGND.n15 12.8005
R36 VGND.n59 VGND.n58 12.8005
R37 VGND.n58 VGND.n17 12.8005
R38 VGND.n54 VGND.n53 12.8005
R39 VGND.n53 VGND.n52 12.8005
R40 VGND.n52 VGND.n20 12.8005
R41 VGND.n48 VGND.n20 12.8005
R42 VGND.n48 VGND.n47 12.8005
R43 VGND.n47 VGND.n46 12.8005
R44 VGND.n46 VGND.n22 12.8005
R45 VGND.n42 VGND.n22 12.8005
R46 VGND.n42 VGND.n41 12.8005
R47 VGND.n39 VGND.n24 12.8005
R48 VGND.n35 VGND.n24 12.8005
R49 VGND.n35 VGND.n34 12.8005
R50 VGND.n34 VGND.n33 12.8005
R51 VGND.n33 VGND.n26 12.8005
R52 VGND.n29 VGND.n26 12.8005
R53 VGND VGND.n83 9.6005
R54 VGND.n30 VGND.n29 9.3005
R55 VGND.n31 VGND.n26 9.3005
R56 VGND.n33 VGND.n32 9.3005
R57 VGND.n34 VGND.n25 9.3005
R58 VGND.n36 VGND.n35 9.3005
R59 VGND.n37 VGND.n24 9.3005
R60 VGND.n39 VGND.n38 9.3005
R61 VGND.n41 VGND.n23 9.3005
R62 VGND.n43 VGND.n42 9.3005
R63 VGND.n44 VGND.n22 9.3005
R64 VGND.n46 VGND.n45 9.3005
R65 VGND.n47 VGND.n21 9.3005
R66 VGND.n49 VGND.n48 9.3005
R67 VGND.n50 VGND.n20 9.3005
R68 VGND.n52 VGND.n51 9.3005
R69 VGND.n53 VGND.n18 9.3005
R70 VGND.n55 VGND.n54 9.3005
R71 VGND.n56 VGND.n17 9.3005
R72 VGND.n58 VGND.n57 9.3005
R73 VGND.n59 VGND.n16 9.3005
R74 VGND.n62 VGND.n61 9.3005
R75 VGND.n63 VGND.n15 9.3005
R76 VGND.n65 VGND.n64 9.3005
R77 VGND.n66 VGND.n14 9.3005
R78 VGND.n68 VGND.n67 9.3005
R79 VGND.n69 VGND.n13 9.3005
R80 VGND.n71 VGND.n70 9.3005
R81 VGND.n72 VGND.n12 9.3005
R82 VGND.n74 VGND.n73 9.3005
R83 VGND.n76 VGND.n75 9.3005
R84 VGND.n77 VGND.n9 9.3005
R85 VGND.n79 VGND.n78 9.3005
R86 VGND.n80 VGND.n1 9.3005
R87 VGND.n82 VGND.n81 9.3005
R88 VGND.n8 VGND.n0 9.3005
R89 VGND.n7 VGND.n6 9.3005
R90 VGND.n5 VGND.n2 9.3005
R91 VGND.n83 VGND.n0 6.4005
R92 VGND.n83 VGND.n82 6.4005
R93 VGND.n76 VGND.n11 6.4005
R94 VGND.n73 VGND.n11 6.4005
R95 VGND.n61 VGND.n60 6.4005
R96 VGND.n60 VGND.n59 6.4005
R97 VGND.n19 VGND.n17 6.4005
R98 VGND.n54 VGND.n19 6.4005
R99 VGND.n41 VGND.n40 6.4005
R100 VGND.n40 VGND.n39 6.4005
R101 VGND.n29 VGND.n28 6.4005
R102 VGND.n4 VGND.n3 6.08215
R103 VGND.n3 VGND.n2 0.2391
R104 VGND.n7 VGND.n2 0.063
R105 VGND.n8 VGND.n7 0.063
R106 VGND.n81 VGND.n8 0.063
R107 VGND.n81 VGND.n80 0.063
R108 VGND.n80 VGND.n79 0.063
R109 VGND.n79 VGND.n9 0.063
R110 VGND.n75 VGND.n9 0.063
R111 VGND.n75 VGND.n74 0.063
R112 VGND.n74 VGND.n12 0.063
R113 VGND.n70 VGND.n12 0.063
R114 VGND.n70 VGND.n69 0.063
R115 VGND.n69 VGND.n68 0.063
R116 VGND.n68 VGND.n14 0.063
R117 VGND.n64 VGND.n14 0.063
R118 VGND.n64 VGND.n63 0.063
R119 VGND.n63 VGND.n62 0.063
R120 VGND.n62 VGND.n16 0.063
R121 VGND.n57 VGND.n16 0.063
R122 VGND.n57 VGND.n56 0.063
R123 VGND.n56 VGND.n55 0.063
R124 VGND.n55 VGND.n18 0.063
R125 VGND.n51 VGND.n18 0.063
R126 VGND.n51 VGND.n50 0.063
R127 VGND.n50 VGND.n49 0.063
R128 VGND.n49 VGND.n21 0.063
R129 VGND.n45 VGND.n21 0.063
R130 VGND.n45 VGND.n44 0.063
R131 VGND.n44 VGND.n43 0.063
R132 VGND.n43 VGND.n23 0.063
R133 VGND.n38 VGND.n23 0.063
R134 VGND.n38 VGND.n37 0.063
R135 VGND.n37 VGND.n36 0.063
R136 VGND.n36 VGND.n25 0.063
R137 VGND.n32 VGND.n25 0.063
R138 VGND.n32 VGND.n31 0.063
R139 VGND.n31 VGND.n30 0.063
R140 VGND.n30 VGND.n27 0.063
R141 VGND.n27 VGND 0.03175
R142 VPWR.n19 VPWR.t1 683.168
R143 VPWR.n76 VPWR.t3 683.168
R144 VPWR.n84 VPWR.t11 661.976
R145 VPWR.n21 VPWR.t10 661.976
R146 VPWR.n23 VPWR.t6 661.976
R147 VPWR.n49 VPWR.n14 597.801
R148 VPWR.n70 VPWR.n7 597.801
R149 VPWR.n56 VPWR.t9 359.127
R150 VPWR.n3 VPWR.t8 328.07
R151 VPWR.n86 VPWR.t4 328.07
R152 VPWR.n14 VPWR.t2 85.3672
R153 VPWR.n14 VPWR.t7 85.3672
R154 VPWR.n7 VPWR.t0 85.3672
R155 VPWR.n7 VPWR.t5 85.3672
R156 VPWR.n86 VPWR.n85 31.9387
R157 VPWR.n4 VPWR.n3 25.6005
R158 VPWR.n3 VPWR 16.0005
R159 VPWR VPWR.n86 16.0005
R160 VPWR.n24 VPWR.n23 15.7005
R161 VPWR.n84 VPWR.n83 12.8005
R162 VPWR.n83 VPWR.n82 12.8005
R163 VPWR.n82 VPWR.n1 12.8005
R164 VPWR.n78 VPWR.n77 12.8005
R165 VPWR.n75 VPWR.n5 12.8005
R166 VPWR.n71 VPWR.n5 12.8005
R167 VPWR.n69 VPWR.n68 12.8005
R168 VPWR.n68 VPWR.n8 12.8005
R169 VPWR.n64 VPWR.n8 12.8005
R170 VPWR.n64 VPWR.n63 12.8005
R171 VPWR.n63 VPWR.n62 12.8005
R172 VPWR.n62 VPWR.n10 12.8005
R173 VPWR.n58 VPWR.n10 12.8005
R174 VPWR.n58 VPWR.n57 12.8005
R175 VPWR.n55 VPWR.n12 12.8005
R176 VPWR.n51 VPWR.n12 12.8005
R177 VPWR.n51 VPWR.n50 12.8005
R178 VPWR.n50 VPWR.n49 12.8005
R179 VPWR.n49 VPWR.n15 12.8005
R180 VPWR.n45 VPWR.n15 12.8005
R181 VPWR.n45 VPWR.n44 12.8005
R182 VPWR.n44 VPWR.n43 12.8005
R183 VPWR.n43 VPWR.n17 12.8005
R184 VPWR.n39 VPWR.n17 12.8005
R185 VPWR.n39 VPWR.n38 12.8005
R186 VPWR.n38 VPWR.n37 12.8005
R187 VPWR.n34 VPWR.n33 12.8005
R188 VPWR.n33 VPWR.n32 12.8005
R189 VPWR.n32 VPWR.n21 12.8005
R190 VPWR.n28 VPWR.n21 12.8005
R191 VPWR.n28 VPWR.n27 12.8005
R192 VPWR.n27 VPWR.n26 12.8005
R193 VPWR.n26 VPWR.n25 9.3005
R194 VPWR.n27 VPWR.n22 9.3005
R195 VPWR.n29 VPWR.n28 9.3005
R196 VPWR.n30 VPWR.n21 9.3005
R197 VPWR.n32 VPWR.n31 9.3005
R198 VPWR.n33 VPWR.n20 9.3005
R199 VPWR.n35 VPWR.n34 9.3005
R200 VPWR.n37 VPWR.n36 9.3005
R201 VPWR.n38 VPWR.n18 9.3005
R202 VPWR.n40 VPWR.n39 9.3005
R203 VPWR.n41 VPWR.n17 9.3005
R204 VPWR.n43 VPWR.n42 9.3005
R205 VPWR.n44 VPWR.n16 9.3005
R206 VPWR.n46 VPWR.n45 9.3005
R207 VPWR.n47 VPWR.n15 9.3005
R208 VPWR.n49 VPWR.n48 9.3005
R209 VPWR.n50 VPWR.n13 9.3005
R210 VPWR.n52 VPWR.n51 9.3005
R211 VPWR.n53 VPWR.n12 9.3005
R212 VPWR.n55 VPWR.n54 9.3005
R213 VPWR.n57 VPWR.n11 9.3005
R214 VPWR.n59 VPWR.n58 9.3005
R215 VPWR.n60 VPWR.n10 9.3005
R216 VPWR.n62 VPWR.n61 9.3005
R217 VPWR.n63 VPWR.n9 9.3005
R218 VPWR.n65 VPWR.n64 9.3005
R219 VPWR.n66 VPWR.n8 9.3005
R220 VPWR.n68 VPWR.n67 9.3005
R221 VPWR.n69 VPWR.n6 9.3005
R222 VPWR.n72 VPWR.n71 9.3005
R223 VPWR.n73 VPWR.n5 9.3005
R224 VPWR.n75 VPWR.n74 9.3005
R225 VPWR.n77 VPWR.n2 9.3005
R226 VPWR.n79 VPWR.n78 9.3005
R227 VPWR.n80 VPWR.n1 9.3005
R228 VPWR.n82 VPWR.n81 9.3005
R229 VPWR.n83 VPWR.n0 9.3005
R230 VPWR.n4 VPWR.n1 6.4005
R231 VPWR.n78 VPWR.n4 6.4005
R232 VPWR.n77 VPWR.n76 6.4005
R233 VPWR.n76 VPWR.n75 6.4005
R234 VPWR.n71 VPWR.n70 6.4005
R235 VPWR.n70 VPWR.n69 6.4005
R236 VPWR.n57 VPWR.n56 6.4005
R237 VPWR.n56 VPWR.n55 6.4005
R238 VPWR.n37 VPWR.n19 6.4005
R239 VPWR.n34 VPWR.n19 6.4005
R240 VPWR.n26 VPWR.n23 6.4005
R241 VPWR.n85 VPWR.n84 6.08215
R242 VPWR.n85 VPWR.n0 0.2391
R243 VPWR.n81 VPWR.n0 0.063
R244 VPWR.n81 VPWR.n80 0.063
R245 VPWR.n80 VPWR.n79 0.063
R246 VPWR.n79 VPWR.n2 0.063
R247 VPWR.n74 VPWR.n2 0.063
R248 VPWR.n74 VPWR.n73 0.063
R249 VPWR.n73 VPWR.n72 0.063
R250 VPWR.n72 VPWR.n6 0.063
R251 VPWR.n67 VPWR.n6 0.063
R252 VPWR.n67 VPWR.n66 0.063
R253 VPWR.n66 VPWR.n65 0.063
R254 VPWR.n65 VPWR.n9 0.063
R255 VPWR.n61 VPWR.n9 0.063
R256 VPWR.n61 VPWR.n60 0.063
R257 VPWR.n60 VPWR.n59 0.063
R258 VPWR.n59 VPWR.n11 0.063
R259 VPWR.n54 VPWR.n11 0.063
R260 VPWR.n54 VPWR.n53 0.063
R261 VPWR.n53 VPWR.n52 0.063
R262 VPWR.n52 VPWR.n13 0.063
R263 VPWR.n48 VPWR.n13 0.063
R264 VPWR.n48 VPWR.n47 0.063
R265 VPWR.n47 VPWR.n46 0.063
R266 VPWR.n46 VPWR.n16 0.063
R267 VPWR.n42 VPWR.n16 0.063
R268 VPWR.n42 VPWR.n41 0.063
R269 VPWR.n41 VPWR.n40 0.063
R270 VPWR.n40 VPWR.n18 0.063
R271 VPWR.n36 VPWR.n18 0.063
R272 VPWR.n36 VPWR.n35 0.063
R273 VPWR.n35 VPWR.n20 0.063
R274 VPWR.n31 VPWR.n20 0.063
R275 VPWR.n31 VPWR.n30 0.063
R276 VPWR.n30 VPWR.n29 0.063
R277 VPWR.n29 VPWR.n22 0.063
R278 VPWR.n25 VPWR.n22 0.063
R279 VPWR.n25 VPWR.n24 0.063
R280 VPWR.n24 VPWR 0.03175
R281 RESET_B.n1 RESET_B.t1 424.697
R282 RESET_B.n0 RESET_B.t0 424.697
R283 RESET_B RESET_B.n0 217.03
R284 RESET_B.n1 RESET_B.t3 193.337
R285 RESET_B.n0 RESET_B.t2 193.337
R286 RESET_B RESET_B.n1 161.601
R287 D.n0 D.t1 290.808
R288 D.n0 D.t0 290.808
R289 D D.n0 158.4
R290 CLK.n0 CLK.t1 319.728
R291 CLK.n0 CLK.t0 232.968
R292 CLK CLK.n0 158.4
R293 VPB.t14 VPB.t5 777.274
R294 VPB.t11 VPB.t1 604.545
R295 VPB.t4 VPB.t11 604.545
R296 VPB.t0 VPB.t4 604.545
R297 VPB.t10 VPB.t12 604.545
R298 VPB.t13 VPB.t10 604.545
R299 VPB.t6 VPB.t8 518.183
R300 VPB.t9 VPB.t7 518.183
R301 VPB.t8 VPB.t2 431.818
R302 VPB.t7 VPB.t3 431.818
R303 VPB.t5 VPB.t6 345.455
R304 VPB VPB.t13 302.274
R305 VPB.t15 VPB.t0 259.091
R306 VPB.t2 VPB.t15 259.091
R307 VPB.t3 VPB.t14 259.091
R308 VPB.t12 VPB.t9 259.091
R309 VNB.t14 VNB.t10 3600
R310 VNB.t5 VNB.t2 2800
R311 VNB.t3 VNB.t5 2800
R312 VNB.t1 VNB.t3 2800
R313 VNB.t7 VNB.t12 2800
R314 VNB.t13 VNB.t7 2800
R315 VNB.t8 VNB.t0 2400
R316 VNB.t6 VNB.t9 2400
R317 VNB.t0 VNB.t4 2000
R318 VNB.t9 VNB.t11 2000
R319 VNB.t10 VNB.t8 1600
R320 VNB VNB.t13 1400
R321 VNB.t15 VNB.t1 1200
R322 VNB.t4 VNB.t15 1200
R323 VNB.t11 VNB.t14 1200
R324 VNB.t12 VNB.t6 1200
R325 a_2229_36.t0 a_2229_36.t1 104.001
R326 a_1941_36.t0 a_1941_36.t1 219
R327 a_1149_36.t0 a_1149_36.t1 104.001
R328 a_969_36.t0 a_969_36.t1 219
R329 a_1941_450.t0 a_1941_450.t1 328.334
R330 a_969_450.n0 a_969_450.t1 242.968
R331 a_969_450.t0 a_969_450.n0 85.3672
R332 a_969_450.n0 a_969_450.t2 1287.6
R333 a_645_36.n0 a_645_36.t2 56.0005
R334 a_645_36.t0 a_645_36.n0 65.0005
R335 a_645_36.n0 a_645_36.n1 907.601
R336 a_645_36.n1 a_645_36.t3 85.3672
R337 a_645_36.n1 a_645_36.t1 85.3672
R338 a_2841_36.t0 a_2841_36.n0 259.401
R339 a_2841_36.n0 a_2841_36.n1 177.601
R340 a_2841_36.n1 a_2841_36.t2 204.048
R341 a_2841_36.n1 a_2841_36.t3 247.428
R342 a_2841_36.n0 a_2841_36.t1 681.177
R343 a_1725_36.n0 a_1725_36.t1 245
R344 a_1725_36.t0 a_1725_36.n0 65.0005
R345 a_1725_36.n0 a_1725_36.n2 242.601
R346 a_1725_36.n2 a_1725_36.n3 305.601
R347 a_1725_36.n3 a_1725_36.t4 251.177
R348 a_1725_36.n3 a_1725_36.t5 366.856
R349 a_1725_36.n2 a_1725_36.n1 652.201
R350 a_1725_36.n1 a_1725_36.t2 321.767
R351 a_1725_36.n1 a_1725_36.t3 85.3672
R352 a_2060_165.t0 a_2060_165.n1 249.8
R353 a_2060_165.n1 a_2060_165.n3 16.0005
R354 a_2060_165.n3 a_2060_165.n5 210.55
R355 a_2060_165.n5 a_2060_165.n4 168.701
R356 a_2060_165.n5 a_2060_165.t7 231.361
R357 a_2060_165.n5 a_2060_165.t4 187.981
R358 a_2060_165.n4 a_2060_165.t6 303.661
R359 a_2060_165.n4 a_2060_165.t3 216.9
R360 a_2060_165.n3 a_2060_165.n2 645.801
R361 a_2060_165.n2 a_2060_165.t2 85.3672
R362 a_2060_165.n2 a_2060_165.t1 85.3672
R363 a_2060_165.n1 a_2060_165.n0 235.379
R364 a_2060_165.n0 a_2060_165.t5 161.036
R365 a_2060_165.n0 a_2060_165.t8 450.236
R366 a_753_36.t0 a_753_36.n0 245
R367 a_753_36.n0 a_753_36.t1 65.0005
R368 a_753_36.n0 a_753_36.n2 242.601
R369 a_753_36.n2 a_753_36.n3 382.401
R370 a_753_36.n3 a_753_36.t4 222.256
R371 a_753_36.n3 a_753_36.t5 309.017
R372 a_753_36.n2 a_753_36.n1 652.201
R373 a_753_36.n1 a_753_36.t3 321.767
R374 a_753_36.n1 a_753_36.t2 85.3672
R375 a_1088_165.n0 a_1088_165.t2 107.144
R376 a_1088_165.t0 a_1088_165.n0 65.0005
R377 a_1088_165.n0 a_1088_165.n2 204.201
R378 a_1088_165.n2 a_1088_165.n3 331.378
R379 a_1088_165.n3 a_1088_165.t4 161.036
R380 a_1088_165.n3 a_1088_165.t5 450.236
R381 a_1088_165.n2 a_1088_165.n1 690.601
R382 a_1088_165.n1 a_1088_165.t3 139.846
R383 a_1088_165.n1 a_1088_165.t1 85.3672
R384 a_393_36.t0 a_393_36.n0 253
R385 a_393_36.n0 a_393_36.n1 10.2246
R386 a_393_36.n1 a_393_36.n2 0.321929
R387 a_393_36.n2 a_393_36.n3 10.9076
R388 a_393_36.n3 a_393_36.t4 425.334
R389 a_393_36.n3 a_393_36.t2 301.957
R390 a_393_36.n2 a_393_36.t3 308.091
R391 a_393_36.n1 a_393_36.t5 680.521
R392 a_393_36.n0 a_393_36.t1 700.376
R393 a_141_36.t0 a_141_36.n4 259.401
R394 a_141_36.n4 a_141_36.n5 177.601
R395 a_141_36.n5 a_141_36.t4 232.968
R396 a_141_36.n5 a_141_36.t7 319.728
R397 a_141_36.n4 a_141_36.n0 12.8005
R398 a_141_36.n0 a_141_36.n1 10.45
R399 a_141_36.n1 a_141_36.n2 0.561253
R400 a_141_36.n2 a_141_36.n3 2.0005
R401 a_141_36.n3 a_141_36.t2 308.413
R402 a_141_36.n3 a_141_36.t5 680.521
R403 a_141_36.n2 a_141_36.t6 351.471
R404 a_141_36.n1 a_141_36.t3 375.257
R405 a_141_36.n0 a_141_36.t1 668.376
C21 Q_N VNB 0.27171f
C22 Q VNB 0.25016f
C23 VGND VNB 2.104f
C24 VPWR VNB 1.43702f
C25 RESET_B VNB 1.29381f
C26 D VNB 0.22214f
C27 CLK VNB 0.25869f
C28 VPB VNB 3.90497f
C29 a_141_36.t0 VNB 0.0884f
C30 a_141_36.t1 VNB 0.12414f
C31 a_141_36.n0 VNB 0.24399f
C32 a_141_36.t3 VNB 0.06958f
C33 a_141_36.n1 VNB 0.70792f
C34 a_141_36.t6 VNB 0.07113f
C35 a_141_36.n2 VNB 0.55936f
C36 a_141_36.t5 VNB 0.11983f
C37 a_141_36.n3 VNB 0.7474f
C38 a_141_36.t2 VNB 0.06526f
C39 a_141_36.n4 VNB 0.41302f
C40 a_141_36.t7 VNB 0.05303f
C41 a_141_36.t4 VNB 0.03506f
C42 a_141_36.n5 VNB 0.18077f
C43 a_393_36.t0 VNB 0.0948f
C44 a_393_36.t1 VNB 0.15352f
C45 a_393_36.n0 VNB 0.57599f
C46 a_393_36.t5 VNB 0.13479f
C47 a_393_36.n1 VNB 0.60081f
C48 a_393_36.t3 VNB 0.07323f
C49 a_393_36.n2 VNB 0.7375f
C50 a_393_36.n3 VNB 0.50714f
C51 a_393_36.t2 VNB 0.05653f
C52 a_393_36.t4 VNB 0.15251f
C53 a_1088_165.t0 VNB 0.01998f
C54 a_1088_165.n0 VNB 0.06765f
C55 a_1088_165.t3 VNB 0.09729f
C56 a_1088_165.t1 VNB 0.02498f
C57 a_1088_165.n1 VNB 0.09935f
C58 a_1088_165.n2 VNB 0.52003f
C59 a_1088_165.t5 VNB 0.06429f
C60 a_1088_165.t4 VNB 0.027f
C61 a_1088_165.n3 VNB 0.22673f
C62 a_1088_165.t2 VNB 0.07532f
C63 a_753_36.t0 VNB 0.0715f
C64 a_753_36.n0 VNB 0.11402f
C65 a_753_36.t3 VNB 0.08937f
C66 a_753_36.t2 VNB 0.02371f
C67 a_753_36.n1 VNB 0.12519f
C68 a_753_36.n2 VNB 0.49624f
C69 a_753_36.t5 VNB 0.05801f
C70 a_753_36.t4 VNB 0.04008f
C71 a_753_36.n3 VNB 0.18808f
C72 a_753_36.t1 VNB 0.01897f
C73 a_2060_165.t0 VNB 0.07405f
C74 a_2060_165.t8 VNB 0.05537f
C75 a_2060_165.t5 VNB 0.02325f
C76 a_2060_165.n0 VNB 0.14287f
C77 a_2060_165.n1 VNB 0.26174f
C78 a_2060_165.t2 VNB 0.02151f
C79 a_2060_165.t1 VNB 0.02151f
C80 a_2060_165.n2 VNB 0.05624f
C81 a_2060_165.n3 VNB 0.40317f
C82 a_2060_165.t3 VNB 0.02813f
C83 a_2060_165.t6 VNB 0.04467f
C84 a_2060_165.n4 VNB 0.18663f
C85 a_2060_165.t4 VNB 0.03144f
C86 a_2060_165.t7 VNB 0.05294f
C87 a_2060_165.n5 VNB 0.23833f
C88 a_1725_36.t0 VNB 0.01908f
C89 a_1725_36.n0 VNB 0.11469f
C90 a_1725_36.t2 VNB 0.0899f
C91 a_1725_36.t3 VNB 0.02385f
C92 a_1725_36.n1 VNB 0.12593f
C93 a_1725_36.n2 VNB 0.43499f
C94 a_1725_36.t5 VNB 0.05089f
C95 a_1725_36.t4 VNB 0.03652f
C96 a_1725_36.n3 VNB 0.15893f
C97 a_1725_36.t1 VNB 0.07192f
C98 a_2841_36.t0 VNB 0.05409f
C99 a_2841_36.t1 VNB 0.07845f
C100 a_2841_36.n0 VNB 0.38305f
C101 a_2841_36.t3 VNB 0.0383f
C102 a_2841_36.t2 VNB 0.02385f
C103 a_2841_36.n1 VNB 0.10234f
C104 a_645_36.t0 VNB 0.01931f
C105 a_645_36.n0 VNB 0.2809f
C106 a_645_36.t3 VNB 0.02414f
C107 a_645_36.t1 VNB 0.02414f
C108 a_645_36.n1 VNB 0.14137f
C109 a_645_36.t2 VNB 0.02727f
C110 a_969_450.t0 VNB 0.01976f
C111 a_969_450.n0 VNB 0.25037f
C112 a_969_450.t2 VNB 0.22169f
C113 a_969_450.t1 VNB 0.05625f
C114 a_1941_450.t0 VNB 0.02074f
C115 a_1941_450.t1 VNB 0.02074f
C116 a_969_36.t0 VNB 0.0164f
C117 a_969_36.t1 VNB 0.02024f
C118 a_1149_36.t0 VNB 0.01067f
C119 a_1149_36.t1 VNB 0.01067f
C120 a_1941_36.t0 VNB 0.01671f
C121 a_1941_36.t1 VNB 0.02062f
C122 a_2229_36.t0 VNB 0.01114f
C123 a_2229_36.t1 VNB 0.01114f
C124 VPB.t1 VNB 0.2553f
C125 VPB.t11 VNB 0.22339f
C126 VPB.t4 VNB 0.22339f
C127 VPB.t0 VNB 0.15956f
C128 VPB.t15 VNB 0.09574f
C129 VPB.t2 VNB 0.12765f
C130 VPB.t8 VNB 0.17552f
C131 VPB.t6 VNB 0.15956f
C132 VPB.t5 VNB 0.20743f
C133 VPB.t14 VNB 0.19148f
C134 VPB.t3 VNB 0.12765f
C135 VPB.t7 VNB 0.17552f
C136 VPB.t9 VNB 0.14361f
C137 VPB.t12 VNB 0.15956f
C138 VPB.t10 VNB 0.22339f
C139 VPB.t13 VNB 0.16754f
C140 CLK.t1 VNB 0.04659f
C141 CLK.t0 VNB 0.0308f
C142 CLK.n0 VNB 0.14726f
C143 D.t1 VNB 0.05528f
C144 D.t0 VNB 0.05528f
C145 D.n0 VNB 0.22521f
C146 RESET_B.t2 VNB 0.04033f
C147 RESET_B.t0 VNB 0.07954f
C148 RESET_B.n0 VNB 0.43949f
C149 RESET_B.t3 VNB 0.04033f
C150 RESET_B.t1 VNB 0.07954f
C151 RESET_B.n1 VNB 0.15413f
C152 VPWR.n0 VNB 0.25659f
C153 VPWR.t11 VNB 0.03646f
C154 VPWR.n1 VNB 0.01573f
C155 VPWR.n2 VNB 0.04196f
C156 VPWR.t8 VNB 0.0603f
C157 VPWR.n3 VNB 0.03935f
C158 VPWR.n4 VNB 0.03147f
C159 VPWR.t3 VNB 0.02528f
C160 VPWR.n5 VNB 0.02098f
C161 VPWR.n6 VNB 0.04196f
C162 VPWR.t0 VNB 0.0071f
C163 VPWR.t5 VNB 0.0071f
C164 VPWR.n7 VNB 0.01477f
C165 VPWR.n8 VNB 0.02098f
C166 VPWR.n9 VNB 0.04196f
C167 VPWR.n10 VNB 0.02098f
C168 VPWR.n11 VNB 0.04196f
C169 VPWR.t9 VNB 0.04661f
C170 VPWR.n12 VNB 0.02098f
C171 VPWR.n13 VNB 0.04196f
C172 VPWR.t2 VNB 0.0071f
C173 VPWR.t7 VNB 0.0071f
C174 VPWR.n14 VNB 0.01477f
C175 VPWR.n15 VNB 0.02098f
C176 VPWR.n16 VNB 0.04196f
C177 VPWR.n17 VNB 0.02098f
C178 VPWR.n18 VNB 0.04196f
C179 VPWR.t1 VNB 0.02528f
C180 VPWR.n19 VNB 0.04924f
C181 VPWR.n20 VNB 0.04196f
C182 VPWR.t10 VNB 0.03646f
C183 VPWR.n21 VNB 0.06997f
C184 VPWR.n22 VNB 0.04196f
C185 VPWR.t6 VNB 0.03646f
C186 VPWR.n23 VNB 0.0688f
C187 VPWR.n24 VNB 0.03788f
C188 VPWR.n25 VNB 0.04196f
C189 VPWR.n26 VNB 0.01573f
C190 VPWR.n27 VNB 0.02098f
C191 VPWR.n28 VNB 0.02098f
C192 VPWR.n29 VNB 0.04196f
C193 VPWR.n30 VNB 0.04196f
C194 VPWR.n31 VNB 0.04196f
C195 VPWR.n32 VNB 0.02098f
C196 VPWR.n33 VNB 0.02098f
C197 VPWR.n34 VNB 0.01573f
C198 VPWR.n35 VNB 0.04196f
C199 VPWR.n36 VNB 0.04196f
C200 VPWR.n37 VNB 0.01573f
C201 VPWR.n38 VNB 0.02098f
C202 VPWR.n39 VNB 0.02098f
C203 VPWR.n40 VNB 0.04196f
C204 VPWR.n41 VNB 0.04196f
C205 VPWR.n42 VNB 0.04196f
C206 VPWR.n43 VNB 0.02098f
C207 VPWR.n44 VNB 0.02098f
C208 VPWR.n45 VNB 0.02098f
C209 VPWR.n46 VNB 0.04196f
C210 VPWR.n47 VNB 0.04196f
C211 VPWR.n48 VNB 0.04196f
C212 VPWR.n49 VNB 0.05713f
C213 VPWR.n50 VNB 0.02098f
C214 VPWR.n51 VNB 0.02098f
C215 VPWR.n52 VNB 0.04196f
C216 VPWR.n53 VNB 0.04196f
C217 VPWR.n54 VNB 0.04196f
C218 VPWR.n55 VNB 0.01573f
C219 VPWR.n56 VNB 0.07074f
C220 VPWR.n57 VNB 0.01573f
C221 VPWR.n58 VNB 0.02098f
C222 VPWR.n59 VNB 0.04196f
C223 VPWR.n60 VNB 0.04196f
C224 VPWR.n61 VNB 0.04196f
C225 VPWR.n62 VNB 0.02098f
C226 VPWR.n63 VNB 0.02098f
C227 VPWR.n64 VNB 0.02098f
C228 VPWR.n65 VNB 0.04196f
C229 VPWR.n66 VNB 0.04196f
C230 VPWR.n67 VNB 0.04196f
C231 VPWR.n68 VNB 0.02098f
C232 VPWR.n69 VNB 0.01573f
C233 VPWR.n70 VNB 0.04664f
C234 VPWR.n71 VNB 0.01573f
C235 VPWR.n72 VNB 0.04196f
C236 VPWR.n73 VNB 0.04196f
C237 VPWR.n74 VNB 0.04196f
C238 VPWR.n75 VNB 0.01573f
C239 VPWR.n76 VNB 0.04924f
C240 VPWR.n77 VNB 0.01573f
C241 VPWR.n78 VNB 0.01573f
C242 VPWR.n79 VNB 0.04196f
C243 VPWR.n80 VNB 0.04196f
C244 VPWR.n81 VNB 0.04196f
C245 VPWR.n82 VNB 0.02098f
C246 VPWR.n83 VNB 0.02098f
C247 VPWR.n84 VNB 0.07849f
C248 VPWR.n85 VNB 0.20496f
C249 VPWR.t4 VNB 0.0603f
C250 VPWR.n86 VNB 0.0518f
C251 VGND.t5 VNB 0.02431f
C252 VGND.n0 VNB 0.01103f
C253 VGND.n1 VNB 0.0147f
C254 VGND.n2 VNB 0.17982f
C255 VGND.t7 VNB 0.01728f
C256 VGND.t4 VNB 0.02431f
C257 VGND.n3 VNB 0.12934f
C258 VGND.n4 VNB 0.04827f
C259 VGND.n5 VNB 0.0147f
C260 VGND.n6 VNB 0.0147f
C261 VGND.n7 VNB 0.02941f
C262 VGND.n8 VNB 0.02941f
C263 VGND.n9 VNB 0.02941f
C264 VGND.t0 VNB 0.00498f
C265 VGND.t6 VNB 0.00498f
C266 VGND.n10 VNB 0.01091f
C267 VGND.n11 VNB 0.02845f
C268 VGND.n12 VNB 0.02941f
C269 VGND.n13 VNB 0.0147f
C270 VGND.n14 VNB 0.02941f
C271 VGND.n15 VNB 0.0147f
C272 VGND.n16 VNB 0.02941f
C273 VGND.t9 VNB 0.02447f
C274 VGND.n17 VNB 0.01103f
C275 VGND.n18 VNB 0.02941f
C276 VGND.t1 VNB 0.01695f
C277 VGND.n19 VNB 0.0316f
C278 VGND.n20 VNB 0.0147f
C279 VGND.n21 VNB 0.02941f
C280 VGND.n22 VNB 0.0147f
C281 VGND.n23 VNB 0.02941f
C282 VGND.t2 VNB 0.01728f
C283 VGND.n24 VNB 0.0147f
C284 VGND.n25 VNB 0.02941f
C285 VGND.t8 VNB 0.01728f
C286 VGND.n26 VNB 0.0147f
C287 VGND.n27 VNB 0.02655f
C288 VGND.t3 VNB 0.01728f
C289 VGND.n28 VNB 0.04148f
C290 VGND.n29 VNB 0.01103f
C291 VGND.n30 VNB 0.02941f
C292 VGND.n31 VNB 0.02941f
C293 VGND.n32 VNB 0.02941f
C294 VGND.n33 VNB 0.0147f
C295 VGND.n34 VNB 0.0423f
C296 VGND.n35 VNB 0.0147f
C297 VGND.n36 VNB 0.02941f
C298 VGND.n37 VNB 0.02941f
C299 VGND.n38 VNB 0.02941f
C300 VGND.n39 VNB 0.01103f
C301 VGND.n40 VNB 0.03495f
C302 VGND.n41 VNB 0.01103f
C303 VGND.n42 VNB 0.0147f
C304 VGND.n43 VNB 0.02941f
C305 VGND.n44 VNB 0.02941f
C306 VGND.n45 VNB 0.02941f
C307 VGND.n46 VNB 0.0147f
C308 VGND.n47 VNB 0.0147f
C309 VGND.n48 VNB 0.0147f
C310 VGND.n49 VNB 0.02941f
C311 VGND.n50 VNB 0.02941f
C312 VGND.n51 VNB 0.02941f
C313 VGND.n52 VNB 0.0147f
C314 VGND.n53 VNB 0.0147f
C315 VGND.n54 VNB 0.01103f
C316 VGND.n55 VNB 0.02941f
C317 VGND.n56 VNB 0.02941f
C318 VGND.n57 VNB 0.02941f
C319 VGND.n58 VNB 0.0147f
C320 VGND.n59 VNB 0.01103f
C321 VGND.n60 VNB 0.03174f
C322 VGND.n61 VNB 0.01103f
C323 VGND.n62 VNB 0.02941f
C324 VGND.n63 VNB 0.02941f
C325 VGND.n64 VNB 0.02941f
C326 VGND.n65 VNB 0.0147f
C327 VGND.n66 VNB 0.0147f
C328 VGND.n67 VNB 0.0147f
C329 VGND.n68 VNB 0.02941f
C330 VGND.n69 VNB 0.02941f
C331 VGND.n70 VNB 0.02941f
C332 VGND.n71 VNB 0.0147f
C333 VGND.n72 VNB 0.0147f
C334 VGND.n73 VNB 0.01103f
C335 VGND.n74 VNB 0.02941f
C336 VGND.n75 VNB 0.02941f
C337 VGND.n76 VNB 0.01103f
C338 VGND.n77 VNB 0.0147f
C339 VGND.n78 VNB 0.0147f
C340 VGND.n79 VNB 0.02941f
C341 VGND.n80 VNB 0.02941f
C342 VGND.n81 VNB 0.02941f
C343 VGND.n82 VNB 0.01103f
C344 VGND.n83 VNB 0.01286f
C345 Q.t1 VNB 0.11564f
C346 Q.t0 VNB 0.06189f
C347 Q.n0 VNB 0.05233f
C348 Q_N.t1 VNB 0.08172f
C349 Q_N.t0 VNB 0.04373f
C350 Q_N.n0 VNB 0.03697f
.ends

.subckt sky130_efx_lvdig__dfrbp_2 CLK D RESET_B Q Q_N VGND VNB VPB VPWR
X0 VGND.t3 a_2060_165.t4 Q.t2 VNB.t1 sky130_fd_pr__nfet_01v8 ad=0.23625 pd=2.01 as=0.12285 ps=1.02 w=0.63 l=0.15
X1 a_2949_36.t0 a_2060_165.t7 VPWR.t2 VPB.t1 sky130_fd_pr__pfet_01v8_hvt ad=0.23625 pd=2.01 as=0.23625 ps=2.01 w=0.63 l=0.15
X2 Q.t1 a_2060_165.t5 VGND.t1 VNB.t0 sky130_fd_pr__nfet_01v8 ad=0.12285 pd=1.02 as=0.23625 ps=2.01 w=0.63 l=0.15
X3 a_969_450.t2 a_141_36.t6 a_753_36.t3 VPB.t15 sky130_fd_pr__pfet_01v8_hvt ad=0.16875 pd=1.2 as=0.20925 ps=1.38 w=0.45 l=0.15
X4 VPWR.t9 a_1088_165.t5 a_969_450.t0 VPB.t10 sky130_fd_pr__pfet_01v8_hvt ad=0.08775 pd=0.84 as=0.16875 ps=1.2 w=0.45 l=0.15
X5 a_141_36.t1 CLK.t1 VPWR.t12 VPB.t16 sky130_fd_pr__pfet_01v8_hvt ad=0.23625 pd=2.01 as=0.23625 ps=2.01 w=0.63 l=0.15
X6 VPWR.t3 a_1725_36.t5 a_2060_165.t2 VPB.t3 sky130_fd_pr__pfet_01v8_hvt ad=0.16875 pd=1.65 as=0.08775 ps=0.84 w=0.45 l=0.15
X7 a_645_36.t1 D.t0 VGND.t10 VNB.t13 sky130_fd_pr__nfet_01v8 ad=0.08258 pd=0.84 as=0.16875 ps=1.65 w=0.45 l=0.15
X8 a_753_36.t2 a_141_36.t3 a_645_36.t3 VNB.t14 sky130_fd_pr__special_nfet_01v8 ad=0.1674 pd=1.29 as=0.08258 ps=0.84 w=0.36 l=0.15
X9 a_969_450.t1 RESET_B.t3 VPWR.t11 VPB.t12 sky130_fd_pr__pfet_01v8_hvt ad=0.16875 pd=1.65 as=0.08775 ps=0.84 w=0.45 l=0.15
X10 Q.t0 a_2060_165.t9 VPWR.t1 VPB.t0 sky130_fd_pr__pfet_01v8_hvt ad=0.2106 pd=1.47 as=0.405 ps=2.91 w=1.08 l=0.15
X11 Q_N.t2 a_2949_36.t5 VPWR.t6 VPB.t7 sky130_fd_pr__pfet_01v8_hvt ad=0.2106 pd=1.47 as=0.405 ps=2.91 w=1.08 l=0.15
X12 a_1941_450.t0 a_393_36.t4 a_1725_36.t0 VPB.t6 sky130_fd_pr__pfet_01v8_hvt ad=0.16875 pd=1.2 as=0.20925 ps=1.38 w=0.45 l=0.15
X13 VGND.t5 a_2060_165.t6 a_1941_36.t0 VNB.t4 sky130_fd_pr__nfet_01v8 ad=0.08775 pd=0.84 as=0.15593 ps=1.2 w=0.45 l=0.15
X14 a_2949_36.t1 a_2060_165.t3 VGND.t9 VNB.t9 sky130_fd_pr__nfet_01v8 ad=0.16875 pd=1.65 as=0.16875 ps=1.65 w=0.45 l=0.15
X15 VPWR.t4 a_2060_165.t8 Q.t3 VPB.t4 sky130_fd_pr__pfet_01v8_hvt ad=0.405 pd=2.91 as=0.2106 ps=1.47 w=1.08 l=0.15
X16 VPWR.t7 a_2949_36.t4 Q_N.t3 VPB.t8 sky130_fd_pr__pfet_01v8_hvt ad=0.405 pd=2.91 as=0.2106 ps=1.47 w=1.08 l=0.15
X17 Q_N.t1 a_2949_36.t3 VGND.t7 VNB.t7 sky130_fd_pr__nfet_01v8 ad=0.12285 pd=1.02 as=0.23625 ps=2.01 w=0.63 l=0.15
X18 a_141_36.t0 CLK.t0 VGND.t2 VNB.t17 sky130_fd_pr__nfet_01v8 ad=0.16875 pd=1.65 as=0.16875 ps=1.65 w=0.45 l=0.15
X19 a_1088_165.t1 a_753_36.t4 VGND.t6 VNB.t5 sky130_fd_pr__nfet_01v8 ad=0.13702 pd=1.2 as=0.23625 ps=2.01 w=0.63 l=0.15
X20 a_393_36.t1 a_141_36.t7 VPWR.t10 VPB.t17 sky130_fd_pr__pfet_01v8_hvt ad=0.23625 pd=2.01 as=0.23625 ps=2.01 w=0.63 l=0.15
X21 a_969_36.t0 a_393_36.t3 a_753_36.t1 VNB.t6 sky130_fd_pr__special_nfet_01v8 ad=0.15593 pd=1.2 as=0.1674 ps=1.29 w=0.36 l=0.15
X22 a_1149_36.t0 a_1088_165.t4 a_969_36.t1 VNB.t10 sky130_fd_pr__nfet_01v8 ad=0.08775 pd=0.84 as=0.15593 ps=1.2 w=0.45 l=0.15
X23 VGND.t8 RESET_B.t1 a_1149_36.t1 VNB.t11 sky130_fd_pr__nfet_01v8 ad=0.16875 pd=1.65 as=0.08775 ps=0.84 w=0.45 l=0.15
X24 VPWR.t8 a_2060_165.t10 a_1941_450.t1 VPB.t9 sky130_fd_pr__pfet_01v8_hvt ad=0.08775 pd=0.84 as=0.16875 ps=1.2 w=0.45 l=0.15
X25 a_2060_165.t1 a_1725_36.t4 a_2229_36.t0 VNB.t3 sky130_fd_pr__nfet_01v8 ad=0.16875 pd=1.65 as=0.08775 ps=0.84 w=0.45 l=0.15
X26 a_2229_36.t1 RESET_B.t0 VGND.t0 VNB.t12 sky130_fd_pr__nfet_01v8 ad=0.08775 pd=0.84 as=0.08775 ps=0.84 w=0.45 l=0.15
X27 a_645_36.t2 D.t1 VPWR.t0 VPB.t14 sky130_fd_pr__pfet_01v8_hvt ad=0.08775 pd=0.84 as=0.16875 ps=1.65 w=0.45 l=0.15
X28 a_2060_165.t0 RESET_B.t2 VPWR.t13 VPB.t13 sky130_fd_pr__pfet_01v8_hvt ad=0.08775 pd=0.84 as=0.08775 ps=0.84 w=0.45 l=0.15
X29 a_1725_36.t2 a_141_36.t5 a_1088_165.t3 VPB.t11 sky130_fd_pr__pfet_01v8_hvt ad=0.20925 pd=1.38 as=0.17415 ps=1.38 w=0.45 l=0.15
X30 VGND.t4 a_2949_36.t2 Q_N.t0 VNB.t2 sky130_fd_pr__nfet_01v8 ad=0.23625 pd=2.01 as=0.12285 ps=1.02 w=0.63 l=0.15
X31 a_753_36.t0 a_393_36.t5 a_645_36.t0 VPB.t2 sky130_fd_pr__pfet_01v8_hvt ad=0.20925 pd=1.38 as=0.08775 ps=0.84 w=0.45 l=0.15
X32 a_1088_165.t2 a_753_36.t5 VPWR.t5 VPB.t5 sky130_fd_pr__pfet_01v8_hvt ad=0.17415 pd=1.38 as=0.30375 ps=2.37 w=0.81 l=0.15
X33 a_393_36.t0 a_141_36.t4 VGND.t11 VNB.t15 sky130_fd_pr__nfet_01v8 ad=0.16875 pd=1.65 as=0.16875 ps=1.65 w=0.45 l=0.15
X34 a_1941_36.t1 a_141_36.t2 a_1725_36.t3 VNB.t16 sky130_fd_pr__special_nfet_01v8 ad=0.15593 pd=1.2 as=0.1674 ps=1.29 w=0.36 l=0.15
X35 a_1725_36.t1 a_393_36.t2 a_1088_165.t0 VNB.t8 sky130_fd_pr__special_nfet_01v8 ad=0.1674 pd=1.29 as=0.13702 ps=1.2 w=0.36 l=0.15
C0 CLK VGND 0.04537f
C1 VPB VPWR 0.74883f
C2 VPB VGND 0.04933f
C3 VPB Q 0.00889f
C4 VPWR VGND 0.17818f
C5 VPWR Q 0.22627f
C6 VPB Q_N 0.00808f
C7 VPWR Q_N 0.22627f
C8 D VPB 0.11625f
C9 D VPWR 0.03564f
C10 VPB RESET_B 0.26878f
C11 VPWR RESET_B 0.58314f
C12 Q VGND 0.15357f
C13 Q_N VGND 0.15357f
C14 D VGND 0.03531f
C15 RESET_B VGND 0.064f
C16 CLK VPB 0.09785f
C17 Q RESET_B 0.00144f
C18 CLK VPWR 0.04196f
R0 Q_N Q_N.n0 308.5
R1 Q_N Q_N.n1 204.201
R2 Q_N.n1 Q_N.t0 37.1434
R3 Q_N.n1 Q_N.t1 37.1434
R4 Q_N.n0 Q_N.t3 35.5699
R5 Q_N.n0 Q_N.t2 35.5699
R6 Q Q.n0 308.5
R7 Q Q.n1 204.201
R8 Q.n1 Q.t2 37.1434
R9 Q.n1 Q.t1 37.1434
R10 Q.n0 Q.t3 35.5699
R11 Q.n0 Q.t0 35.5699
R12 VGND.n88 VGND.t11 253
R13 VGND.n30 VGND.t9 253
R14 VGND.n81 VGND.t10 253
R15 VGND.n94 VGND.t2 253
R16 VGND.n67 VGND.t8 249.8
R17 VGND.n23 VGND.t4 246.113
R18 VGND.n24 VGND.t7 241.344
R19 VGND.n20 VGND.t3 241.344
R20 VGND.n18 VGND.t1 241.344
R21 VGND.n61 VGND.t6 234.944
R22 VGND.n47 VGND.n15 197.8
R23 VGND.n15 VGND.t0 52.0005
R24 VGND.n15 VGND.t5 52.0005
R25 VGND.n95 VGND.n94 15.7005
R26 VGND.n25 VGND.n24 12.8005
R27 VGND.n25 VGND.n22 12.8005
R28 VGND.n29 VGND.n22 12.8005
R29 VGND.n32 VGND.n31 12.8005
R30 VGND.n36 VGND.n35 12.8005
R31 VGND.n37 VGND.n36 12.8005
R32 VGND.n41 VGND.n40 12.8005
R33 VGND.n42 VGND.n41 12.8005
R34 VGND.n42 VGND.n16 12.8005
R35 VGND.n46 VGND.n16 12.8005
R36 VGND.n49 VGND.n48 12.8005
R37 VGND.n49 VGND.n13 12.8005
R38 VGND.n53 VGND.n13 12.8005
R39 VGND.n54 VGND.n53 12.8005
R40 VGND.n55 VGND.n54 12.8005
R41 VGND.n55 VGND.n11 12.8005
R42 VGND.n59 VGND.n11 12.8005
R43 VGND.n60 VGND.n59 12.8005
R44 VGND.n62 VGND.n9 12.8005
R45 VGND.n66 VGND.n9 12.8005
R46 VGND.n69 VGND.n68 12.8005
R47 VGND.n69 VGND.n7 12.8005
R48 VGND.n73 VGND.n7 12.8005
R49 VGND.n74 VGND.n73 12.8005
R50 VGND.n75 VGND.n74 12.8005
R51 VGND.n75 VGND.n5 12.8005
R52 VGND.n79 VGND.n5 12.8005
R53 VGND.n80 VGND.n79 12.8005
R54 VGND.n82 VGND.n80 12.8005
R55 VGND.n86 VGND.n3 12.8005
R56 VGND.n87 VGND.n86 12.8005
R57 VGND.n88 VGND.n87 12.8005
R58 VGND.n88 VGND.n1 12.8005
R59 VGND.n92 VGND.n1 12.8005
R60 VGND.n93 VGND.n92 12.8005
R61 VGND.n93 VGND.n0 9.3005
R62 VGND.n92 VGND.n91 9.3005
R63 VGND.n90 VGND.n1 9.3005
R64 VGND.n89 VGND.n88 9.3005
R65 VGND.n87 VGND.n2 9.3005
R66 VGND.n86 VGND.n85 9.3005
R67 VGND.n84 VGND.n3 9.3005
R68 VGND.n83 VGND.n82 9.3005
R69 VGND.n80 VGND.n4 9.3005
R70 VGND.n79 VGND.n78 9.3005
R71 VGND.n77 VGND.n5 9.3005
R72 VGND.n76 VGND.n75 9.3005
R73 VGND.n74 VGND.n6 9.3005
R74 VGND.n73 VGND.n72 9.3005
R75 VGND.n71 VGND.n7 9.3005
R76 VGND.n70 VGND.n69 9.3005
R77 VGND.n68 VGND.n8 9.3005
R78 VGND.n66 VGND.n65 9.3005
R79 VGND.n64 VGND.n9 9.3005
R80 VGND.n63 VGND.n62 9.3005
R81 VGND.n60 VGND.n10 9.3005
R82 VGND.n59 VGND.n58 9.3005
R83 VGND.n57 VGND.n11 9.3005
R84 VGND.n56 VGND.n55 9.3005
R85 VGND.n54 VGND.n12 9.3005
R86 VGND.n53 VGND.n52 9.3005
R87 VGND.n51 VGND.n13 9.3005
R88 VGND.n50 VGND.n49 9.3005
R89 VGND.n48 VGND.n14 9.3005
R90 VGND.n46 VGND.n45 9.3005
R91 VGND.n44 VGND.n16 9.3005
R92 VGND.n43 VGND.n42 9.3005
R93 VGND.n41 VGND.n17 9.3005
R94 VGND.n40 VGND.n39 9.3005
R95 VGND.n38 VGND.n37 9.3005
R96 VGND.n36 VGND.n19 9.3005
R97 VGND.n35 VGND.n34 9.3005
R98 VGND.n33 VGND.n32 9.3005
R99 VGND.n31 VGND.n21 9.3005
R100 VGND.n29 VGND.n28 9.3005
R101 VGND.n27 VGND.n22 9.3005
R102 VGND.n26 VGND.n25 9.3005
R103 VGND.n30 VGND.n29 6.4005
R104 VGND.n31 VGND.n30 6.4005
R105 VGND.n32 VGND.n20 6.4005
R106 VGND.n35 VGND.n20 6.4005
R107 VGND.n37 VGND.n18 6.4005
R108 VGND.n40 VGND.n18 6.4005
R109 VGND.n47 VGND.n46 6.4005
R110 VGND.n48 VGND.n47 6.4005
R111 VGND.n61 VGND.n60 6.4005
R112 VGND.n62 VGND.n61 6.4005
R113 VGND.n67 VGND.n66 6.4005
R114 VGND.n68 VGND.n67 6.4005
R115 VGND.n82 VGND.n81 6.4005
R116 VGND.n81 VGND.n3 6.4005
R117 VGND.n94 VGND.n93 6.4005
R118 VGND.n24 VGND.n23 6.00163
R119 VGND.n26 VGND.n23 0.319971
R120 VGND.n27 VGND.n26 0.063
R121 VGND.n28 VGND.n27 0.063
R122 VGND.n28 VGND.n21 0.063
R123 VGND.n33 VGND.n21 0.063
R124 VGND.n34 VGND.n33 0.063
R125 VGND.n34 VGND.n19 0.063
R126 VGND.n38 VGND.n19 0.063
R127 VGND.n39 VGND.n38 0.063
R128 VGND.n39 VGND.n17 0.063
R129 VGND.n43 VGND.n17 0.063
R130 VGND.n44 VGND.n43 0.063
R131 VGND.n45 VGND.n44 0.063
R132 VGND.n45 VGND.n14 0.063
R133 VGND.n50 VGND.n14 0.063
R134 VGND.n51 VGND.n50 0.063
R135 VGND.n52 VGND.n51 0.063
R136 VGND.n52 VGND.n12 0.063
R137 VGND.n56 VGND.n12 0.063
R138 VGND.n57 VGND.n56 0.063
R139 VGND.n58 VGND.n57 0.063
R140 VGND.n58 VGND.n10 0.063
R141 VGND.n63 VGND.n10 0.063
R142 VGND.n64 VGND.n63 0.063
R143 VGND.n65 VGND.n64 0.063
R144 VGND.n65 VGND.n8 0.063
R145 VGND.n70 VGND.n8 0.063
R146 VGND.n71 VGND.n70 0.063
R147 VGND.n72 VGND.n71 0.063
R148 VGND.n72 VGND.n6 0.063
R149 VGND.n76 VGND.n6 0.063
R150 VGND.n77 VGND.n76 0.063
R151 VGND.n78 VGND.n77 0.063
R152 VGND.n78 VGND.n4 0.063
R153 VGND.n83 VGND.n4 0.063
R154 VGND.n84 VGND.n83 0.063
R155 VGND.n85 VGND.n84 0.063
R156 VGND.n85 VGND.n2 0.063
R157 VGND.n89 VGND.n2 0.063
R158 VGND.n90 VGND.n89 0.063
R159 VGND.n91 VGND.n90 0.063
R160 VGND.n91 VGND.n0 0.063
R161 VGND.n95 VGND.n0 0.063
R162 VGND VGND.n95 0.03175
R163 VPWR.n50 VPWR.t0 683.168
R164 VPWR.n18 VPWR.t3 683.168
R165 VPWR.n44 VPWR.t10 661.976
R166 VPWR.n38 VPWR.t12 661.976
R167 VPWR.n12 VPWR.t2 661.976
R168 VPWR.n63 VPWR.n29 597.801
R169 VPWR.n21 VPWR.n20 597.801
R170 VPWR.n70 VPWR.t5 359.127
R171 VPWR.n6 VPWR.t7 328.07
R172 VPWR.n4 VPWR.t6 328.07
R173 VPWR.n17 VPWR.t1 328.07
R174 VPWR.n100 VPWR.t4 328.07
R175 VPWR.n29 VPWR.t11 85.3672
R176 VPWR.n29 VPWR.t9 85.3672
R177 VPWR.n20 VPWR.t13 85.3672
R178 VPWR.n20 VPWR.t8 85.3672
R179 VPWR.n7 VPWR.n6 30.3698
R180 VPWR.n5 VPWR.n4 25.6005
R181 VPWR.n93 VPWR.n17 25.6005
R182 VPWR.n100 VPWR.n99 25.6005
R183 VPWR.n6 VPWR 16.0005
R184 VPWR.n4 VPWR 16.0005
R185 VPWR.n17 VPWR 16.0005
R186 VPWR VPWR.n100 16.0005
R187 VPWR.n38 VPWR.n37 15.7005
R188 VPWR.n5 VPWR.n3 12.8005
R189 VPWR.n10 VPWR.n3 12.8005
R190 VPWR.n11 VPWR.n10 12.8005
R191 VPWR.n13 VPWR.n0 12.8005
R192 VPWR.n98 VPWR.n1 12.8005
R193 VPWR.n94 VPWR.n1 12.8005
R194 VPWR.n92 VPWR.n91 12.8005
R195 VPWR.n88 VPWR.n87 12.8005
R196 VPWR.n87 VPWR.n86 12.8005
R197 VPWR.n83 VPWR.n82 12.8005
R198 VPWR.n82 VPWR.n81 12.8005
R199 VPWR.n81 VPWR.n23 12.8005
R200 VPWR.n77 VPWR.n23 12.8005
R201 VPWR.n77 VPWR.n76 12.8005
R202 VPWR.n76 VPWR.n75 12.8005
R203 VPWR.n75 VPWR.n25 12.8005
R204 VPWR.n71 VPWR.n25 12.8005
R205 VPWR.n69 VPWR.n68 12.8005
R206 VPWR.n68 VPWR.n27 12.8005
R207 VPWR.n64 VPWR.n27 12.8005
R208 VPWR.n64 VPWR.n63 12.8005
R209 VPWR.n63 VPWR.n62 12.8005
R210 VPWR.n62 VPWR.n30 12.8005
R211 VPWR.n58 VPWR.n30 12.8005
R212 VPWR.n58 VPWR.n57 12.8005
R213 VPWR.n57 VPWR.n56 12.8005
R214 VPWR.n56 VPWR.n32 12.8005
R215 VPWR.n52 VPWR.n32 12.8005
R216 VPWR.n52 VPWR.n51 12.8005
R217 VPWR.n49 VPWR.n34 12.8005
R218 VPWR.n45 VPWR.n34 12.8005
R219 VPWR.n45 VPWR.n44 12.8005
R220 VPWR.n44 VPWR.n43 12.8005
R221 VPWR.n43 VPWR.n36 12.8005
R222 VPWR.n39 VPWR.n36 12.8005
R223 VPWR.n40 VPWR.n39 9.3005
R224 VPWR.n41 VPWR.n36 9.3005
R225 VPWR.n43 VPWR.n42 9.3005
R226 VPWR.n44 VPWR.n35 9.3005
R227 VPWR.n46 VPWR.n45 9.3005
R228 VPWR.n47 VPWR.n34 9.3005
R229 VPWR.n49 VPWR.n48 9.3005
R230 VPWR.n51 VPWR.n33 9.3005
R231 VPWR.n53 VPWR.n52 9.3005
R232 VPWR.n54 VPWR.n32 9.3005
R233 VPWR.n56 VPWR.n55 9.3005
R234 VPWR.n57 VPWR.n31 9.3005
R235 VPWR.n59 VPWR.n58 9.3005
R236 VPWR.n60 VPWR.n30 9.3005
R237 VPWR.n62 VPWR.n61 9.3005
R238 VPWR.n63 VPWR.n28 9.3005
R239 VPWR.n65 VPWR.n64 9.3005
R240 VPWR.n66 VPWR.n27 9.3005
R241 VPWR.n68 VPWR.n67 9.3005
R242 VPWR.n69 VPWR.n26 9.3005
R243 VPWR.n72 VPWR.n71 9.3005
R244 VPWR.n73 VPWR.n25 9.3005
R245 VPWR.n75 VPWR.n74 9.3005
R246 VPWR.n76 VPWR.n24 9.3005
R247 VPWR.n78 VPWR.n77 9.3005
R248 VPWR.n79 VPWR.n23 9.3005
R249 VPWR.n81 VPWR.n80 9.3005
R250 VPWR.n82 VPWR.n22 9.3005
R251 VPWR.n84 VPWR.n83 9.3005
R252 VPWR.n86 VPWR.n85 9.3005
R253 VPWR.n87 VPWR.n19 9.3005
R254 VPWR.n89 VPWR.n88 9.3005
R255 VPWR.n91 VPWR.n90 9.3005
R256 VPWR.n92 VPWR.n16 9.3005
R257 VPWR.n95 VPWR.n94 9.3005
R258 VPWR.n96 VPWR.n1 9.3005
R259 VPWR.n98 VPWR.n97 9.3005
R260 VPWR.n15 VPWR.n0 9.3005
R261 VPWR.n14 VPWR.n13 9.3005
R262 VPWR.n11 VPWR.n2 9.3005
R263 VPWR.n10 VPWR.n9 9.3005
R264 VPWR.n8 VPWR.n3 9.3005
R265 VPWR.n12 VPWR.n11 6.4005
R266 VPWR.n13 VPWR.n12 6.4005
R267 VPWR.n99 VPWR.n0 6.4005
R268 VPWR.n99 VPWR.n98 6.4005
R269 VPWR.n94 VPWR.n93 6.4005
R270 VPWR.n93 VPWR.n92 6.4005
R271 VPWR.n91 VPWR.n18 6.4005
R272 VPWR.n88 VPWR.n18 6.4005
R273 VPWR.n86 VPWR.n21 6.4005
R274 VPWR.n83 VPWR.n21 6.4005
R275 VPWR.n71 VPWR.n70 6.4005
R276 VPWR.n70 VPWR.n69 6.4005
R277 VPWR.n51 VPWR.n50 6.4005
R278 VPWR.n50 VPWR.n49 6.4005
R279 VPWR.n39 VPWR.n38 6.4005
R280 VPWR.n7 VPWR.n5 6.00163
R281 VPWR.n8 VPWR.n7 0.319971
R282 VPWR.n9 VPWR.n8 0.063
R283 VPWR.n9 VPWR.n2 0.063
R284 VPWR.n14 VPWR.n2 0.063
R285 VPWR.n15 VPWR.n14 0.063
R286 VPWR.n97 VPWR.n15 0.063
R287 VPWR.n97 VPWR.n96 0.063
R288 VPWR.n96 VPWR.n95 0.063
R289 VPWR.n95 VPWR.n16 0.063
R290 VPWR.n90 VPWR.n16 0.063
R291 VPWR.n90 VPWR.n89 0.063
R292 VPWR.n89 VPWR.n19 0.063
R293 VPWR.n85 VPWR.n19 0.063
R294 VPWR.n85 VPWR.n84 0.063
R295 VPWR.n84 VPWR.n22 0.063
R296 VPWR.n80 VPWR.n22 0.063
R297 VPWR.n80 VPWR.n79 0.063
R298 VPWR.n79 VPWR.n78 0.063
R299 VPWR.n78 VPWR.n24 0.063
R300 VPWR.n74 VPWR.n24 0.063
R301 VPWR.n74 VPWR.n73 0.063
R302 VPWR.n73 VPWR.n72 0.063
R303 VPWR.n72 VPWR.n26 0.063
R304 VPWR.n67 VPWR.n26 0.063
R305 VPWR.n67 VPWR.n66 0.063
R306 VPWR.n66 VPWR.n65 0.063
R307 VPWR.n65 VPWR.n28 0.063
R308 VPWR.n61 VPWR.n28 0.063
R309 VPWR.n61 VPWR.n60 0.063
R310 VPWR.n60 VPWR.n59 0.063
R311 VPWR.n59 VPWR.n31 0.063
R312 VPWR.n55 VPWR.n31 0.063
R313 VPWR.n55 VPWR.n54 0.063
R314 VPWR.n54 VPWR.n53 0.063
R315 VPWR.n53 VPWR.n33 0.063
R316 VPWR.n48 VPWR.n33 0.063
R317 VPWR.n48 VPWR.n47 0.063
R318 VPWR.n47 VPWR.n46 0.063
R319 VPWR.n46 VPWR.n35 0.063
R320 VPWR.n42 VPWR.n35 0.063
R321 VPWR.n42 VPWR.n41 0.063
R322 VPWR.n41 VPWR.n40 0.063
R323 VPWR.n40 VPWR.n37 0.063
R324 VPWR.n37 VPWR 0.03175
R325 RESET_B.n1 RESET_B.t1 424.697
R326 RESET_B.n0 RESET_B.t0 424.697
R327 RESET_B RESET_B.n0 217.03
R328 RESET_B.n1 RESET_B.t3 193.337
R329 RESET_B.n0 RESET_B.t2 193.337
R330 RESET_B RESET_B.n1 161.601
R331 D.n0 D.t1 290.808
R332 D.n0 D.t0 290.808
R333 D D.n0 158.4
R334 CLK.n0 CLK.t1 319.728
R335 CLK.n0 CLK.t0 232.968
R336 CLK CLK.n0 158.4
R337 VPB.t12 VPB.t5 777.274
R338 VPB.t1 VPB.t7 604.545
R339 VPB.t4 VPB.t1 604.545
R340 VPB.t3 VPB.t0 604.545
R341 VPB.t17 VPB.t14 604.545
R342 VPB.t16 VPB.t17 604.545
R343 VPB.t11 VPB.t6 518.183
R344 VPB.t2 VPB.t15 518.183
R345 VPB.t6 VPB.t9 431.818
R346 VPB.t15 VPB.t10 431.818
R347 VPB.t5 VPB.t11 345.455
R348 VPB VPB.t16 302.274
R349 VPB.t7 VPB.t8 259.091
R350 VPB.t0 VPB.t4 259.091
R351 VPB.t13 VPB.t3 259.091
R352 VPB.t9 VPB.t13 259.091
R353 VPB.t10 VPB.t12 259.091
R354 VPB.t14 VPB.t2 259.091
R355 VNB.t11 VNB.t5 3600
R356 VNB.t9 VNB.t7 2800
R357 VNB.t1 VNB.t9 2800
R358 VNB.t3 VNB.t0 2800
R359 VNB.t15 VNB.t13 2800
R360 VNB.t17 VNB.t15 2800
R361 VNB.t8 VNB.t16 2400
R362 VNB.t14 VNB.t6 2400
R363 VNB.t16 VNB.t4 2000
R364 VNB.t6 VNB.t10 2000
R365 VNB.t5 VNB.t8 1600
R366 VNB VNB.t17 1400
R367 VNB.t7 VNB.t2 1200
R368 VNB.t0 VNB.t1 1200
R369 VNB.t12 VNB.t3 1200
R370 VNB.t4 VNB.t12 1200
R371 VNB.t10 VNB.t11 1200
R372 VNB.t13 VNB.t14 1200
R373 a_2229_36.t0 a_2229_36.t1 104.001
R374 a_1941_36.t1 a_1941_36.t0 219
R375 a_1149_36.t0 a_1149_36.t1 104.001
R376 a_969_36.t0 a_969_36.t1 219
R377 a_1941_450.t0 a_1941_450.t1 328.334
R378 a_969_450.n0 a_969_450.t2 242.968
R379 a_969_450.t0 a_969_450.n0 85.3672
R380 a_969_450.n0 a_969_450.t1 1287.6
R381 a_645_36.n0 a_645_36.t1 56.0005
R382 a_645_36.t3 a_645_36.n0 65.0005
R383 a_645_36.n0 a_645_36.n1 907.601
R384 a_645_36.n1 a_645_36.t2 85.3672
R385 a_645_36.n1 a_645_36.t0 85.3672
R386 a_2949_36.t1 a_2949_36.n0 259.401
R387 a_2949_36.n0 a_2949_36.n2 213.75
R388 a_2949_36.n2 a_2949_36.n1 72.3005
R389 a_2949_36.n2 a_2949_36.t5 231.361
R390 a_2949_36.n2 a_2949_36.t3 187.981
R391 a_2949_36.n1 a_2949_36.t4 231.361
R392 a_2949_36.n1 a_2949_36.t2 187.981
R393 a_2949_36.n0 a_2949_36.t0 681.177
R394 a_1725_36.t1 a_1725_36.n0 245
R395 a_1725_36.n0 a_1725_36.t3 65.0005
R396 a_1725_36.n0 a_1725_36.n2 242.601
R397 a_1725_36.n2 a_1725_36.n3 305.601
R398 a_1725_36.n3 a_1725_36.t4 251.177
R399 a_1725_36.n3 a_1725_36.t5 366.856
R400 a_1725_36.n2 a_1725_36.n1 652.201
R401 a_1725_36.n1 a_1725_36.t2 321.767
R402 a_1725_36.n1 a_1725_36.t0 85.3672
R403 a_2060_165.t0 a_2060_165.n0 85.3672
R404 a_2060_165.n0 a_2060_165.t2 85.3672
R405 a_2060_165.n0 a_2060_165.n3 645.801
R406 a_2060_165.n3 a_2060_165.n6 210.55
R407 a_2060_165.n6 a_2060_165.n5 72.3005
R408 a_2060_165.n5 a_2060_165.n4 168.701
R409 a_2060_165.n6 a_2060_165.t9 231.361
R410 a_2060_165.n6 a_2060_165.t5 187.981
R411 a_2060_165.n5 a_2060_165.t8 231.361
R412 a_2060_165.n5 a_2060_165.t4 187.981
R413 a_2060_165.n4 a_2060_165.t7 303.661
R414 a_2060_165.n4 a_2060_165.t3 216.9
R415 a_2060_165.n3 a_2060_165.n2 16.0005
R416 a_2060_165.n2 a_2060_165.n1 235.379
R417 a_2060_165.n1 a_2060_165.t6 161.036
R418 a_2060_165.n1 a_2060_165.t10 450.236
R419 a_2060_165.n2 a_2060_165.t1 249.8
R420 a_753_36.n0 a_753_36.t2 245
R421 a_753_36.t1 a_753_36.n0 65.0005
R422 a_753_36.n0 a_753_36.n2 242.601
R423 a_753_36.n2 a_753_36.n3 382.401
R424 a_753_36.n3 a_753_36.t4 222.256
R425 a_753_36.n3 a_753_36.t5 309.017
R426 a_753_36.n2 a_753_36.n1 652.201
R427 a_753_36.n1 a_753_36.t0 321.767
R428 a_753_36.n1 a_753_36.t3 85.3672
R429 a_1088_165.n0 a_1088_165.t1 107.144
R430 a_1088_165.t0 a_1088_165.n0 65.0005
R431 a_1088_165.n0 a_1088_165.n2 204.201
R432 a_1088_165.n2 a_1088_165.n3 331.378
R433 a_1088_165.n3 a_1088_165.t4 161.036
R434 a_1088_165.n3 a_1088_165.t5 450.236
R435 a_1088_165.n2 a_1088_165.n1 690.601
R436 a_1088_165.n1 a_1088_165.t2 139.846
R437 a_1088_165.n1 a_1088_165.t3 85.3672
R438 a_393_36.t0 a_393_36.n0 253
R439 a_393_36.n0 a_393_36.n1 10.2246
R440 a_393_36.n1 a_393_36.n2 0.321929
R441 a_393_36.n2 a_393_36.n3 10.9076
R442 a_393_36.n3 a_393_36.t4 425.334
R443 a_393_36.n3 a_393_36.t2 301.957
R444 a_393_36.n2 a_393_36.t3 308.091
R445 a_393_36.n1 a_393_36.t5 680.521
R446 a_393_36.n0 a_393_36.t1 700.376
R447 a_141_36.t0 a_141_36.n4 259.401
R448 a_141_36.n4 a_141_36.n5 177.601
R449 a_141_36.n5 a_141_36.t4 232.968
R450 a_141_36.n5 a_141_36.t7 319.728
R451 a_141_36.n4 a_141_36.n0 12.8005
R452 a_141_36.n0 a_141_36.n1 10.45
R453 a_141_36.n1 a_141_36.n2 0.561253
R454 a_141_36.n2 a_141_36.n3 2.0005
R455 a_141_36.n3 a_141_36.t2 308.413
R456 a_141_36.n3 a_141_36.t5 680.521
R457 a_141_36.n2 a_141_36.t6 351.471
R458 a_141_36.n1 a_141_36.t3 375.257
R459 a_141_36.n0 a_141_36.t1 668.376
C21 Q_N VNB 0.31817f
C22 Q VNB 0.30974f
C23 VGND VNB 2.18112f
C24 VPWR VNB 1.59188f
C25 RESET_B VNB 1.29278f
C26 D VNB 0.22214f
C27 CLK VNB 0.25869f
C28 VPB VNB 4.16052f
C29 a_141_36.t0 VNB 0.08841f
C30 a_141_36.t1 VNB 0.12416f
C31 a_141_36.n0 VNB 0.24401f
C32 a_141_36.t3 VNB 0.06958f
C33 a_141_36.n1 VNB 0.708f
C34 a_141_36.t6 VNB 0.07114f
C35 a_141_36.n2 VNB 0.55943f
C36 a_141_36.t5 VNB 0.11985f
C37 a_141_36.n3 VNB 0.74748f
C38 a_141_36.t2 VNB 0.06527f
C39 a_141_36.n4 VNB 0.41307f
C40 a_141_36.t7 VNB 0.05304f
C41 a_141_36.t4 VNB 0.03507f
C42 a_141_36.n5 VNB 0.18079f
C43 a_393_36.t0 VNB 0.0948f
C44 a_393_36.t1 VNB 0.15352f
C45 a_393_36.n0 VNB 0.57599f
C46 a_393_36.t5 VNB 0.13479f
C47 a_393_36.n1 VNB 0.60081f
C48 a_393_36.t3 VNB 0.07323f
C49 a_393_36.n2 VNB 0.7375f
C50 a_393_36.n3 VNB 0.50714f
C51 a_393_36.t2 VNB 0.05653f
C52 a_393_36.t4 VNB 0.15251f
C53 a_1088_165.t0 VNB 0.01998f
C54 a_1088_165.n0 VNB 0.06765f
C55 a_1088_165.t2 VNB 0.09729f
C56 a_1088_165.t3 VNB 0.02498f
C57 a_1088_165.n1 VNB 0.09935f
C58 a_1088_165.n2 VNB 0.52003f
C59 a_1088_165.t5 VNB 0.06429f
C60 a_1088_165.t4 VNB 0.027f
C61 a_1088_165.n3 VNB 0.22673f
C62 a_1088_165.t1 VNB 0.07532f
C63 a_753_36.t1 VNB 0.01897f
C64 a_753_36.n0 VNB 0.11402f
C65 a_753_36.t0 VNB 0.08937f
C66 a_753_36.t3 VNB 0.02371f
C67 a_753_36.n1 VNB 0.12519f
C68 a_753_36.n2 VNB 0.49624f
C69 a_753_36.t5 VNB 0.05801f
C70 a_753_36.t4 VNB 0.04008f
C71 a_753_36.n3 VNB 0.18808f
C72 a_753_36.t2 VNB 0.0715f
C73 a_2060_165.t0 VNB 0.02067f
C74 a_2060_165.n0 VNB 0.05404f
C75 a_2060_165.t1 VNB 0.07115f
C76 a_2060_165.t10 VNB 0.0532f
C77 a_2060_165.t6 VNB 0.02234f
C78 a_2060_165.n1 VNB 0.13727f
C79 a_2060_165.n2 VNB 0.25149f
C80 a_2060_165.n3 VNB 0.38738f
C81 a_2060_165.t3 VNB 0.02703f
C82 a_2060_165.t7 VNB 0.04292f
C83 a_2060_165.n4 VNB 0.17932f
C84 a_2060_165.t4 VNB 0.0302f
C85 a_2060_165.t8 VNB 0.05087f
C86 a_2060_165.n5 VNB 0.19871f
C87 a_2060_165.t5 VNB 0.0302f
C88 a_2060_165.t9 VNB 0.05087f
C89 a_2060_165.n6 VNB 0.16795f
C90 a_2060_165.t2 VNB 0.02067f
C91 a_1725_36.t1 VNB 0.07194f
C92 a_1725_36.n0 VNB 0.11474f
C93 a_1725_36.t2 VNB 0.08993f
C94 a_1725_36.t0 VNB 0.02386f
C95 a_1725_36.n1 VNB 0.12598f
C96 a_1725_36.n2 VNB 0.43516f
C97 a_1725_36.t5 VNB 0.05091f
C98 a_1725_36.t4 VNB 0.03653f
C99 a_1725_36.n3 VNB 0.15899f
C100 a_1725_36.t3 VNB 0.01909f
C101 a_2949_36.t1 VNB 0.05378f
C102 a_2949_36.t0 VNB 0.078f
C103 a_2949_36.n0 VNB 0.38881f
C104 a_2949_36.t2 VNB 0.0213f
C105 a_2949_36.t4 VNB 0.03587f
C106 a_2949_36.n1 VNB 0.07556f
C107 a_2949_36.t3 VNB 0.0213f
C108 a_2949_36.t5 VNB 0.03587f
C109 a_2949_36.n2 VNB 0.11997f
C110 a_645_36.t3 VNB 0.01931f
C111 a_645_36.n0 VNB 0.2809f
C112 a_645_36.t2 VNB 0.02414f
C113 a_645_36.t0 VNB 0.02414f
C114 a_645_36.n1 VNB 0.14137f
C115 a_645_36.t1 VNB 0.02727f
C116 a_969_450.t0 VNB 0.01976f
C117 a_969_450.n0 VNB 0.25037f
C118 a_969_450.t1 VNB 0.22169f
C119 a_969_450.t2 VNB 0.05625f
C120 a_1941_450.t0 VNB 0.02074f
C121 a_1941_450.t1 VNB 0.02074f
C122 a_969_36.t0 VNB 0.0164f
C123 a_969_36.t1 VNB 0.02024f
C124 a_1149_36.t0 VNB 0.01067f
C125 a_1149_36.t1 VNB 0.01067f
C126 a_1941_36.t1 VNB 0.01671f
C127 a_1941_36.t0 VNB 0.02062f
C128 a_2229_36.t0 VNB 0.01114f
C129 a_2229_36.t1 VNB 0.01114f
C130 VPB.t8 VNB 0.18786f
C131 VPB.t7 VNB 0.15655f
C132 VPB.t1 VNB 0.21917f
C133 VPB.t4 VNB 0.15655f
C134 VPB.t0 VNB 0.15655f
C135 VPB.t3 VNB 0.15655f
C136 VPB.t13 VNB 0.09393f
C137 VPB.t9 VNB 0.12524f
C138 VPB.t6 VNB 0.17221f
C139 VPB.t11 VNB 0.15655f
C140 VPB.t5 VNB 0.20352f
C141 VPB.t12 VNB 0.18786f
C142 VPB.t10 VNB 0.12524f
C143 VPB.t15 VNB 0.17221f
C144 VPB.t2 VNB 0.1409f
C145 VPB.t14 VNB 0.15655f
C146 VPB.t17 VNB 0.21917f
C147 VPB.t16 VNB 0.16438f
C148 CLK.t1 VNB 0.04659f
C149 CLK.t0 VNB 0.0308f
C150 CLK.n0 VNB 0.14726f
C151 D.t1 VNB 0.05528f
C152 D.t0 VNB 0.05528f
C153 D.n0 VNB 0.22521f
C154 RESET_B.t2 VNB 0.04034f
C155 RESET_B.t0 VNB 0.07956f
C156 RESET_B.n0 VNB 0.43961f
C157 RESET_B.t3 VNB 0.04034f
C158 RESET_B.t1 VNB 0.07956f
C159 RESET_B.n1 VNB 0.15417f
C160 VPWR.n0 VNB 0.01522f
C161 VPWR.n1 VNB 0.02029f
C162 VPWR.n2 VNB 0.04058f
C163 VPWR.t2 VNB 0.03526f
C164 VPWR.n3 VNB 0.02029f
C165 VPWR.t6 VNB 0.05832f
C166 VPWR.n4 VNB 0.03806f
C167 VPWR.n5 VNB 0.04821f
C168 VPWR.t7 VNB 0.05832f
C169 VPWR.n6 VNB 0.04759f
C170 VPWR.n7 VNB 0.12922f
C171 VPWR.n8 VNB 0.19853f
C172 VPWR.n9 VNB 0.04058f
C173 VPWR.n10 VNB 0.02029f
C174 VPWR.n11 VNB 0.01522f
C175 VPWR.n12 VNB 0.05752f
C176 VPWR.n13 VNB 0.01522f
C177 VPWR.n14 VNB 0.04058f
C178 VPWR.n15 VNB 0.04058f
C179 VPWR.n16 VNB 0.04058f
C180 VPWR.t1 VNB 0.05832f
C181 VPWR.n17 VNB 0.03806f
C182 VPWR.t3 VNB 0.02445f
C183 VPWR.n18 VNB 0.04762f
C184 VPWR.n19 VNB 0.04058f
C185 VPWR.t13 VNB 0.00687f
C186 VPWR.t8 VNB 0.00687f
C187 VPWR.n20 VNB 0.01428f
C188 VPWR.n21 VNB 0.04511f
C189 VPWR.n22 VNB 0.04058f
C190 VPWR.n23 VNB 0.02029f
C191 VPWR.n24 VNB 0.04058f
C192 VPWR.n25 VNB 0.02029f
C193 VPWR.n26 VNB 0.04058f
C194 VPWR.t5 VNB 0.04508f
C195 VPWR.n27 VNB 0.02029f
C196 VPWR.n28 VNB 0.04058f
C197 VPWR.t11 VNB 0.00687f
C198 VPWR.t9 VNB 0.00687f
C199 VPWR.n29 VNB 0.01428f
C200 VPWR.n30 VNB 0.02029f
C201 VPWR.n31 VNB 0.04058f
C202 VPWR.n32 VNB 0.02029f
C203 VPWR.n33 VNB 0.04058f
C204 VPWR.t0 VNB 0.02445f
C205 VPWR.n34 VNB 0.02029f
C206 VPWR.n35 VNB 0.04058f
C207 VPWR.t10 VNB 0.03526f
C208 VPWR.n36 VNB 0.02029f
C209 VPWR.n37 VNB 0.03664f
C210 VPWR.t12 VNB 0.03526f
C211 VPWR.n38 VNB 0.06653f
C212 VPWR.n39 VNB 0.01522f
C213 VPWR.n40 VNB 0.04058f
C214 VPWR.n41 VNB 0.04058f
C215 VPWR.n42 VNB 0.04058f
C216 VPWR.n43 VNB 0.02029f
C217 VPWR.n44 VNB 0.06766f
C218 VPWR.n45 VNB 0.02029f
C219 VPWR.n46 VNB 0.04058f
C220 VPWR.n47 VNB 0.04058f
C221 VPWR.n48 VNB 0.04058f
C222 VPWR.n49 VNB 0.01522f
C223 VPWR.n50 VNB 0.04762f
C224 VPWR.n51 VNB 0.01522f
C225 VPWR.n52 VNB 0.02029f
C226 VPWR.n53 VNB 0.04058f
C227 VPWR.n54 VNB 0.04058f
C228 VPWR.n55 VNB 0.04058f
C229 VPWR.n56 VNB 0.02029f
C230 VPWR.n57 VNB 0.02029f
C231 VPWR.n58 VNB 0.02029f
C232 VPWR.n59 VNB 0.04058f
C233 VPWR.n60 VNB 0.04058f
C234 VPWR.n61 VNB 0.04058f
C235 VPWR.n62 VNB 0.02029f
C236 VPWR.n63 VNB 0.05525f
C237 VPWR.n64 VNB 0.02029f
C238 VPWR.n65 VNB 0.04058f
C239 VPWR.n66 VNB 0.04058f
C240 VPWR.n67 VNB 0.04058f
C241 VPWR.n68 VNB 0.02029f
C242 VPWR.n69 VNB 0.01522f
C243 VPWR.n70 VNB 0.06842f
C244 VPWR.n71 VNB 0.01522f
C245 VPWR.n72 VNB 0.04058f
C246 VPWR.n73 VNB 0.04058f
C247 VPWR.n74 VNB 0.04058f
C248 VPWR.n75 VNB 0.02029f
C249 VPWR.n76 VNB 0.02029f
C250 VPWR.n77 VNB 0.02029f
C251 VPWR.n78 VNB 0.04058f
C252 VPWR.n79 VNB 0.04058f
C253 VPWR.n80 VNB 0.04058f
C254 VPWR.n81 VNB 0.02029f
C255 VPWR.n82 VNB 0.02029f
C256 VPWR.n83 VNB 0.01522f
C257 VPWR.n84 VNB 0.04058f
C258 VPWR.n85 VNB 0.04058f
C259 VPWR.n86 VNB 0.01522f
C260 VPWR.n87 VNB 0.02029f
C261 VPWR.n88 VNB 0.01522f
C262 VPWR.n89 VNB 0.04058f
C263 VPWR.n90 VNB 0.04058f
C264 VPWR.n91 VNB 0.01522f
C265 VPWR.n92 VNB 0.01522f
C266 VPWR.n93 VNB 0.03043f
C267 VPWR.n94 VNB 0.01522f
C268 VPWR.n95 VNB 0.04058f
C269 VPWR.n96 VNB 0.04058f
C270 VPWR.n97 VNB 0.04058f
C271 VPWR.n98 VNB 0.01522f
C272 VPWR.n99 VNB 0.03043f
C273 VPWR.t4 VNB 0.05832f
C274 VPWR.n100 VNB 0.03806f
C275 VGND.n0 VNB 0.02881f
C276 VGND.t2 VNB 0.01693f
C277 VGND.n1 VNB 0.01441f
C278 VGND.n2 VNB 0.02881f
C279 VGND.t11 VNB 0.01693f
C280 VGND.n3 VNB 0.0108f
C281 VGND.n4 VNB 0.02881f
C282 VGND.n5 VNB 0.01441f
C283 VGND.n6 VNB 0.02881f
C284 VGND.n7 VNB 0.01441f
C285 VGND.n8 VNB 0.02881f
C286 VGND.t8 VNB 0.01661f
C287 VGND.n9 VNB 0.01441f
C288 VGND.n10 VNB 0.02881f
C289 VGND.t6 VNB 0.02397f
C290 VGND.n11 VNB 0.01441f
C291 VGND.n12 VNB 0.02881f
C292 VGND.n13 VNB 0.01441f
C293 VGND.n14 VNB 0.02881f
C294 VGND.t0 VNB 0.00488f
C295 VGND.t5 VNB 0.00488f
C296 VGND.n15 VNB 0.01069f
C297 VGND.n16 VNB 0.01441f
C298 VGND.n17 VNB 0.02881f
C299 VGND.t1 VNB 0.02499f
C300 VGND.n18 VNB 0.04089f
C301 VGND.n19 VNB 0.02881f
C302 VGND.t3 VNB 0.02499f
C303 VGND.n20 VNB 0.04089f
C304 VGND.n21 VNB 0.02881f
C305 VGND.t9 VNB 0.01693f
C306 VGND.n22 VNB 0.01441f
C307 VGND.t4 VNB 0.0262f
C308 VGND.n23 VNB 0.1166f
C309 VGND.t7 VNB 0.02499f
C310 VGND.n24 VNB 0.05351f
C311 VGND.n25 VNB 0.01441f
C312 VGND.n26 VNB 0.14096f
C313 VGND.n27 VNB 0.02881f
C314 VGND.n28 VNB 0.02881f
C315 VGND.n29 VNB 0.0108f
C316 VGND.n30 VNB 0.03424f
C317 VGND.n31 VNB 0.0108f
C318 VGND.n32 VNB 0.0108f
C319 VGND.n33 VNB 0.02881f
C320 VGND.n34 VNB 0.02881f
C321 VGND.n35 VNB 0.0108f
C322 VGND.n36 VNB 0.01441f
C323 VGND.n37 VNB 0.0108f
C324 VGND.n38 VNB 0.02881f
C325 VGND.n39 VNB 0.02881f
C326 VGND.n40 VNB 0.0108f
C327 VGND.n41 VNB 0.01441f
C328 VGND.n42 VNB 0.01441f
C329 VGND.n43 VNB 0.02881f
C330 VGND.n44 VNB 0.02881f
C331 VGND.n45 VNB 0.02881f
C332 VGND.n46 VNB 0.0108f
C333 VGND.n47 VNB 0.02788f
C334 VGND.n48 VNB 0.0108f
C335 VGND.n49 VNB 0.01441f
C336 VGND.n50 VNB 0.02881f
C337 VGND.n51 VNB 0.02881f
C338 VGND.n52 VNB 0.02881f
C339 VGND.n53 VNB 0.01441f
C340 VGND.n54 VNB 0.01441f
C341 VGND.n55 VNB 0.01441f
C342 VGND.n56 VNB 0.02881f
C343 VGND.n57 VNB 0.02881f
C344 VGND.n58 VNB 0.02881f
C345 VGND.n59 VNB 0.01441f
C346 VGND.n60 VNB 0.0108f
C347 VGND.n61 VNB 0.0311f
C348 VGND.n62 VNB 0.0108f
C349 VGND.n63 VNB 0.02881f
C350 VGND.n64 VNB 0.02881f
C351 VGND.n65 VNB 0.02881f
C352 VGND.n66 VNB 0.0108f
C353 VGND.n67 VNB 0.03096f
C354 VGND.n68 VNB 0.0108f
C355 VGND.n69 VNB 0.01441f
C356 VGND.n70 VNB 0.02881f
C357 VGND.n71 VNB 0.02881f
C358 VGND.n72 VNB 0.02881f
C359 VGND.n73 VNB 0.01441f
C360 VGND.n74 VNB 0.01441f
C361 VGND.n75 VNB 0.01441f
C362 VGND.n76 VNB 0.02881f
C363 VGND.n77 VNB 0.02881f
C364 VGND.n78 VNB 0.02881f
C365 VGND.n79 VNB 0.01441f
C366 VGND.n80 VNB 0.01441f
C367 VGND.t10 VNB 0.01693f
C368 VGND.n81 VNB 0.03424f
C369 VGND.n82 VNB 0.0108f
C370 VGND.n83 VNB 0.02881f
C371 VGND.n84 VNB 0.02881f
C372 VGND.n85 VNB 0.02881f
C373 VGND.n86 VNB 0.01441f
C374 VGND.n87 VNB 0.01441f
C375 VGND.n88 VNB 0.04145f
C376 VGND.n89 VNB 0.02881f
C377 VGND.n90 VNB 0.02881f
C378 VGND.n91 VNB 0.02881f
C379 VGND.n92 VNB 0.01441f
C380 VGND.n93 VNB 0.0108f
C381 VGND.n94 VNB 0.04064f
C382 VGND.n95 VNB 0.02601f
C383 Q.t3 VNB 0.03588f
C384 Q.t0 VNB 0.03588f
C385 Q.n0 VNB 0.07664f
C386 Q.t2 VNB 0.02093f
C387 Q.t1 VNB 0.02093f
C388 Q.n1 VNB 0.04913f
C389 Q_N.t3 VNB 0.03404f
C390 Q_N.t2 VNB 0.03404f
C391 Q_N.n0 VNB 0.0727f
C392 Q_N.t0 VNB 0.01986f
C393 Q_N.t1 VNB 0.01986f
C394 Q_N.n1 VNB 0.04661f
.ends

.subckt sky130_efx_lvdig__dfrtp_1 CLK D RESET_B Q VGND VNB VPB VPWR
X0 Q.t1 a_2060_165.t3 VGND.t6 VNB.t9 sky130_fd_pr__nfet_01v8 ad=0.23625 pd=2.01 as=0.23625 ps=2.01 w=0.63 l=0.15
X1 a_969_450.t1 a_141_36.t6 a_753_36.t0 VPB.t6 sky130_fd_pr__pfet_01v8_hvt ad=0.16875 pd=1.2 as=0.20925 ps=1.38 w=0.45 l=0.15
X2 VPWR.t9 a_1088_165.t5 a_969_450.t2 VPB.t12 sky130_fd_pr__pfet_01v8_hvt ad=0.08775 pd=0.84 as=0.16875 ps=1.2 w=0.45 l=0.15
X3 a_141_36.t1 CLK.t1 VPWR.t4 VPB.t3 sky130_fd_pr__pfet_01v8_hvt ad=0.23625 pd=2.01 as=0.23625 ps=2.01 w=0.63 l=0.15
X4 VPWR.t5 a_1725_36.t5 a_2060_165.t1 VPB.t7 sky130_fd_pr__pfet_01v8_hvt ad=0.16875 pd=1.65 as=0.08775 ps=0.84 w=0.45 l=0.15
X5 a_645_36.t0 D.t0 VGND.t2 VNB.t3 sky130_fd_pr__nfet_01v8 ad=0.08258 pd=0.84 as=0.16875 ps=1.65 w=0.45 l=0.15
X6 a_753_36.t1 a_141_36.t3 a_645_36.t2 VNB.t5 sky130_fd_pr__special_nfet_01v8 ad=0.1674 pd=1.29 as=0.08258 ps=0.84 w=0.36 l=0.15
X7 a_969_450.t0 RESET_B.t3 VPWR.t0 VPB.t1 sky130_fd_pr__pfet_01v8_hvt ad=0.16875 pd=1.65 as=0.08775 ps=0.84 w=0.45 l=0.15
X8 Q.t0 a_2060_165.t5 VPWR.t6 VPB.t8 sky130_fd_pr__pfet_01v8_hvt ad=0.405 pd=2.91 as=0.405 ps=2.91 w=1.08 l=0.15
X9 a_1941_450.t1 a_393_36.t4 a_1725_36.t3 VPB.t13 sky130_fd_pr__pfet_01v8_hvt ad=0.16875 pd=1.2 as=0.20925 ps=1.38 w=0.45 l=0.15
X10 VGND.t5 a_2060_165.t4 a_1941_36.t1 VNB.t7 sky130_fd_pr__nfet_01v8 ad=0.08775 pd=0.84 as=0.15593 ps=1.2 w=0.45 l=0.15
X11 a_141_36.t0 CLK.t0 VGND.t4 VNB.t2 sky130_fd_pr__nfet_01v8 ad=0.16875 pd=1.65 as=0.16875 ps=1.65 w=0.45 l=0.15
X12 a_1088_165.t0 a_753_36.t4 VGND.t7 VNB.t10 sky130_fd_pr__nfet_01v8 ad=0.13702 pd=1.2 as=0.23625 ps=2.01 w=0.63 l=0.15
X13 a_393_36.t0 a_141_36.t7 VPWR.t3 VPB.t0 sky130_fd_pr__pfet_01v8_hvt ad=0.23625 pd=2.01 as=0.23625 ps=2.01 w=0.63 l=0.15
X14 a_969_36.t0 a_393_36.t3 a_753_36.t3 VNB.t11 sky130_fd_pr__special_nfet_01v8 ad=0.15593 pd=1.2 as=0.1674 ps=1.29 w=0.36 l=0.15
X15 a_1149_36.t1 a_1088_165.t4 a_969_36.t1 VNB.t12 sky130_fd_pr__nfet_01v8 ad=0.08775 pd=0.84 as=0.15593 ps=1.2 w=0.45 l=0.15
X16 VGND.t0 RESET_B.t1 a_1149_36.t0 VNB.t0 sky130_fd_pr__nfet_01v8 ad=0.16875 pd=1.65 as=0.08775 ps=0.84 w=0.45 l=0.15
X17 VPWR.t7 a_2060_165.t6 a_1941_450.t0 VPB.t9 sky130_fd_pr__pfet_01v8_hvt ad=0.08775 pd=0.84 as=0.16875 ps=1.2 w=0.45 l=0.15
X18 a_2060_165.t0 a_1725_36.t4 a_2229_36.t1 VNB.t8 sky130_fd_pr__nfet_01v8 ad=0.16875 pd=1.65 as=0.08775 ps=0.84 w=0.45 l=0.15
X19 a_2229_36.t0 RESET_B.t0 VGND.t1 VNB.t1 sky130_fd_pr__nfet_01v8 ad=0.08775 pd=0.84 as=0.08775 ps=0.84 w=0.45 l=0.15
X20 a_645_36.t1 D.t1 VPWR.t1 VPB.t4 sky130_fd_pr__pfet_01v8_hvt ad=0.08775 pd=0.84 as=0.16875 ps=1.65 w=0.45 l=0.15
X21 a_2060_165.t2 RESET_B.t2 VPWR.t2 VPB.t2 sky130_fd_pr__pfet_01v8_hvt ad=0.08775 pd=0.84 as=0.08775 ps=0.84 w=0.45 l=0.15
X22 a_1725_36.t0 a_141_36.t5 a_1088_165.t2 VPB.t5 sky130_fd_pr__pfet_01v8_hvt ad=0.20925 pd=1.38 as=0.17415 ps=1.38 w=0.45 l=0.15
X23 a_753_36.t2 a_393_36.t5 a_645_36.t3 VPB.t11 sky130_fd_pr__pfet_01v8_hvt ad=0.20925 pd=1.38 as=0.08775 ps=0.84 w=0.45 l=0.15
X24 a_1088_165.t1 a_753_36.t5 VPWR.t8 VPB.t10 sky130_fd_pr__pfet_01v8_hvt ad=0.17415 pd=1.38 as=0.30375 ps=2.37 w=0.81 l=0.15
X25 a_393_36.t1 a_141_36.t4 VGND.t3 VNB.t4 sky130_fd_pr__nfet_01v8 ad=0.16875 pd=1.65 as=0.16875 ps=1.65 w=0.45 l=0.15
X26 a_1941_36.t0 a_141_36.t2 a_1725_36.t1 VNB.t6 sky130_fd_pr__special_nfet_01v8 ad=0.15593 pd=1.2 as=0.1674 ps=1.29 w=0.36 l=0.15
X27 a_1725_36.t2 a_393_36.t2 a_1088_165.t3 VNB.t13 sky130_fd_pr__special_nfet_01v8 ad=0.1674 pd=1.29 as=0.13702 ps=1.2 w=0.36 l=0.15
C0 VPWR CLK 0.04196f
C2 Q RESET_B 0.00136f
C3 RESET_B VPB 0.26748f
C4 D VPWR 0.03564f
C5 Q VPWR 0.13857f
C6 VPWR VPB 0.573f
C7 VGND CLK 0.04537f
C8 VGND D 0.03531f
C9 VGND Q 0.10221f
C10 VGND VPB 0.03136f
C11 RESET_B VPWR 0.58159f
C12 VGND RESET_B 0.064f
C13 VGND VPWR 0.0767f
C14 VPB CLK 0.09785f
C15 D VPB 0.11625f
C16 Q VPB 0.01435f
R0 Q Q.t0 344.07
R1 Q.n0 Q.t1 222.143
R2 Q Q.n0 19.2005
R3 Q.n0 Q 9.6005
R4 VGND.n24 VGND.t3 253
R5 VGND.n30 VGND.t2 253
R6 VGND.n18 VGND.t4 253
R7 VGND.n9 VGND.t0 249.8
R8 VGND.n50 VGND.t7 234.944
R9 VGND VGND.t6 231.744
R10 VGND.n1 VGND.n0 197.8
R11 VGND.n0 VGND.t1 52.0005
R12 VGND.n0 VGND.t5 52.0005
R13 VGND VGND.n65 16.0977
R14 VGND.n18 VGND.n17 15.7005
R15 VGND.n63 VGND.n62 12.8005
R16 VGND.n62 VGND.n61 12.8005
R17 VGND.n61 VGND.n3 12.8005
R18 VGND.n57 VGND.n3 12.8005
R19 VGND.n57 VGND.n56 12.8005
R20 VGND.n56 VGND.n55 12.8005
R21 VGND.n55 VGND.n5 12.8005
R22 VGND.n51 VGND.n5 12.8005
R23 VGND.n49 VGND.n48 12.8005
R24 VGND.n48 VGND.n7 12.8005
R25 VGND.n44 VGND.n43 12.8005
R26 VGND.n43 VGND.n42 12.8005
R27 VGND.n42 VGND.n10 12.8005
R28 VGND.n38 VGND.n10 12.8005
R29 VGND.n38 VGND.n37 12.8005
R30 VGND.n37 VGND.n36 12.8005
R31 VGND.n36 VGND.n12 12.8005
R32 VGND.n32 VGND.n12 12.8005
R33 VGND.n32 VGND.n31 12.8005
R34 VGND.n29 VGND.n14 12.8005
R35 VGND.n25 VGND.n14 12.8005
R36 VGND.n25 VGND.n24 12.8005
R37 VGND.n24 VGND.n23 12.8005
R38 VGND.n23 VGND.n16 12.8005
R39 VGND.n19 VGND.n16 12.8005
R40 VGND.n65 VGND.n1 12.5797
R41 VGND.n20 VGND.n19 9.3005
R42 VGND.n21 VGND.n16 9.3005
R43 VGND.n23 VGND.n22 9.3005
R44 VGND.n24 VGND.n15 9.3005
R45 VGND.n26 VGND.n25 9.3005
R46 VGND.n27 VGND.n14 9.3005
R47 VGND.n29 VGND.n28 9.3005
R48 VGND.n31 VGND.n13 9.3005
R49 VGND.n33 VGND.n32 9.3005
R50 VGND.n34 VGND.n12 9.3005
R51 VGND.n36 VGND.n35 9.3005
R52 VGND.n37 VGND.n11 9.3005
R53 VGND.n39 VGND.n38 9.3005
R54 VGND.n40 VGND.n10 9.3005
R55 VGND.n42 VGND.n41 9.3005
R56 VGND.n43 VGND.n8 9.3005
R57 VGND.n45 VGND.n44 9.3005
R58 VGND.n46 VGND.n7 9.3005
R59 VGND.n48 VGND.n47 9.3005
R60 VGND.n49 VGND.n6 9.3005
R61 VGND.n52 VGND.n51 9.3005
R62 VGND.n53 VGND.n5 9.3005
R63 VGND.n55 VGND.n54 9.3005
R64 VGND.n56 VGND.n4 9.3005
R65 VGND.n58 VGND.n57 9.3005
R66 VGND.n59 VGND.n3 9.3005
R67 VGND.n61 VGND.n60 9.3005
R68 VGND.n62 VGND.n2 9.3005
R69 VGND.n64 VGND.n63 9.3005
R70 VGND.n63 VGND.n1 6.4005
R71 VGND.n51 VGND.n50 6.4005
R72 VGND.n50 VGND.n49 6.4005
R73 VGND.n9 VGND.n7 6.4005
R74 VGND.n44 VGND.n9 6.4005
R75 VGND.n31 VGND.n30 6.4005
R76 VGND.n30 VGND.n29 6.4005
R77 VGND.n19 VGND.n18 6.4005
R78 VGND.n65 VGND.n64 0.141577
R79 VGND.n64 VGND.n2 0.063
R80 VGND.n60 VGND.n2 0.063
R81 VGND.n60 VGND.n59 0.063
R82 VGND.n59 VGND.n58 0.063
R83 VGND.n58 VGND.n4 0.063
R84 VGND.n54 VGND.n4 0.063
R85 VGND.n54 VGND.n53 0.063
R86 VGND.n53 VGND.n52 0.063
R87 VGND.n52 VGND.n6 0.063
R88 VGND.n47 VGND.n6 0.063
R89 VGND.n47 VGND.n46 0.063
R90 VGND.n46 VGND.n45 0.063
R91 VGND.n45 VGND.n8 0.063
R92 VGND.n41 VGND.n8 0.063
R93 VGND.n41 VGND.n40 0.063
R94 VGND.n40 VGND.n39 0.063
R95 VGND.n39 VGND.n11 0.063
R96 VGND.n35 VGND.n11 0.063
R97 VGND.n35 VGND.n34 0.063
R98 VGND.n34 VGND.n33 0.063
R99 VGND.n33 VGND.n13 0.063
R100 VGND.n28 VGND.n13 0.063
R101 VGND.n28 VGND.n27 0.063
R102 VGND.n27 VGND.n26 0.063
R103 VGND.n26 VGND.n15 0.063
R104 VGND.n22 VGND.n15 0.063
R105 VGND.n22 VGND.n21 0.063
R106 VGND.n21 VGND.n20 0.063
R107 VGND.n20 VGND.n17 0.063
R108 VGND.n17 VGND 0.03175
R109 VPWR.n32 VPWR.t1 683.168
R110 VPWR.n71 VPWR.t5 683.168
R111 VPWR.n26 VPWR.t3 661.976
R112 VPWR.n20 VPWR.t4 661.976
R113 VPWR.n45 VPWR.n11 597.801
R114 VPWR.n4 VPWR.n3 597.801
R115 VPWR.n52 VPWR.t8 359.127
R116 VPWR.n73 VPWR.t6 328.07
R117 VPWR.n11 VPWR.t0 85.3672
R118 VPWR.n11 VPWR.t9 85.3672
R119 VPWR.n3 VPWR.t2 85.3672
R120 VPWR.n3 VPWR.t7 85.3672
R121 VPWR.n73 VPWR.n72 30.6867
R122 VPWR VPWR.n73 16.0005
R123 VPWR.n20 VPWR.n19 15.7005
R124 VPWR.n70 VPWR.n69 12.8005
R125 VPWR.n69 VPWR.n1 12.8005
R126 VPWR.n65 VPWR.n64 12.8005
R127 VPWR.n64 VPWR.n63 12.8005
R128 VPWR.n63 VPWR.n5 12.8005
R129 VPWR.n59 VPWR.n5 12.8005
R130 VPWR.n59 VPWR.n58 12.8005
R131 VPWR.n58 VPWR.n57 12.8005
R132 VPWR.n57 VPWR.n7 12.8005
R133 VPWR.n53 VPWR.n7 12.8005
R134 VPWR.n51 VPWR.n50 12.8005
R135 VPWR.n50 VPWR.n9 12.8005
R136 VPWR.n46 VPWR.n9 12.8005
R137 VPWR.n46 VPWR.n45 12.8005
R138 VPWR.n45 VPWR.n44 12.8005
R139 VPWR.n44 VPWR.n12 12.8005
R140 VPWR.n40 VPWR.n12 12.8005
R141 VPWR.n40 VPWR.n39 12.8005
R142 VPWR.n39 VPWR.n38 12.8005
R143 VPWR.n38 VPWR.n14 12.8005
R144 VPWR.n34 VPWR.n14 12.8005
R145 VPWR.n34 VPWR.n33 12.8005
R146 VPWR.n31 VPWR.n16 12.8005
R147 VPWR.n27 VPWR.n16 12.8005
R148 VPWR.n27 VPWR.n26 12.8005
R149 VPWR.n26 VPWR.n25 12.8005
R150 VPWR.n25 VPWR.n18 12.8005
R151 VPWR.n21 VPWR.n18 12.8005
R152 VPWR.n72 VPWR.n71 11.2737
R153 VPWR.n22 VPWR.n21 9.3005
R154 VPWR.n23 VPWR.n18 9.3005
R155 VPWR.n25 VPWR.n24 9.3005
R156 VPWR.n26 VPWR.n17 9.3005
R157 VPWR.n28 VPWR.n27 9.3005
R158 VPWR.n29 VPWR.n16 9.3005
R159 VPWR.n31 VPWR.n30 9.3005
R160 VPWR.n33 VPWR.n15 9.3005
R161 VPWR.n35 VPWR.n34 9.3005
R162 VPWR.n36 VPWR.n14 9.3005
R163 VPWR.n38 VPWR.n37 9.3005
R164 VPWR.n39 VPWR.n13 9.3005
R165 VPWR.n41 VPWR.n40 9.3005
R166 VPWR.n42 VPWR.n12 9.3005
R167 VPWR.n44 VPWR.n43 9.3005
R168 VPWR.n45 VPWR.n10 9.3005
R169 VPWR.n47 VPWR.n46 9.3005
R170 VPWR.n48 VPWR.n9 9.3005
R171 VPWR.n50 VPWR.n49 9.3005
R172 VPWR.n51 VPWR.n8 9.3005
R173 VPWR.n54 VPWR.n53 9.3005
R174 VPWR.n55 VPWR.n7 9.3005
R175 VPWR.n57 VPWR.n56 9.3005
R176 VPWR.n58 VPWR.n6 9.3005
R177 VPWR.n60 VPWR.n59 9.3005
R178 VPWR.n61 VPWR.n5 9.3005
R179 VPWR.n63 VPWR.n62 9.3005
R180 VPWR.n64 VPWR.n2 9.3005
R181 VPWR.n66 VPWR.n65 9.3005
R182 VPWR.n67 VPWR.n1 9.3005
R183 VPWR.n69 VPWR.n68 9.3005
R184 VPWR.n70 VPWR.n0 9.3005
R185 VPWR.n71 VPWR.n70 6.4005
R186 VPWR.n4 VPWR.n1 6.4005
R187 VPWR.n65 VPWR.n4 6.4005
R188 VPWR.n53 VPWR.n52 6.4005
R189 VPWR.n52 VPWR.n51 6.4005
R190 VPWR.n33 VPWR.n32 6.4005
R191 VPWR.n32 VPWR.n31 6.4005
R192 VPWR.n21 VPWR.n20 6.4005
R193 VPWR.n72 VPWR.n0 1.44789
R194 VPWR.n68 VPWR.n0 0.063
R195 VPWR.n68 VPWR.n67 0.063
R196 VPWR.n67 VPWR.n66 0.063
R197 VPWR.n66 VPWR.n2 0.063
R198 VPWR.n62 VPWR.n2 0.063
R199 VPWR.n62 VPWR.n61 0.063
R200 VPWR.n61 VPWR.n60 0.063
R201 VPWR.n60 VPWR.n6 0.063
R202 VPWR.n56 VPWR.n6 0.063
R203 VPWR.n56 VPWR.n55 0.063
R204 VPWR.n55 VPWR.n54 0.063
R205 VPWR.n54 VPWR.n8 0.063
R206 VPWR.n49 VPWR.n8 0.063
R207 VPWR.n49 VPWR.n48 0.063
R208 VPWR.n48 VPWR.n47 0.063
R209 VPWR.n47 VPWR.n10 0.063
R210 VPWR.n43 VPWR.n10 0.063
R211 VPWR.n43 VPWR.n42 0.063
R212 VPWR.n42 VPWR.n41 0.063
R213 VPWR.n41 VPWR.n13 0.063
R214 VPWR.n37 VPWR.n13 0.063
R215 VPWR.n37 VPWR.n36 0.063
R216 VPWR.n36 VPWR.n35 0.063
R217 VPWR.n35 VPWR.n15 0.063
R218 VPWR.n30 VPWR.n15 0.063
R219 VPWR.n30 VPWR.n29 0.063
R220 VPWR.n29 VPWR.n28 0.063
R221 VPWR.n28 VPWR.n17 0.063
R222 VPWR.n24 VPWR.n17 0.063
R223 VPWR.n24 VPWR.n23 0.063
R224 VPWR.n23 VPWR.n22 0.063
R225 VPWR.n22 VPWR.n19 0.063
R226 VPWR.n19 VPWR 0.03175
R227 RESET_B.n1 RESET_B.t1 424.697
R228 RESET_B.n0 RESET_B.t0 424.697
R229 RESET_B RESET_B.n0 217.03
R230 RESET_B.n1 RESET_B.t3 193.337
R231 RESET_B.n0 RESET_B.t2 193.337
R232 RESET_B RESET_B.n1 161.601
R233 D.n0 D.t1 290.808
R234 D.n0 D.t0 290.808
R235 D D.n0 158.4
R236 CLK.n0 CLK.t1 319.728
R237 CLK.n0 CLK.t0 232.968
R238 CLK CLK.n0 158.4
R239 VPB.t1 VPB.t10 777.274
R240 VPB.t7 VPB.t8 604.545
R241 VPB.t0 VPB.t4 604.545
R242 VPB.t3 VPB.t0 604.545
R243 VPB.t5 VPB.t13 518.183
R244 VPB.t11 VPB.t6 518.183
R245 VPB.t13 VPB.t9 431.818
R246 VPB.t6 VPB.t12 431.818
R247 VPB.t10 VPB.t5 345.455
R248 VPB VPB.t3 302.274
R249 VPB.t2 VPB.t7 259.091
R250 VPB.t9 VPB.t2 259.091
R251 VPB.t12 VPB.t1 259.091
R252 VPB.t4 VPB.t11 259.091
R253 VNB.t0 VNB.t10 3600
R254 VNB.t8 VNB.t9 2800
R255 VNB.t4 VNB.t3 2800
R256 VNB.t2 VNB.t4 2800
R257 VNB.t13 VNB.t6 2400
R258 VNB.t5 VNB.t11 2400
R259 VNB.t6 VNB.t7 2000
R260 VNB.t11 VNB.t12 2000
R261 VNB.t10 VNB.t13 1600
R262 VNB VNB.t2 1400
R263 VNB.t1 VNB.t8 1200
R264 VNB.t7 VNB.t1 1200
R265 VNB.t12 VNB.t0 1200
R266 VNB.t3 VNB.t5 1200
R267 a_2229_36.t0 a_2229_36.t1 104.001
R268 a_1941_36.t0 a_1941_36.t1 219
R269 a_1149_36.t0 a_1149_36.t1 104.001
R270 a_969_36.t0 a_969_36.t1 219
R271 a_1941_450.t0 a_1941_450.t1 328.334
R272 a_969_450.t0 a_969_450.n0 1287.6
R273 a_969_450.n0 a_969_450.t1 242.968
R274 a_969_450.n0 a_969_450.t2 85.3672
R275 a_645_36.n0 a_645_36.t0 56.0005
R276 a_645_36.t2 a_645_36.n0 65.0005
R277 a_645_36.n0 a_645_36.n1 907.601
R278 a_645_36.n1 a_645_36.t1 85.3672
R279 a_645_36.n1 a_645_36.t3 85.3672
R280 a_1725_36.n0 a_1725_36.t2 245
R281 a_1725_36.t1 a_1725_36.n0 65.0005
R282 a_1725_36.n0 a_1725_36.n2 242.601
R283 a_1725_36.n2 a_1725_36.n3 305.601
R284 a_1725_36.n3 a_1725_36.t4 251.177
R285 a_1725_36.n3 a_1725_36.t5 366.856
R286 a_1725_36.n2 a_1725_36.n1 652.201
R287 a_1725_36.n1 a_1725_36.t0 321.767
R288 a_1725_36.n1 a_1725_36.t3 85.3672
R289 a_2060_165.t0 a_2060_165.n1 249.8
R290 a_2060_165.n1 a_2060_165.n3 16.0005
R291 a_2060_165.n3 a_2060_165.n4 174.4
R292 a_2060_165.n4 a_2060_165.t3 204.048
R293 a_2060_165.n4 a_2060_165.t5 247.428
R294 a_2060_165.n3 a_2060_165.n2 645.801
R295 a_2060_165.n2 a_2060_165.t2 85.3672
R296 a_2060_165.n2 a_2060_165.t1 85.3672
R297 a_2060_165.n1 a_2060_165.n0 235.379
R298 a_2060_165.n0 a_2060_165.t4 161.036
R299 a_2060_165.n0 a_2060_165.t6 450.236
R300 a_753_36.t1 a_753_36.n0 245
R301 a_753_36.n0 a_753_36.t3 65.0005
R302 a_753_36.n0 a_753_36.n2 242.601
R303 a_753_36.n2 a_753_36.n3 382.401
R304 a_753_36.n3 a_753_36.t4 222.256
R305 a_753_36.n3 a_753_36.t5 309.017
R306 a_753_36.n2 a_753_36.n1 652.201
R307 a_753_36.n1 a_753_36.t2 321.767
R308 a_753_36.n1 a_753_36.t0 85.3672
R309 a_1088_165.n0 a_1088_165.t0 107.144
R310 a_1088_165.t3 a_1088_165.n0 65.0005
R311 a_1088_165.n0 a_1088_165.n2 204.201
R312 a_1088_165.n2 a_1088_165.n3 331.378
R313 a_1088_165.n3 a_1088_165.t4 161.036
R314 a_1088_165.n3 a_1088_165.t5 450.236
R315 a_1088_165.n2 a_1088_165.n1 690.601
R316 a_1088_165.n1 a_1088_165.t1 139.846
R317 a_1088_165.n1 a_1088_165.t2 85.3672
R318 a_393_36.t1 a_393_36.n0 253
R319 a_393_36.n0 a_393_36.n1 10.2246
R320 a_393_36.n1 a_393_36.n2 0.321929
R321 a_393_36.n2 a_393_36.n3 10.9076
R322 a_393_36.n3 a_393_36.t4 425.334
R323 a_393_36.n3 a_393_36.t2 301.957
R324 a_393_36.n2 a_393_36.t3 308.091
R325 a_393_36.n1 a_393_36.t5 680.521
R326 a_393_36.n0 a_393_36.t0 700.376
R327 a_141_36.t0 a_141_36.n4 259.401
R328 a_141_36.n4 a_141_36.n5 177.601
R329 a_141_36.n5 a_141_36.t4 232.968
R330 a_141_36.n5 a_141_36.t7 319.728
R331 a_141_36.n4 a_141_36.n0 12.8005
R332 a_141_36.n0 a_141_36.n1 10.45
R333 a_141_36.n1 a_141_36.n2 0.561253
R334 a_141_36.n2 a_141_36.n3 2.0005
R335 a_141_36.n3 a_141_36.t2 308.413
R336 a_141_36.n3 a_141_36.t5 680.521
R337 a_141_36.n2 a_141_36.t6 351.471
R338 a_141_36.n1 a_141_36.t3 375.257
R339 a_141_36.n0 a_141_36.t1 668.376
C17 Q VNB 0.27249f
C18 VGND VNB 1.77018f
C19 VPWR VNB 1.22068f
C20 RESET_B VNB 1.29763f
C21 D VNB 0.22214f
C22 CLK VNB 0.25869f
C23 VPB VNB 3.30737f
C24 a_141_36.t0 VNB 0.08837f
C25 a_141_36.t1 VNB 0.1241f
C26 a_141_36.n0 VNB 0.2439f
C27 a_141_36.t3 VNB 0.06955f
C28 a_141_36.n1 VNB 0.70766f
C29 a_141_36.t6 VNB 0.0711f
C30 a_141_36.n2 VNB 0.55916f
C31 a_141_36.t5 VNB 0.11979f
C32 a_141_36.n3 VNB 0.74713f
C33 a_141_36.t2 VNB 0.06524f
C34 a_141_36.n4 VNB 0.41287f
C35 a_141_36.t7 VNB 0.05301f
C36 a_141_36.t4 VNB 0.03505f
C37 a_141_36.n5 VNB 0.18071f
C38 a_393_36.t1 VNB 0.0948f
C39 a_393_36.t0 VNB 0.15352f
C40 a_393_36.n0 VNB 0.57599f
C41 a_393_36.t5 VNB 0.13479f
C42 a_393_36.n1 VNB 0.60081f
C43 a_393_36.t3 VNB 0.07323f
C44 a_393_36.n2 VNB 0.7375f
C45 a_393_36.n3 VNB 0.50714f
C46 a_393_36.t2 VNB 0.05653f
C47 a_393_36.t4 VNB 0.15251f
C48 a_1088_165.t3 VNB 0.01998f
C49 a_1088_165.n0 VNB 0.06765f
C50 a_1088_165.t1 VNB 0.09729f
C51 a_1088_165.t2 VNB 0.02498f
C52 a_1088_165.n1 VNB 0.09935f
C53 a_1088_165.n2 VNB 0.52003f
C54 a_1088_165.t5 VNB 0.06429f
C55 a_1088_165.t4 VNB 0.027f
C56 a_1088_165.n3 VNB 0.22673f
C57 a_1088_165.t0 VNB 0.07532f
C58 a_753_36.t1 VNB 0.0715f
C59 a_753_36.n0 VNB 0.11402f
C60 a_753_36.t2 VNB 0.08937f
C61 a_753_36.t0 VNB 0.02371f
C62 a_753_36.n1 VNB 0.12519f
C63 a_753_36.n2 VNB 0.49624f
C64 a_753_36.t5 VNB 0.05801f
C65 a_753_36.t4 VNB 0.04008f
C66 a_753_36.n3 VNB 0.18808f
C67 a_753_36.t3 VNB 0.01897f
C68 a_2060_165.t0 VNB 0.07499f
C69 a_2060_165.t6 VNB 0.05607f
C70 a_2060_165.t4 VNB 0.02354f
C71 a_2060_165.n0 VNB 0.14468f
C72 a_2060_165.n1 VNB 0.26507f
C73 a_2060_165.t2 VNB 0.02178f
C74 a_2060_165.t1 VNB 0.02178f
C75 a_2060_165.n2 VNB 0.05695f
C76 a_2060_165.n3 VNB 0.39667f
C77 a_2060_165.t5 VNB 0.05692f
C78 a_2060_165.t3 VNB 0.03545f
C79 a_2060_165.n4 VNB 0.14954f
C80 a_1725_36.t1 VNB 0.01898f
C81 a_1725_36.n0 VNB 0.11409f
C82 a_1725_36.t0 VNB 0.08943f
C83 a_1725_36.t3 VNB 0.02373f
C84 a_1725_36.n1 VNB 0.12527f
C85 a_1725_36.n2 VNB 0.43272f
C86 a_1725_36.t5 VNB 0.05062f
C87 a_1725_36.t4 VNB 0.03633f
C88 a_1725_36.n3 VNB 0.1581f
C89 a_1725_36.t2 VNB 0.07154f
C90 a_645_36.t2 VNB 0.01931f
C91 a_645_36.n0 VNB 0.2809f
C92 a_645_36.t1 VNB 0.02414f
C93 a_645_36.t3 VNB 0.02414f
C94 a_645_36.n1 VNB 0.14137f
C95 a_645_36.t0 VNB 0.02727f
C96 a_969_450.t0 VNB 0.22169f
C97 a_969_450.t1 VNB 0.05625f
C98 a_969_450.t2 VNB 0.01976f
C99 a_969_450.n0 VNB 0.25037f
C100 a_1941_450.t0 VNB 0.02074f
C101 a_1941_450.t1 VNB 0.02074f
C102 a_969_36.t0 VNB 0.0164f
C103 a_969_36.t1 VNB 0.02024f
C104 a_1149_36.t0 VNB 0.01067f
C105 a_1149_36.t1 VNB 0.01067f
C106 a_1941_36.t0 VNB 0.01671f
C107 a_1941_36.t1 VNB 0.02062f
C108 a_2229_36.t0 VNB 0.01114f
C109 a_2229_36.t1 VNB 0.01114f
C110 VPB.t8 VNB 0.26055f
C111 VPB.t7 VNB 0.16284f
C112 VPB.t2 VNB 0.09771f
C113 VPB.t9 VNB 0.13027f
C114 VPB.t13 VNB 0.17913f
C115 VPB.t5 VNB 0.16284f
C116 VPB.t10 VNB 0.2117f
C117 VPB.t1 VNB 0.19541f
C118 VPB.t12 VNB 0.13027f
C119 VPB.t6 VNB 0.17913f
C120 VPB.t11 VNB 0.14656f
C121 VPB.t4 VNB 0.16284f
C122 VPB.t0 VNB 0.22798f
C123 VPB.t3 VNB 0.17098f
C124 CLK.t1 VNB 0.04659f
C125 CLK.t0 VNB 0.0308f
C126 CLK.n0 VNB 0.14726f
C127 D.t1 VNB 0.05528f
C128 D.t0 VNB 0.05528f
C129 D.n0 VNB 0.22521f
C130 RESET_B.t2 VNB 0.04023f
C131 RESET_B.t0 VNB 0.07936f
C132 RESET_B.n0 VNB 0.4385f
C133 RESET_B.t3 VNB 0.04023f
C134 RESET_B.t1 VNB 0.07936f
C135 RESET_B.n1 VNB 0.15379f
C136 VPWR.n0 VNB 0.28564f
C137 VPWR.t5 VNB 0.02564f
C138 VPWR.n1 VNB 0.01596f
C139 VPWR.n2 VNB 0.04255f
C140 VPWR.t2 VNB 0.0072f
C141 VPWR.t7 VNB 0.0072f
C142 VPWR.n3 VNB 0.01498f
C143 VPWR.n4 VNB 0.0473f
C144 VPWR.n5 VNB 0.02128f
C145 VPWR.n6 VNB 0.04255f
C146 VPWR.n7 VNB 0.02128f
C147 VPWR.n8 VNB 0.04255f
C148 VPWR.t8 VNB 0.04727f
C149 VPWR.n9 VNB 0.02128f
C150 VPWR.n10 VNB 0.04255f
C151 VPWR.t0 VNB 0.0072f
C152 VPWR.t9 VNB 0.0072f
C153 VPWR.n11 VNB 0.01498f
C154 VPWR.n12 VNB 0.02128f
C155 VPWR.n13 VNB 0.04255f
C156 VPWR.n14 VNB 0.02128f
C157 VPWR.n15 VNB 0.04255f
C158 VPWR.t1 VNB 0.02564f
C159 VPWR.n16 VNB 0.02128f
C160 VPWR.n17 VNB 0.04255f
C161 VPWR.t3 VNB 0.03698f
C162 VPWR.n18 VNB 0.02128f
C163 VPWR.n19 VNB 0.03842f
C164 VPWR.t4 VNB 0.03698f
C165 VPWR.n20 VNB 0.06977f
C166 VPWR.n21 VNB 0.01596f
C167 VPWR.n22 VNB 0.04255f
C168 VPWR.n23 VNB 0.04255f
C169 VPWR.n24 VNB 0.04255f
C170 VPWR.n25 VNB 0.02128f
C171 VPWR.n26 VNB 0.07096f
C172 VPWR.n27 VNB 0.02128f
C173 VPWR.n28 VNB 0.04255f
C174 VPWR.n29 VNB 0.04255f
C175 VPWR.n30 VNB 0.04255f
C176 VPWR.n31 VNB 0.01596f
C177 VPWR.n32 VNB 0.04994f
C178 VPWR.n33 VNB 0.01596f
C179 VPWR.n34 VNB 0.02128f
C180 VPWR.n35 VNB 0.04255f
C181 VPWR.n36 VNB 0.04255f
C182 VPWR.n37 VNB 0.04255f
C183 VPWR.n38 VNB 0.02128f
C184 VPWR.n39 VNB 0.02128f
C185 VPWR.n40 VNB 0.02128f
C186 VPWR.n41 VNB 0.04255f
C187 VPWR.n42 VNB 0.04255f
C188 VPWR.n43 VNB 0.04255f
C189 VPWR.n44 VNB 0.02128f
C190 VPWR.n45 VNB 0.05794f
C191 VPWR.n46 VNB 0.02128f
C192 VPWR.n47 VNB 0.04255f
C193 VPWR.n48 VNB 0.04255f
C194 VPWR.n49 VNB 0.04255f
C195 VPWR.n50 VNB 0.02128f
C196 VPWR.n51 VNB 0.01596f
C197 VPWR.n52 VNB 0.07175f
C198 VPWR.n53 VNB 0.01596f
C199 VPWR.n54 VNB 0.04255f
C200 VPWR.n55 VNB 0.04255f
C201 VPWR.n56 VNB 0.04255f
C202 VPWR.n57 VNB 0.02128f
C203 VPWR.n58 VNB 0.02128f
C204 VPWR.n59 VNB 0.02128f
C205 VPWR.n60 VNB 0.04255f
C206 VPWR.n61 VNB 0.04255f
C207 VPWR.n62 VNB 0.04255f
C208 VPWR.n63 VNB 0.02128f
C209 VPWR.n64 VNB 0.02128f
C210 VPWR.n65 VNB 0.01596f
C211 VPWR.n66 VNB 0.04255f
C212 VPWR.n67 VNB 0.04255f
C213 VPWR.n68 VNB 0.04255f
C214 VPWR.n69 VNB 0.02128f
C215 VPWR.n70 VNB 0.01596f
C216 VPWR.n71 VNB 0.0578f
C217 VPWR.n72 VNB 0.07531f
C218 VPWR.t6 VNB 0.06115f
C219 VPWR.n73 VNB 0.04875f
C220 VGND.t6 VNB 0.02421f
C221 VGND.t1 VNB 0.00496f
C222 VGND.t5 VNB 0.00496f
C223 VGND.n0 VNB 0.01086f
C224 VGND.n1 VNB 0.037f
C225 VGND.n2 VNB 0.02929f
C226 VGND.n3 VNB 0.01464f
C227 VGND.n4 VNB 0.02929f
C228 VGND.n5 VNB 0.01464f
C229 VGND.n6 VNB 0.02929f
C230 VGND.t7 VNB 0.02437f
C231 VGND.n7 VNB 0.01098f
C232 VGND.n8 VNB 0.02929f
C233 VGND.t0 VNB 0.01688f
C234 VGND.n9 VNB 0.03148f
C235 VGND.n10 VNB 0.01464f
C236 VGND.n11 VNB 0.02929f
C237 VGND.n12 VNB 0.01464f
C238 VGND.n13 VNB 0.02929f
C239 VGND.t2 VNB 0.01721f
C240 VGND.n14 VNB 0.01464f
C241 VGND.n15 VNB 0.02929f
C242 VGND.t3 VNB 0.01721f
C243 VGND.n16 VNB 0.01464f
C244 VGND.n17 VNB 0.02644f
C245 VGND.t4 VNB 0.01721f
C246 VGND.n18 VNB 0.04132f
C247 VGND.n19 VNB 0.01098f
C248 VGND.n20 VNB 0.02929f
C249 VGND.n21 VNB 0.02929f
C250 VGND.n22 VNB 0.02929f
C251 VGND.n23 VNB 0.01464f
C252 VGND.n24 VNB 0.04213f
C253 VGND.n25 VNB 0.01464f
C254 VGND.n26 VNB 0.02929f
C255 VGND.n27 VNB 0.02929f
C256 VGND.n28 VNB 0.02929f
C257 VGND.n29 VNB 0.01098f
C258 VGND.n30 VNB 0.03481f
C259 VGND.n31 VNB 0.01098f
C260 VGND.n32 VNB 0.01464f
C261 VGND.n33 VNB 0.02929f
C262 VGND.n34 VNB 0.02929f
C263 VGND.n35 VNB 0.02929f
C264 VGND.n36 VNB 0.01464f
C265 VGND.n37 VNB 0.01464f
C266 VGND.n38 VNB 0.01464f
C267 VGND.n39 VNB 0.02929f
C268 VGND.n40 VNB 0.02929f
C269 VGND.n41 VNB 0.02929f
C270 VGND.n42 VNB 0.01464f
C271 VGND.n43 VNB 0.01464f
C272 VGND.n44 VNB 0.01098f
C273 VGND.n45 VNB 0.02929f
C274 VGND.n46 VNB 0.02929f
C275 VGND.n47 VNB 0.02929f
C276 VGND.n48 VNB 0.01464f
C277 VGND.n49 VNB 0.01098f
C278 VGND.n50 VNB 0.03161f
C279 VGND.n51 VNB 0.01098f
C280 VGND.n52 VNB 0.02929f
C281 VGND.n53 VNB 0.02929f
C282 VGND.n54 VNB 0.02929f
C283 VGND.n55 VNB 0.01464f
C284 VGND.n56 VNB 0.01464f
C285 VGND.n57 VNB 0.01464f
C286 VGND.n58 VNB 0.02929f
C287 VGND.n59 VNB 0.02929f
C288 VGND.n60 VNB 0.02929f
C289 VGND.n61 VNB 0.01464f
C290 VGND.n62 VNB 0.01464f
C291 VGND.n63 VNB 0.01098f
C292 VGND.n64 VNB 0.12905f
C293 VGND.n65 VNB 0.2297f
C294 Q.t0 VNB 0.0821f
C295 Q.t1 VNB 0.04394f
C296 Q.n0 VNB 0.03715f
.ends

.subckt sky130_efx_lvdig__dfrtp_2 CLK D RESET_B Q VGND VNB VPB VPWR
X0 VGND.t5 a_2060_165.t3 Q.t1 VNB.t5 sky130_fd_pr__nfet_01v8 ad=0.23625 pd=2.01 as=0.12285 ps=1.02 w=0.63 l=0.15
X1 Q.t2 a_2060_165.t4 VGND.t6 VNB.t6 sky130_fd_pr__nfet_01v8 ad=0.12285 pd=1.02 as=0.23625 ps=2.01 w=0.63 l=0.15
X2 a_969_450.t2 a_141_36.t6 a_753_36.t3 VPB.t14 sky130_fd_pr__pfet_01v8_hvt ad=0.16875 pd=1.2 as=0.20925 ps=1.38 w=0.45 l=0.15
X3 VPWR.t10 a_1088_165.t5 a_969_450.t1 VPB.t10 sky130_fd_pr__pfet_01v8_hvt ad=0.08775 pd=0.84 as=0.16875 ps=1.2 w=0.45 l=0.15
X4 a_141_36.t0 CLK.t1 VPWR.t2 VPB.t3 sky130_fd_pr__pfet_01v8_hvt ad=0.23625 pd=2.01 as=0.23625 ps=2.01 w=0.63 l=0.15
X5 VPWR.t8 a_1725_36.t5 a_2060_165.t1 VPB.t7 sky130_fd_pr__pfet_01v8_hvt ad=0.16875 pd=1.65 as=0.08775 ps=0.84 w=0.45 l=0.15
X6 a_645_36.t1 D.t0 VGND.t1 VNB.t7 sky130_fd_pr__nfet_01v8 ad=0.08258 pd=0.84 as=0.16875 ps=1.65 w=0.45 l=0.15
X7 a_753_36.t2 a_141_36.t3 a_645_36.t3 VNB.t13 sky130_fd_pr__special_nfet_01v8 ad=0.1674 pd=1.29 as=0.08258 ps=0.84 w=0.36 l=0.15
X8 a_969_450.t0 RESET_B.t3 VPWR.t4 VPB.t1 sky130_fd_pr__pfet_01v8_hvt ad=0.16875 pd=1.65 as=0.08775 ps=0.84 w=0.45 l=0.15
X9 Q.t0 a_2060_165.t7 VPWR.t5 VPB.t4 sky130_fd_pr__pfet_01v8_hvt ad=0.2106 pd=1.47 as=0.405 ps=2.91 w=1.08 l=0.15
X10 a_1941_450.t1 a_393_36.t4 a_1725_36.t1 VPB.t12 sky130_fd_pr__pfet_01v8_hvt ad=0.16875 pd=1.2 as=0.20925 ps=1.38 w=0.45 l=0.15
X11 VGND.t4 a_2060_165.t5 a_1941_36.t0 VNB.t4 sky130_fd_pr__nfet_01v8 ad=0.08775 pd=0.84 as=0.15593 ps=1.2 w=0.45 l=0.15
X12 VPWR.t7 a_2060_165.t6 Q.t3 VPB.t6 sky130_fd_pr__pfet_01v8_hvt ad=0.405 pd=2.91 as=0.2106 ps=1.47 w=1.08 l=0.15
X13 a_141_36.t1 CLK.t0 VGND.t0 VNB.t2 sky130_fd_pr__nfet_01v8 ad=0.16875 pd=1.65 as=0.16875 ps=1.65 w=0.45 l=0.15
X14 a_1088_165.t3 a_753_36.t4 VGND.t7 VNB.t8 sky130_fd_pr__nfet_01v8 ad=0.13702 pd=1.2 as=0.23625 ps=2.01 w=0.63 l=0.15
X15 a_393_36.t0 a_141_36.t7 VPWR.t3 VPB.t0 sky130_fd_pr__pfet_01v8_hvt ad=0.23625 pd=2.01 as=0.23625 ps=2.01 w=0.63 l=0.15
X16 a_969_36.t1 a_393_36.t3 a_753_36.t1 VNB.t11 sky130_fd_pr__special_nfet_01v8 ad=0.15593 pd=1.2 as=0.1674 ps=1.29 w=0.36 l=0.15
X17 a_1149_36.t1 a_1088_165.t4 a_969_36.t0 VNB.t10 sky130_fd_pr__nfet_01v8 ad=0.08775 pd=0.84 as=0.15593 ps=1.2 w=0.45 l=0.15
X18 VGND.t3 RESET_B.t1 a_1149_36.t0 VNB.t0 sky130_fd_pr__nfet_01v8 ad=0.16875 pd=1.65 as=0.08775 ps=0.84 w=0.45 l=0.15
X19 VPWR.t6 a_2060_165.t8 a_1941_450.t0 VPB.t5 sky130_fd_pr__pfet_01v8_hvt ad=0.08775 pd=0.84 as=0.16875 ps=1.2 w=0.45 l=0.15
X20 a_2060_165.t0 a_1725_36.t4 a_2229_36.t1 VNB.t3 sky130_fd_pr__nfet_01v8 ad=0.16875 pd=1.65 as=0.08775 ps=0.84 w=0.45 l=0.15
X21 a_2229_36.t0 RESET_B.t0 VGND.t2 VNB.t1 sky130_fd_pr__nfet_01v8 ad=0.08775 pd=0.84 as=0.08775 ps=0.84 w=0.45 l=0.15
X22 a_645_36.t0 D.t1 VPWR.t1 VPB.t8 sky130_fd_pr__pfet_01v8_hvt ad=0.08775 pd=0.84 as=0.16875 ps=1.65 w=0.45 l=0.15
X23 a_2060_165.t2 RESET_B.t2 VPWR.t0 VPB.t2 sky130_fd_pr__pfet_01v8_hvt ad=0.08775 pd=0.84 as=0.08775 ps=0.84 w=0.45 l=0.15
X24 a_1725_36.t2 a_141_36.t5 a_1088_165.t1 VPB.t13 sky130_fd_pr__pfet_01v8_hvt ad=0.20925 pd=1.38 as=0.17415 ps=1.38 w=0.45 l=0.15
X25 a_753_36.t0 a_393_36.t5 a_645_36.t2 VPB.t11 sky130_fd_pr__pfet_01v8_hvt ad=0.20925 pd=1.38 as=0.08775 ps=0.84 w=0.45 l=0.15
X26 a_1088_165.t2 a_753_36.t5 VPWR.t9 VPB.t9 sky130_fd_pr__pfet_01v8_hvt ad=0.17415 pd=1.38 as=0.30375 ps=2.37 w=0.81 l=0.15
X27 a_393_36.t1 a_141_36.t4 VGND.t8 VNB.t12 sky130_fd_pr__nfet_01v8 ad=0.16875 pd=1.65 as=0.16875 ps=1.65 w=0.45 l=0.15
X28 a_1941_36.t1 a_141_36.t2 a_1725_36.t3 VNB.t14 sky130_fd_pr__special_nfet_01v8 ad=0.15593 pd=1.2 as=0.1674 ps=1.29 w=0.36 l=0.15
X29 a_1725_36.t0 a_393_36.t2 a_1088_165.t0 VNB.t9 sky130_fd_pr__special_nfet_01v8 ad=0.1674 pd=1.29 as=0.13702 ps=1.2 w=0.36 l=0.15
C0 Q RESET_B 0.00144f
C1 Q VPB 0.00762f
C2 RESET_B VPWR 0.58244f
C3 VPB VPWR 0.58277f
C5 D VPB 0.11625f
C6 Q VGND 0.15357f
C7 CLK VPWR 0.04196f
C8 VGND VPWR 0.0948f
C9 VGND D 0.03531f
C10 VPB RESET_B 0.26648f
C11 VGND RESET_B 0.064f
C12 VPB CLK 0.09785f
C13 VGND VPB 0.02998f
C14 Q VPWR 0.22627f
C15 VGND CLK 0.04537f
C16 D VPWR 0.03564f
R0 Q Q.n0 308.5
R1 Q Q.n1 204.201
R2 Q.n1 Q.t1 37.1434
R3 Q.n1 Q.t2 37.1434
R4 Q.n0 Q.t3 35.5699
R5 Q.n0 Q.t0 35.5699
R6 VGND.n69 VGND.t8 253
R7 VGND.n62 VGND.t1 253
R8 VGND.n75 VGND.t0 253
R9 VGND.n48 VGND.t3 249.8
R10 VGND.n19 VGND.t5 247.951
R11 VGND.n18 VGND.t6 241.344
R12 VGND.n42 VGND.t7 234.944
R13 VGND.n28 VGND.n15 197.8
R14 VGND.n15 VGND.t2 52.0005
R15 VGND.n15 VGND.t4 52.0005
R16 VGND.n76 VGND.n75 15.7005
R17 VGND.n22 VGND.n21 12.8005
R18 VGND.n23 VGND.n22 12.8005
R19 VGND.n23 VGND.n16 12.8005
R20 VGND.n27 VGND.n16 12.8005
R21 VGND.n30 VGND.n29 12.8005
R22 VGND.n30 VGND.n13 12.8005
R23 VGND.n34 VGND.n13 12.8005
R24 VGND.n35 VGND.n34 12.8005
R25 VGND.n36 VGND.n35 12.8005
R26 VGND.n36 VGND.n11 12.8005
R27 VGND.n40 VGND.n11 12.8005
R28 VGND.n41 VGND.n40 12.8005
R29 VGND.n43 VGND.n9 12.8005
R30 VGND.n47 VGND.n9 12.8005
R31 VGND.n50 VGND.n49 12.8005
R32 VGND.n50 VGND.n7 12.8005
R33 VGND.n54 VGND.n7 12.8005
R34 VGND.n55 VGND.n54 12.8005
R35 VGND.n56 VGND.n55 12.8005
R36 VGND.n56 VGND.n5 12.8005
R37 VGND.n60 VGND.n5 12.8005
R38 VGND.n61 VGND.n60 12.8005
R39 VGND.n63 VGND.n61 12.8005
R40 VGND.n67 VGND.n3 12.8005
R41 VGND.n68 VGND.n67 12.8005
R42 VGND.n69 VGND.n68 12.8005
R43 VGND.n69 VGND.n1 12.8005
R44 VGND.n73 VGND.n1 12.8005
R45 VGND.n74 VGND.n73 12.8005
R46 VGND.n19 VGND.n18 12.1406
R47 VGND.n74 VGND.n0 9.3005
R48 VGND.n73 VGND.n72 9.3005
R49 VGND.n71 VGND.n1 9.3005
R50 VGND.n70 VGND.n69 9.3005
R51 VGND.n68 VGND.n2 9.3005
R52 VGND.n67 VGND.n66 9.3005
R53 VGND.n65 VGND.n3 9.3005
R54 VGND.n64 VGND.n63 9.3005
R55 VGND.n61 VGND.n4 9.3005
R56 VGND.n60 VGND.n59 9.3005
R57 VGND.n58 VGND.n5 9.3005
R58 VGND.n57 VGND.n56 9.3005
R59 VGND.n55 VGND.n6 9.3005
R60 VGND.n54 VGND.n53 9.3005
R61 VGND.n52 VGND.n7 9.3005
R62 VGND.n51 VGND.n50 9.3005
R63 VGND.n49 VGND.n8 9.3005
R64 VGND.n47 VGND.n46 9.3005
R65 VGND.n45 VGND.n9 9.3005
R66 VGND.n44 VGND.n43 9.3005
R67 VGND.n41 VGND.n10 9.3005
R68 VGND.n40 VGND.n39 9.3005
R69 VGND.n38 VGND.n11 9.3005
R70 VGND.n37 VGND.n36 9.3005
R71 VGND.n35 VGND.n12 9.3005
R72 VGND.n34 VGND.n33 9.3005
R73 VGND.n32 VGND.n13 9.3005
R74 VGND.n31 VGND.n30 9.3005
R75 VGND.n29 VGND.n14 9.3005
R76 VGND.n27 VGND.n26 9.3005
R77 VGND.n25 VGND.n16 9.3005
R78 VGND.n24 VGND.n23 9.3005
R79 VGND.n22 VGND.n17 9.3005
R80 VGND.n21 VGND.n20 9.3005
R81 VGND.n21 VGND.n18 6.4005
R82 VGND.n28 VGND.n27 6.4005
R83 VGND.n29 VGND.n28 6.4005
R84 VGND.n42 VGND.n41 6.4005
R85 VGND.n43 VGND.n42 6.4005
R86 VGND.n48 VGND.n47 6.4005
R87 VGND.n49 VGND.n48 6.4005
R88 VGND.n63 VGND.n62 6.4005
R89 VGND.n62 VGND.n3 6.4005
R90 VGND.n75 VGND.n74 6.4005
R91 VGND.n20 VGND.n19 0.584022
R92 VGND.n20 VGND.n17 0.063
R93 VGND.n24 VGND.n17 0.063
R94 VGND.n25 VGND.n24 0.063
R95 VGND.n26 VGND.n25 0.063
R96 VGND.n26 VGND.n14 0.063
R97 VGND.n31 VGND.n14 0.063
R98 VGND.n32 VGND.n31 0.063
R99 VGND.n33 VGND.n32 0.063
R100 VGND.n33 VGND.n12 0.063
R101 VGND.n37 VGND.n12 0.063
R102 VGND.n38 VGND.n37 0.063
R103 VGND.n39 VGND.n38 0.063
R104 VGND.n39 VGND.n10 0.063
R105 VGND.n44 VGND.n10 0.063
R106 VGND.n45 VGND.n44 0.063
R107 VGND.n46 VGND.n45 0.063
R108 VGND.n46 VGND.n8 0.063
R109 VGND.n51 VGND.n8 0.063
R110 VGND.n52 VGND.n51 0.063
R111 VGND.n53 VGND.n52 0.063
R112 VGND.n53 VGND.n6 0.063
R113 VGND.n57 VGND.n6 0.063
R114 VGND.n58 VGND.n57 0.063
R115 VGND.n59 VGND.n58 0.063
R116 VGND.n59 VGND.n4 0.063
R117 VGND.n64 VGND.n4 0.063
R118 VGND.n65 VGND.n64 0.063
R119 VGND.n66 VGND.n65 0.063
R120 VGND.n66 VGND.n2 0.063
R121 VGND.n70 VGND.n2 0.063
R122 VGND.n71 VGND.n70 0.063
R123 VGND.n72 VGND.n71 0.063
R124 VGND.n72 VGND.n0 0.063
R125 VGND.n76 VGND.n0 0.063
R126 VGND VGND.n76 0.03175
R127 VPWR.n34 VPWR.t1 683.168
R128 VPWR.n2 VPWR.t8 683.168
R129 VPWR.n28 VPWR.t3 661.976
R130 VPWR.n22 VPWR.t2 661.976
R131 VPWR.n47 VPWR.n13 597.801
R132 VPWR.n5 VPWR.n4 597.801
R133 VPWR.n54 VPWR.t9 359.127
R134 VPWR.n1 VPWR.t5 328.07
R135 VPWR.n79 VPWR.t7 328.07
R136 VPWR.n13 VPWR.t4 85.3672
R137 VPWR.n13 VPWR.t10 85.3672
R138 VPWR.n4 VPWR.t0 85.3672
R139 VPWR.n4 VPWR.t6 85.3672
R140 VPWR.n79 VPWR.n78 32.2074
R141 VPWR.n77 VPWR.n1 25.6005
R142 VPWR.n1 VPWR 16.0005
R143 VPWR VPWR.n79 16.0005
R144 VPWR.n22 VPWR.n21 15.7005
R145 VPWR.n76 VPWR.n75 12.8005
R146 VPWR.n72 VPWR.n71 12.8005
R147 VPWR.n71 VPWR.n70 12.8005
R148 VPWR.n67 VPWR.n66 12.8005
R149 VPWR.n66 VPWR.n65 12.8005
R150 VPWR.n65 VPWR.n7 12.8005
R151 VPWR.n61 VPWR.n7 12.8005
R152 VPWR.n61 VPWR.n60 12.8005
R153 VPWR.n60 VPWR.n59 12.8005
R154 VPWR.n59 VPWR.n9 12.8005
R155 VPWR.n55 VPWR.n9 12.8005
R156 VPWR.n53 VPWR.n52 12.8005
R157 VPWR.n52 VPWR.n11 12.8005
R158 VPWR.n48 VPWR.n11 12.8005
R159 VPWR.n48 VPWR.n47 12.8005
R160 VPWR.n47 VPWR.n46 12.8005
R161 VPWR.n46 VPWR.n14 12.8005
R162 VPWR.n42 VPWR.n14 12.8005
R163 VPWR.n42 VPWR.n41 12.8005
R164 VPWR.n41 VPWR.n40 12.8005
R165 VPWR.n40 VPWR.n16 12.8005
R166 VPWR.n36 VPWR.n16 12.8005
R167 VPWR.n36 VPWR.n35 12.8005
R168 VPWR.n33 VPWR.n18 12.8005
R169 VPWR.n29 VPWR.n18 12.8005
R170 VPWR.n29 VPWR.n28 12.8005
R171 VPWR.n28 VPWR.n27 12.8005
R172 VPWR.n27 VPWR.n20 12.8005
R173 VPWR.n23 VPWR.n20 12.8005
R174 VPWR.n78 VPWR.n77 12.1406
R175 VPWR.n24 VPWR.n23 9.3005
R176 VPWR.n25 VPWR.n20 9.3005
R177 VPWR.n27 VPWR.n26 9.3005
R178 VPWR.n28 VPWR.n19 9.3005
R179 VPWR.n30 VPWR.n29 9.3005
R180 VPWR.n31 VPWR.n18 9.3005
R181 VPWR.n33 VPWR.n32 9.3005
R182 VPWR.n35 VPWR.n17 9.3005
R183 VPWR.n37 VPWR.n36 9.3005
R184 VPWR.n38 VPWR.n16 9.3005
R185 VPWR.n40 VPWR.n39 9.3005
R186 VPWR.n41 VPWR.n15 9.3005
R187 VPWR.n43 VPWR.n42 9.3005
R188 VPWR.n44 VPWR.n14 9.3005
R189 VPWR.n46 VPWR.n45 9.3005
R190 VPWR.n47 VPWR.n12 9.3005
R191 VPWR.n49 VPWR.n48 9.3005
R192 VPWR.n50 VPWR.n11 9.3005
R193 VPWR.n52 VPWR.n51 9.3005
R194 VPWR.n53 VPWR.n10 9.3005
R195 VPWR.n56 VPWR.n55 9.3005
R196 VPWR.n57 VPWR.n9 9.3005
R197 VPWR.n59 VPWR.n58 9.3005
R198 VPWR.n60 VPWR.n8 9.3005
R199 VPWR.n62 VPWR.n61 9.3005
R200 VPWR.n63 VPWR.n7 9.3005
R201 VPWR.n65 VPWR.n64 9.3005
R202 VPWR.n66 VPWR.n6 9.3005
R203 VPWR.n68 VPWR.n67 9.3005
R204 VPWR.n70 VPWR.n69 9.3005
R205 VPWR.n71 VPWR.n3 9.3005
R206 VPWR.n73 VPWR.n72 9.3005
R207 VPWR.n75 VPWR.n74 9.3005
R208 VPWR.n76 VPWR.n0 9.3005
R209 VPWR.n77 VPWR.n76 6.4005
R210 VPWR.n75 VPWR.n2 6.4005
R211 VPWR.n72 VPWR.n2 6.4005
R212 VPWR.n70 VPWR.n5 6.4005
R213 VPWR.n67 VPWR.n5 6.4005
R214 VPWR.n55 VPWR.n54 6.4005
R215 VPWR.n54 VPWR.n53 6.4005
R216 VPWR.n35 VPWR.n34 6.4005
R217 VPWR.n34 VPWR.n33 6.4005
R218 VPWR.n23 VPWR.n22 6.4005
R219 VPWR.n78 VPWR.n0 0.584022
R220 VPWR.n74 VPWR.n0 0.063
R221 VPWR.n74 VPWR.n73 0.063
R222 VPWR.n73 VPWR.n3 0.063
R223 VPWR.n69 VPWR.n3 0.063
R224 VPWR.n69 VPWR.n68 0.063
R225 VPWR.n68 VPWR.n6 0.063
R226 VPWR.n64 VPWR.n6 0.063
R227 VPWR.n64 VPWR.n63 0.063
R228 VPWR.n63 VPWR.n62 0.063
R229 VPWR.n62 VPWR.n8 0.063
R230 VPWR.n58 VPWR.n8 0.063
R231 VPWR.n58 VPWR.n57 0.063
R232 VPWR.n57 VPWR.n56 0.063
R233 VPWR.n56 VPWR.n10 0.063
R234 VPWR.n51 VPWR.n10 0.063
R235 VPWR.n51 VPWR.n50 0.063
R236 VPWR.n50 VPWR.n49 0.063
R237 VPWR.n49 VPWR.n12 0.063
R238 VPWR.n45 VPWR.n12 0.063
R239 VPWR.n45 VPWR.n44 0.063
R240 VPWR.n44 VPWR.n43 0.063
R241 VPWR.n43 VPWR.n15 0.063
R242 VPWR.n39 VPWR.n15 0.063
R243 VPWR.n39 VPWR.n38 0.063
R244 VPWR.n38 VPWR.n37 0.063
R245 VPWR.n37 VPWR.n17 0.063
R246 VPWR.n32 VPWR.n17 0.063
R247 VPWR.n32 VPWR.n31 0.063
R248 VPWR.n31 VPWR.n30 0.063
R249 VPWR.n30 VPWR.n19 0.063
R250 VPWR.n26 VPWR.n19 0.063
R251 VPWR.n26 VPWR.n25 0.063
R252 VPWR.n25 VPWR.n24 0.063
R253 VPWR.n24 VPWR.n21 0.063
R254 VPWR.n21 VPWR 0.03175
R255 RESET_B.n1 RESET_B.t1 424.697
R256 RESET_B.n0 RESET_B.t0 424.697
R257 RESET_B RESET_B.n0 217.03
R258 RESET_B.n1 RESET_B.t3 193.337
R259 RESET_B.n0 RESET_B.t2 193.337
R260 RESET_B RESET_B.n1 161.601
R261 D.n0 D.t1 290.808
R262 D.n0 D.t0 290.808
R263 D D.n0 158.4
R264 CLK.n0 CLK.t1 319.728
R265 CLK.n0 CLK.t0 232.968
R266 CLK CLK.n0 158.4
R267 VPB.t1 VPB.t9 777.274
R268 VPB.t7 VPB.t4 604.545
R269 VPB.t0 VPB.t8 604.545
R270 VPB.t3 VPB.t0 604.545
R271 VPB.t13 VPB.t12 518.183
R272 VPB.t11 VPB.t14 518.183
R273 VPB.t12 VPB.t5 431.818
R274 VPB.t14 VPB.t10 431.818
R275 VPB.t9 VPB.t13 345.455
R276 VPB VPB.t3 302.274
R277 VPB.t4 VPB.t6 259.091
R278 VPB.t2 VPB.t7 259.091
R279 VPB.t5 VPB.t2 259.091
R280 VPB.t10 VPB.t1 259.091
R281 VPB.t8 VPB.t11 259.091
R282 VNB.t0 VNB.t8 3600
R283 VNB.t3 VNB.t6 2800
R284 VNB.t12 VNB.t7 2800
R285 VNB.t2 VNB.t12 2800
R286 VNB.t9 VNB.t14 2400
R287 VNB.t13 VNB.t11 2400
R288 VNB.t14 VNB.t4 2000
R289 VNB.t11 VNB.t10 2000
R290 VNB.t8 VNB.t9 1600
R291 VNB VNB.t2 1400
R292 VNB.t6 VNB.t5 1200
R293 VNB.t1 VNB.t3 1200
R294 VNB.t4 VNB.t1 1200
R295 VNB.t10 VNB.t0 1200
R296 VNB.t7 VNB.t13 1200
R297 a_2229_36.t0 a_2229_36.t1 104.001
R298 a_1941_36.t1 a_1941_36.t0 219
R299 a_1149_36.t0 a_1149_36.t1 104.001
R300 a_969_36.t1 a_969_36.t0 219
R301 a_1941_450.t0 a_1941_450.t1 328.334
R302 a_969_450.t0 a_969_450.n0 1287.6
R303 a_969_450.n0 a_969_450.t2 242.968
R304 a_969_450.n0 a_969_450.t1 85.3672
R305 a_645_36.n0 a_645_36.t1 56.0005
R306 a_645_36.t3 a_645_36.n0 65.0005
R307 a_645_36.n0 a_645_36.n1 907.601
R308 a_645_36.n1 a_645_36.t0 85.3672
R309 a_645_36.n1 a_645_36.t2 85.3672
R310 a_1725_36.t0 a_1725_36.n0 245
R311 a_1725_36.n0 a_1725_36.t3 65.0005
R312 a_1725_36.n0 a_1725_36.n2 242.601
R313 a_1725_36.n2 a_1725_36.n3 305.601
R314 a_1725_36.n3 a_1725_36.t4 251.177
R315 a_1725_36.n3 a_1725_36.t5 366.856
R316 a_1725_36.n2 a_1725_36.n1 652.201
R317 a_1725_36.n1 a_1725_36.t2 321.767
R318 a_1725_36.n1 a_1725_36.t1 85.3672
R319 a_2060_165.t0 a_2060_165.n1 249.8
R320 a_2060_165.n1 a_2060_165.n3 16.0005
R321 a_2060_165.n3 a_2060_165.n5 210.55
R322 a_2060_165.n5 a_2060_165.n4 72.3005
R323 a_2060_165.n5 a_2060_165.t7 231.361
R324 a_2060_165.n5 a_2060_165.t4 187.981
R325 a_2060_165.n4 a_2060_165.t6 231.361
R326 a_2060_165.n4 a_2060_165.t3 187.981
R327 a_2060_165.n3 a_2060_165.n2 645.801
R328 a_2060_165.n2 a_2060_165.t2 85.3672
R329 a_2060_165.n2 a_2060_165.t1 85.3672
R330 a_2060_165.n1 a_2060_165.n0 235.379
R331 a_2060_165.n0 a_2060_165.t5 161.036
R332 a_2060_165.n0 a_2060_165.t8 450.236
R333 a_753_36.n0 a_753_36.t2 245
R334 a_753_36.t1 a_753_36.n0 65.0005
R335 a_753_36.n0 a_753_36.n2 242.601
R336 a_753_36.n2 a_753_36.n3 382.401
R337 a_753_36.n3 a_753_36.t4 222.256
R338 a_753_36.n3 a_753_36.t5 309.017
R339 a_753_36.n2 a_753_36.n1 652.201
R340 a_753_36.n1 a_753_36.t0 321.767
R341 a_753_36.n1 a_753_36.t3 85.3672
R342 a_1088_165.n0 a_1088_165.t3 107.144
R343 a_1088_165.t0 a_1088_165.n0 65.0005
R344 a_1088_165.n0 a_1088_165.n2 204.201
R345 a_1088_165.n2 a_1088_165.n3 331.378
R346 a_1088_165.n3 a_1088_165.t4 161.036
R347 a_1088_165.n3 a_1088_165.t5 450.236
R348 a_1088_165.n2 a_1088_165.n1 690.601
R349 a_1088_165.n1 a_1088_165.t2 139.846
R350 a_1088_165.n1 a_1088_165.t1 85.3672
R351 a_393_36.t1 a_393_36.n0 253
R352 a_393_36.n0 a_393_36.n1 10.2246
R353 a_393_36.n1 a_393_36.n2 0.321929
R354 a_393_36.n2 a_393_36.n3 10.9076
R355 a_393_36.n3 a_393_36.t4 425.334
R356 a_393_36.n3 a_393_36.t2 301.957
R357 a_393_36.n2 a_393_36.t3 308.091
R358 a_393_36.n1 a_393_36.t5 680.521
R359 a_393_36.n0 a_393_36.t0 700.376
R360 a_141_36.t1 a_141_36.n4 259.401
R361 a_141_36.n4 a_141_36.n5 177.601
R362 a_141_36.n5 a_141_36.t4 232.968
R363 a_141_36.n5 a_141_36.t7 319.728
R364 a_141_36.n4 a_141_36.n0 12.8005
R365 a_141_36.n0 a_141_36.n1 10.45
R366 a_141_36.n1 a_141_36.n2 0.561253
R367 a_141_36.n2 a_141_36.n3 2.0005
R368 a_141_36.n3 a_141_36.t2 308.413
R369 a_141_36.n3 a_141_36.t5 680.521
R370 a_141_36.n2 a_141_36.t6 351.471
R371 a_141_36.n1 a_141_36.t3 375.257
R372 a_141_36.n0 a_141_36.t0 668.376
C17 Q VNB 0.31931f
C18 VGND VNB 1.78868f
C19 VPWR VNB 1.30686f
C20 RESET_B VNB 1.2966f
C21 D VNB 0.22214f
C22 CLK VNB 0.25869f
C23 VPB VNB 3.39246f
C24 a_141_36.t1 VNB 0.08838f
C25 a_141_36.t0 VNB 0.12411f
C26 a_141_36.n0 VNB 0.24392f
C27 a_141_36.t3 VNB 0.06956f
C28 a_141_36.n1 VNB 0.70772f
C29 a_141_36.t6 VNB 0.07111f
C30 a_141_36.n2 VNB 0.55921f
C31 a_141_36.t5 VNB 0.1198f
C32 a_141_36.n3 VNB 0.74719f
C33 a_141_36.t2 VNB 0.06524f
C34 a_141_36.n4 VNB 0.41291f
C35 a_141_36.t7 VNB 0.05302f
C36 a_141_36.t4 VNB 0.03505f
C37 a_141_36.n5 VNB 0.18072f
C38 a_393_36.t1 VNB 0.0948f
C39 a_393_36.t0 VNB 0.15352f
C40 a_393_36.n0 VNB 0.57599f
C41 a_393_36.t5 VNB 0.13479f
C42 a_393_36.n1 VNB 0.60081f
C43 a_393_36.t3 VNB 0.07323f
C44 a_393_36.n2 VNB 0.7375f
C45 a_393_36.n3 VNB 0.50714f
C46 a_393_36.t2 VNB 0.05653f
C47 a_393_36.t4 VNB 0.15251f
C48 a_1088_165.t0 VNB 0.01998f
C49 a_1088_165.n0 VNB 0.06765f
C50 a_1088_165.t2 VNB 0.09729f
C51 a_1088_165.t1 VNB 0.02498f
C52 a_1088_165.n1 VNB 0.09935f
C53 a_1088_165.n2 VNB 0.52003f
C54 a_1088_165.t5 VNB 0.06429f
C55 a_1088_165.t4 VNB 0.027f
C56 a_1088_165.n3 VNB 0.22673f
C57 a_1088_165.t3 VNB 0.07532f
C58 a_753_36.t1 VNB 0.01897f
C59 a_753_36.n0 VNB 0.11402f
C60 a_753_36.t0 VNB 0.08937f
C61 a_753_36.t3 VNB 0.02371f
C62 a_753_36.n1 VNB 0.12519f
C63 a_753_36.n2 VNB 0.49624f
C64 a_753_36.t5 VNB 0.05801f
C65 a_753_36.t4 VNB 0.04008f
C66 a_753_36.n3 VNB 0.18808f
C67 a_753_36.t2 VNB 0.0715f
C68 a_2060_165.t0 VNB 0.07117f
C69 a_2060_165.t8 VNB 0.05321f
C70 a_2060_165.t5 VNB 0.02234f
C71 a_2060_165.n0 VNB 0.13732f
C72 a_2060_165.n1 VNB 0.25157f
C73 a_2060_165.t2 VNB 0.02067f
C74 a_2060_165.t1 VNB 0.02067f
C75 a_2060_165.n2 VNB 0.05405f
C76 a_2060_165.n3 VNB 0.3875f
C77 a_2060_165.t3 VNB 0.03021f
C78 a_2060_165.t6 VNB 0.05089f
C79 a_2060_165.n4 VNB 0.10718f
C80 a_2060_165.t4 VNB 0.03021f
C81 a_2060_165.t7 VNB 0.05089f
C82 a_2060_165.n5 VNB 0.168f
C83 a_1725_36.t0 VNB 0.07163f
C84 a_1725_36.n0 VNB 0.11423f
C85 a_1725_36.t2 VNB 0.08953f
C86 a_1725_36.t1 VNB 0.02375f
C87 a_1725_36.n1 VNB 0.12542f
C88 a_1725_36.n2 VNB 0.43324f
C89 a_1725_36.t5 VNB 0.05068f
C90 a_1725_36.t4 VNB 0.03637f
C91 a_1725_36.n3 VNB 0.15829f
C92 a_1725_36.t3 VNB 0.019f
C93 a_645_36.t3 VNB 0.01931f
C94 a_645_36.n0 VNB 0.2809f
C95 a_645_36.t0 VNB 0.02414f
C96 a_645_36.t2 VNB 0.02414f
C97 a_645_36.n1 VNB 0.14137f
C98 a_645_36.t1 VNB 0.02727f
C99 a_969_450.t0 VNB 0.22169f
C100 a_969_450.t2 VNB 0.05625f
C101 a_969_450.t1 VNB 0.01976f
C102 a_969_450.n0 VNB 0.25037f
C103 a_1941_450.t0 VNB 0.02074f
C104 a_1941_450.t1 VNB 0.02074f
C105 a_969_36.t1 VNB 0.0164f
C106 a_969_36.t0 VNB 0.02024f
C107 a_1149_36.t0 VNB 0.01067f
C108 a_1149_36.t1 VNB 0.01067f
C109 a_1941_36.t1 VNB 0.01671f
C110 a_1941_36.t0 VNB 0.02062f
C111 a_2229_36.t0 VNB 0.01114f
C112 a_2229_36.t1 VNB 0.01114f
C113 VPB.t6 VNB 0.16161f
C114 VPB.t4 VNB 0.16161f
C115 VPB.t7 VNB 0.16161f
C116 VPB.t2 VNB 0.09696f
C117 VPB.t5 VNB 0.12929f
C118 VPB.t12 VNB 0.17777f
C119 VPB.t13 VNB 0.16161f
C120 VPB.t9 VNB 0.21009f
C121 VPB.t1 VNB 0.19393f
C122 VPB.t10 VNB 0.12929f
C123 VPB.t14 VNB 0.17777f
C124 VPB.t11 VNB 0.14545f
C125 VPB.t8 VNB 0.16161f
C126 VPB.t0 VNB 0.22625f
C127 VPB.t3 VNB 0.16969f
C128 CLK.t1 VNB 0.04659f
C129 CLK.t0 VNB 0.0308f
C130 CLK.n0 VNB 0.14726f
C131 D.t1 VNB 0.05528f
C132 D.t0 VNB 0.05528f
C133 D.n0 VNB 0.22521f
C134 RESET_B.t2 VNB 0.04025f
C135 RESET_B.t0 VNB 0.07938f
C136 RESET_B.n0 VNB 0.43864f
C137 RESET_B.t3 VNB 0.04025f
C138 RESET_B.t1 VNB 0.07938f
C139 RESET_B.n1 VNB 0.15384f
C140 VPWR.n0 VNB 0.19109f
C141 VPWR.t5 VNB 0.0601f
C142 VPWR.n1 VNB 0.03922f
C143 VPWR.t8 VNB 0.0252f
C144 VPWR.n2 VNB 0.04908f
C145 VPWR.n3 VNB 0.04182f
C146 VPWR.t0 VNB 0.00708f
C147 VPWR.t6 VNB 0.00708f
C148 VPWR.n4 VNB 0.01472f
C149 VPWR.n5 VNB 0.04649f
C150 VPWR.n6 VNB 0.04182f
C151 VPWR.n7 VNB 0.02091f
C152 VPWR.n8 VNB 0.04182f
C153 VPWR.n9 VNB 0.02091f
C154 VPWR.n10 VNB 0.04182f
C155 VPWR.t9 VNB 0.04645f
C156 VPWR.n11 VNB 0.02091f
C157 VPWR.n12 VNB 0.04182f
C158 VPWR.t4 VNB 0.00708f
C159 VPWR.t10 VNB 0.00708f
C160 VPWR.n13 VNB 0.01472f
C161 VPWR.n14 VNB 0.02091f
C162 VPWR.n15 VNB 0.04182f
C163 VPWR.n16 VNB 0.02091f
C164 VPWR.n17 VNB 0.04182f
C165 VPWR.t1 VNB 0.0252f
C166 VPWR.n18 VNB 0.02091f
C167 VPWR.n19 VNB 0.04182f
C168 VPWR.t3 VNB 0.03634f
C169 VPWR.n20 VNB 0.02091f
C170 VPWR.n21 VNB 0.03776f
C171 VPWR.t2 VNB 0.03634f
C172 VPWR.n22 VNB 0.06857f
C173 VPWR.n23 VNB 0.01568f
C174 VPWR.n24 VNB 0.04182f
C175 VPWR.n25 VNB 0.04182f
C176 VPWR.n26 VNB 0.04182f
C177 VPWR.n27 VNB 0.02091f
C178 VPWR.n28 VNB 0.06974f
C179 VPWR.n29 VNB 0.02091f
C180 VPWR.n30 VNB 0.04182f
C181 VPWR.n31 VNB 0.04182f
C182 VPWR.n32 VNB 0.04182f
C183 VPWR.n33 VNB 0.01568f
C184 VPWR.n34 VNB 0.04908f
C185 VPWR.n35 VNB 0.01568f
C186 VPWR.n36 VNB 0.02091f
C187 VPWR.n37 VNB 0.04182f
C188 VPWR.n38 VNB 0.04182f
C189 VPWR.n39 VNB 0.04182f
C190 VPWR.n40 VNB 0.02091f
C191 VPWR.n41 VNB 0.02091f
C192 VPWR.n42 VNB 0.02091f
C193 VPWR.n43 VNB 0.04182f
C194 VPWR.n44 VNB 0.04182f
C195 VPWR.n45 VNB 0.04182f
C196 VPWR.n46 VNB 0.02091f
C197 VPWR.n47 VNB 0.05694f
C198 VPWR.n48 VNB 0.02091f
C199 VPWR.n49 VNB 0.04182f
C200 VPWR.n50 VNB 0.04182f
C201 VPWR.n51 VNB 0.04182f
C202 VPWR.n52 VNB 0.02091f
C203 VPWR.n53 VNB 0.01568f
C204 VPWR.n54 VNB 0.07051f
C205 VPWR.n55 VNB 0.01568f
C206 VPWR.n56 VNB 0.04182f
C207 VPWR.n57 VNB 0.04182f
C208 VPWR.n58 VNB 0.04182f
C209 VPWR.n59 VNB 0.02091f
C210 VPWR.n60 VNB 0.02091f
C211 VPWR.n61 VNB 0.02091f
C212 VPWR.n62 VNB 0.04182f
C213 VPWR.n63 VNB 0.04182f
C214 VPWR.n64 VNB 0.04182f
C215 VPWR.n65 VNB 0.02091f
C216 VPWR.n66 VNB 0.02091f
C217 VPWR.n67 VNB 0.01568f
C218 VPWR.n68 VNB 0.04182f
C219 VPWR.n69 VNB 0.04182f
C220 VPWR.n70 VNB 0.01568f
C221 VPWR.n71 VNB 0.02091f
C222 VPWR.n72 VNB 0.01568f
C223 VPWR.n73 VNB 0.04182f
C224 VPWR.n74 VNB 0.04182f
C225 VPWR.n75 VNB 0.01568f
C226 VPWR.n76 VNB 0.01568f
C227 VPWR.n77 VNB 0.04172f
C228 VPWR.n78 VNB 0.09637f
C229 VPWR.t7 VNB 0.0601f
C230 VPWR.n79 VNB 0.04984f
C231 VGND.n0 VNB 0.02918f
C232 VGND.t0 VNB 0.01714f
C233 VGND.n1 VNB 0.01459f
C234 VGND.n2 VNB 0.02918f
C235 VGND.t8 VNB 0.01714f
C236 VGND.n3 VNB 0.01094f
C237 VGND.n4 VNB 0.02918f
C238 VGND.n5 VNB 0.01459f
C239 VGND.n6 VNB 0.02918f
C240 VGND.n7 VNB 0.01459f
C241 VGND.n8 VNB 0.02918f
C242 VGND.t3 VNB 0.01682f
C243 VGND.n9 VNB 0.01459f
C244 VGND.n10 VNB 0.02918f
C245 VGND.t7 VNB 0.02428f
C246 VGND.n11 VNB 0.01459f
C247 VGND.n12 VNB 0.02918f
C248 VGND.n13 VNB 0.01459f
C249 VGND.n14 VNB 0.02918f
C250 VGND.t2 VNB 0.00494f
C251 VGND.t4 VNB 0.00494f
C252 VGND.n15 VNB 0.01082f
C253 VGND.n16 VNB 0.01459f
C254 VGND.n17 VNB 0.02918f
C255 VGND.t6 VNB 0.02531f
C256 VGND.n18 VNB 0.04863f
C257 VGND.t5 VNB 0.02679f
C258 VGND.n19 VNB 0.09268f
C259 VGND.n20 VNB 0.13331f
C260 VGND.n21 VNB 0.01094f
C261 VGND.n22 VNB 0.01459f
C262 VGND.n23 VNB 0.01459f
C263 VGND.n24 VNB 0.02918f
C264 VGND.n25 VNB 0.02918f
C265 VGND.n26 VNB 0.02918f
C266 VGND.n27 VNB 0.01094f
C267 VGND.n28 VNB 0.02823f
C268 VGND.n29 VNB 0.01094f
C269 VGND.n30 VNB 0.01459f
C270 VGND.n31 VNB 0.02918f
C271 VGND.n32 VNB 0.02918f
C272 VGND.n33 VNB 0.02918f
C273 VGND.n34 VNB 0.01459f
C274 VGND.n35 VNB 0.01459f
C275 VGND.n36 VNB 0.01459f
C276 VGND.n37 VNB 0.02918f
C277 VGND.n38 VNB 0.02918f
C278 VGND.n39 VNB 0.02918f
C279 VGND.n40 VNB 0.01459f
C280 VGND.n41 VNB 0.01094f
C281 VGND.n42 VNB 0.03149f
C282 VGND.n43 VNB 0.01094f
C283 VGND.n44 VNB 0.02918f
C284 VGND.n45 VNB 0.02918f
C285 VGND.n46 VNB 0.02918f
C286 VGND.n47 VNB 0.01094f
C287 VGND.n48 VNB 0.03135f
C288 VGND.n49 VNB 0.01094f
C289 VGND.n50 VNB 0.01459f
C290 VGND.n51 VNB 0.02918f
C291 VGND.n52 VNB 0.02918f
C292 VGND.n53 VNB 0.02918f
C293 VGND.n54 VNB 0.01459f
C294 VGND.n55 VNB 0.01459f
C295 VGND.n56 VNB 0.01459f
C296 VGND.n57 VNB 0.02918f
C297 VGND.n58 VNB 0.02918f
C298 VGND.n59 VNB 0.02918f
C299 VGND.n60 VNB 0.01459f
C300 VGND.n61 VNB 0.01459f
C301 VGND.t1 VNB 0.01714f
C302 VGND.n62 VNB 0.03467f
C303 VGND.n63 VNB 0.01094f
C304 VGND.n64 VNB 0.02918f
C305 VGND.n65 VNB 0.02918f
C306 VGND.n66 VNB 0.02918f
C307 VGND.n67 VNB 0.01459f
C308 VGND.n68 VNB 0.01459f
C309 VGND.n69 VNB 0.04197f
C310 VGND.n70 VNB 0.02918f
C311 VGND.n71 VNB 0.02918f
C312 VGND.n72 VNB 0.02918f
C313 VGND.n73 VNB 0.01459f
C314 VGND.n74 VNB 0.01094f
C315 VGND.n75 VNB 0.04116f
C316 VGND.n76 VNB 0.02634f
C317 Q.t3 VNB 0.03413f
C318 Q.t0 VNB 0.03413f
C319 Q.n0 VNB 0.07288f
C320 Q.t1 VNB 0.01991f
C321 Q.t2 VNB 0.01991f
C322 Q.n1 VNB 0.04672f
.ends

.subckt sky130_efx_lvdig__dfstp_1 CLK D SET_B Q VGND VNB VPB VPWR
X0 a_1137_171.t0 a_789_36.t7 VPWR.t10 VPB.t7 sky130_fd_pr__pfet_01v8_hvt ad=0.08775 pd=0.84 as=0.16875 ps=1.65 w=0.45 l=0.15
X1 a_2985_36.t0 a_1977_36.t5 VGND.t1 VNB.t1 sky130_fd_pr__nfet_01v8 ad=0.16875 pd=1.65 as=0.16875 ps=1.65 w=0.45 l=0.15
X2 a_141_36.t0 CLK.t1 VPWR.t2 VPB.t12 sky130_fd_pr__pfet_01v8_hvt ad=0.23625 pd=2.01 as=0.23625 ps=2.01 w=0.63 l=0.15
X3 a_645_36.t3 D.t0 VGND.t3 VNB.t13 sky130_fd_pr__nfet_01v8 ad=0.13702 pd=1.2 as=0.23625 ps=2.01 w=0.63 l=0.15
X4 a_789_36.t2 a_393_36.t5 a_645_36.t0 VPB.t10 sky130_fd_pr__pfet_01v8_hvt ad=0.20925 pd=1.38 as=0.17415 ps=1.38 w=0.45 l=0.15
X5 VPWR.t3 SET_B.t3 a_1137_171.t2 VPB.t14 sky130_fd_pr__pfet_01v8_hvt ad=0.16875 pd=1.65 as=0.08775 ps=0.84 w=0.45 l=0.15
X6 a_1869_36.t0 a_789_36.t4 VGND.t9 VNB.t6 sky130_fd_pr__nfet_01v8 ad=0.08775 pd=0.84 as=0.16875 ps=1.65 w=0.45 l=0.15
X7 a_1977_36.t1 a_393_36.t2 a_1869_36.t1 VNB.t8 sky130_fd_pr__nfet_01v8 ad=0.20925 pd=1.38 as=0.08775 ps=0.84 w=0.45 l=0.15
X8 a_645_36.t2 D.t1 VPWR.t0 VPB.t13 sky130_fd_pr__pfet_01v8_hvt ad=0.17415 pd=1.38 as=0.30375 ps=2.37 w=0.81 l=0.15
X9 a_2985_36.t1 a_1977_36.t7 VPWR.t6 VPB.t3 sky130_fd_pr__pfet_01v8_hvt ad=0.23625 pd=2.01 as=0.23625 ps=2.01 w=0.63 l=0.15
X10 VPWR.t9 a_1137_171.t4 a_1005_450.t0 VPB.t6 sky130_fd_pr__pfet_01v8_hvt ad=0.16875 pd=1.65 as=0.16875 ps=1.2 w=0.45 l=0.15
X11 a_1005_450.t1 a_141_36.t6 a_789_36.t0 VPB.t8 sky130_fd_pr__pfet_01v8_hvt ad=0.16875 pd=1.2 as=0.20925 ps=1.38 w=0.45 l=0.15
X12 VPWR.t8 a_2325_171.t3 a_2193_450.t0 VPB.t5 sky130_fd_pr__pfet_01v8_hvt ad=0.08775 pd=0.84 as=0.16875 ps=1.2 w=0.45 l=0.15
X13 a_2193_36.t1 a_141_36.t2 a_1977_36.t3 VNB.t11 sky130_fd_pr__nfet_01v8 ad=0.16875 pd=1.2 as=0.20925 ps=1.38 w=0.45 l=0.15
X14 a_1005_36.t1 a_393_36.t3 a_789_36.t1 VNB.t9 sky130_fd_pr__special_nfet_01v8 ad=0.15593 pd=1.2 as=0.1674 ps=1.29 w=0.36 l=0.15
X15 VGND.t8 a_1137_171.t3 a_1005_36.t0 VNB.t5 sky130_fd_pr__nfet_01v8 ad=0.16875 pd=1.65 as=0.15593 ps=1.2 w=0.45 l=0.15
X16 a_1869_450.t1 a_789_36.t6 VPWR.t7 VPB.t4 sky130_fd_pr__pfet_01v8_hvt ad=0.08775 pd=0.84 as=0.16875 ps=1.65 w=0.45 l=0.15
X17 a_2193_450.t1 a_393_36.t4 a_1977_36.t2 VPB.t9 sky130_fd_pr__pfet_01v8_hvt ad=0.16875 pd=1.2 as=0.20925 ps=1.38 w=0.45 l=0.15
X18 a_1977_36.t4 SET_B.t2 VPWR.t1 VPB.t15 sky130_fd_pr__pfet_01v8_hvt ad=0.16875 pd=1.65 as=0.08775 ps=0.84 w=0.45 l=0.15
X19 a_789_36.t3 a_141_36.t3 a_645_36.t1 VNB.t10 sky130_fd_pr__special_nfet_01v8 ad=0.1674 pd=1.29 as=0.13702 ps=1.2 w=0.36 l=0.15
X20 a_141_36.t1 CLK.t0 VGND.t4 VNB.t12 sky130_fd_pr__nfet_01v8 ad=0.16875 pd=1.65 as=0.16875 ps=1.65 w=0.45 l=0.15
X21 a_2373_36.t0 a_2325_171.t2 a_2193_36.t0 VNB.t4 sky130_fd_pr__nfet_01v8 ad=0.08775 pd=0.84 as=0.16875 ps=1.2 w=0.45 l=0.15
X22 VGND.t5 SET_B.t0 a_2373_36.t1 VNB.t15 sky130_fd_pr__nfet_01v8 ad=0.16875 pd=1.65 as=0.08775 ps=0.84 w=0.45 l=0.15
X23 a_1977_36.t0 a_141_36.t5 a_1869_450.t0 VPB.t0 sky130_fd_pr__pfet_01v8_hvt ad=0.20925 pd=1.38 as=0.08775 ps=0.84 w=0.45 l=0.15
X24 a_393_36.t1 a_141_36.t7 VPWR.t11 VPB.t11 sky130_fd_pr__pfet_01v8_hvt ad=0.23625 pd=2.01 as=0.23625 ps=2.01 w=0.63 l=0.15
X25 a_2325_171.t0 a_1977_36.t8 VPWR.t5 VPB.t2 sky130_fd_pr__pfet_01v8_hvt ad=0.30375 pd=2.37 as=0.30375 ps=2.37 w=0.81 l=0.15
X26 Q.t1 a_2985_36.t2 VGND.t2 VNB.t2 sky130_fd_pr__nfet_01v8 ad=0.23625 pd=2.01 as=0.23625 ps=2.01 w=0.63 l=0.15
X27 a_1437_36.t0 a_789_36.t5 a_1137_171.t1 VNB.t7 sky130_fd_pr__nfet_01v8 ad=0.08775 pd=0.84 as=0.16875 ps=1.65 w=0.45 l=0.15
X28 VGND.t6 SET_B.t1 a_1437_36.t1 VNB.t14 sky130_fd_pr__nfet_01v8 ad=0.16875 pd=1.65 as=0.08775 ps=0.84 w=0.45 l=0.15
X29 Q.t0 a_2985_36.t3 VPWR.t4 VPB.t1 sky130_fd_pr__pfet_01v8_hvt ad=0.405 pd=2.91 as=0.405 ps=2.91 w=1.08 l=0.15
X30 a_2325_171.t1 a_1977_36.t6 VGND.t0 VNB.t0 sky130_fd_pr__nfet_01v8 ad=0.2025 pd=1.83 as=0.2025 ps=1.83 w=0.54 l=0.15
X31 a_393_36.t0 a_141_36.t4 VGND.t7 VNB.t3 sky130_fd_pr__nfet_01v8 ad=0.16875 pd=1.65 as=0.16875 ps=1.65 w=0.45 l=0.15
C0 VPB VPWR 0.74953f
C2 D VPB 0.08736f
C3 VPB SET_B 0.31464f
C4 VPB CLK 0.09785f
C5 VGND Q 0.10221f
C6 Q VPWR 0.13857f
C7 VGND VPWR 0.12695f
C8 D VGND 0.04181f
C10 VGND SET_B 0.06764f
C11 VGND CLK 0.04537f
C12 VPB Q 0.01435f
C13 VGND VPB 0.04941f
C14 D VPWR 0.0516f
C15 SET_B VPWR 0.58001f
C17 VPWR CLK 0.04196f
R0 Q Q.t0 344.07
R1 Q.n0 Q.t1 222.143
R2 Q Q.n0 19.2005
R3 Q.n0 Q 9.6005
R4 VGND.n86 VGND.t1 253
R5 VGND.n29 VGND.t7 253
R6 VGND.n10 VGND.t9 253
R7 VGND.n11 VGND.t6 253
R8 VGND.n23 VGND.t4 253
R9 VGND.n78 VGND.t5 249.8
R10 VGND.n49 VGND.t8 249.8
R11 VGND.n35 VGND.t3 241.344
R12 VGND.n3 VGND.t0 241.133
R13 VGND VGND.t2 231.744
R14 VGND VGND.n87 15.9387
R15 VGND.n23 VGND.n22 15.7005
R16 VGND.n86 VGND.n85 12.8005
R17 VGND.n85 VGND.n84 12.8005
R18 VGND.n84 VGND.n1 12.8005
R19 VGND.n80 VGND.n79 12.8005
R20 VGND.n77 VGND.n4 12.8005
R21 VGND.n73 VGND.n4 12.8005
R22 VGND.n73 VGND.n72 12.8005
R23 VGND.n72 VGND.n71 12.8005
R24 VGND.n71 VGND.n6 12.8005
R25 VGND.n67 VGND.n6 12.8005
R26 VGND.n67 VGND.n66 12.8005
R27 VGND.n66 VGND.n65 12.8005
R28 VGND.n65 VGND.n8 12.8005
R29 VGND.n61 VGND.n60 12.8005
R30 VGND.n60 VGND.n59 12.8005
R31 VGND.n56 VGND.n55 12.8005
R32 VGND.n55 VGND.n54 12.8005
R33 VGND.n54 VGND.n13 12.8005
R34 VGND.n50 VGND.n13 12.8005
R35 VGND.n48 VGND.n47 12.8005
R36 VGND.n47 VGND.n15 12.8005
R37 VGND.n43 VGND.n15 12.8005
R38 VGND.n43 VGND.n42 12.8005
R39 VGND.n42 VGND.n41 12.8005
R40 VGND.n41 VGND.n17 12.8005
R41 VGND.n37 VGND.n17 12.8005
R42 VGND.n37 VGND.n36 12.8005
R43 VGND.n34 VGND.n19 12.8005
R44 VGND.n30 VGND.n19 12.8005
R45 VGND.n30 VGND.n29 12.8005
R46 VGND.n29 VGND.n28 12.8005
R47 VGND.n28 VGND.n21 12.8005
R48 VGND.n24 VGND.n21 12.8005
R49 VGND.n25 VGND.n24 9.3005
R50 VGND.n26 VGND.n21 9.3005
R51 VGND.n28 VGND.n27 9.3005
R52 VGND.n29 VGND.n20 9.3005
R53 VGND.n31 VGND.n30 9.3005
R54 VGND.n32 VGND.n19 9.3005
R55 VGND.n34 VGND.n33 9.3005
R56 VGND.n36 VGND.n18 9.3005
R57 VGND.n38 VGND.n37 9.3005
R58 VGND.n39 VGND.n17 9.3005
R59 VGND.n41 VGND.n40 9.3005
R60 VGND.n42 VGND.n16 9.3005
R61 VGND.n44 VGND.n43 9.3005
R62 VGND.n45 VGND.n15 9.3005
R63 VGND.n47 VGND.n46 9.3005
R64 VGND.n48 VGND.n14 9.3005
R65 VGND.n51 VGND.n50 9.3005
R66 VGND.n52 VGND.n13 9.3005
R67 VGND.n54 VGND.n53 9.3005
R68 VGND.n55 VGND.n12 9.3005
R69 VGND.n57 VGND.n56 9.3005
R70 VGND.n59 VGND.n58 9.3005
R71 VGND.n60 VGND.n9 9.3005
R72 VGND.n62 VGND.n61 9.3005
R73 VGND.n63 VGND.n8 9.3005
R74 VGND.n65 VGND.n64 9.3005
R75 VGND.n66 VGND.n7 9.3005
R76 VGND.n68 VGND.n67 9.3005
R77 VGND.n69 VGND.n6 9.3005
R78 VGND.n71 VGND.n70 9.3005
R79 VGND.n72 VGND.n5 9.3005
R80 VGND.n74 VGND.n73 9.3005
R81 VGND.n75 VGND.n4 9.3005
R82 VGND.n77 VGND.n76 9.3005
R83 VGND.n79 VGND.n2 9.3005
R84 VGND.n81 VGND.n80 9.3005
R85 VGND.n82 VGND.n1 9.3005
R86 VGND.n84 VGND.n83 9.3005
R87 VGND.n85 VGND.n0 9.3005
R88 VGND.n3 VGND.n1 6.4005
R89 VGND.n80 VGND.n3 6.4005
R90 VGND.n79 VGND.n78 6.4005
R91 VGND.n78 VGND.n77 6.4005
R92 VGND.n10 VGND.n8 6.4005
R93 VGND.n61 VGND.n10 6.4005
R94 VGND.n59 VGND.n11 6.4005
R95 VGND.n56 VGND.n11 6.4005
R96 VGND.n50 VGND.n49 6.4005
R97 VGND.n49 VGND.n48 6.4005
R98 VGND.n36 VGND.n35 6.4005
R99 VGND.n35 VGND.n34 6.4005
R100 VGND.n24 VGND.n23 6.4005
R101 VGND.n87 VGND.n86 6.08215
R102 VGND.n87 VGND.n0 0.2391
R103 VGND.n83 VGND.n0 0.063
R104 VGND.n83 VGND.n82 0.063
R105 VGND.n82 VGND.n81 0.063
R106 VGND.n81 VGND.n2 0.063
R107 VGND.n76 VGND.n2 0.063
R108 VGND.n76 VGND.n75 0.063
R109 VGND.n75 VGND.n74 0.063
R110 VGND.n74 VGND.n5 0.063
R111 VGND.n70 VGND.n5 0.063
R112 VGND.n70 VGND.n69 0.063
R113 VGND.n69 VGND.n68 0.063
R114 VGND.n68 VGND.n7 0.063
R115 VGND.n64 VGND.n7 0.063
R116 VGND.n64 VGND.n63 0.063
R117 VGND.n63 VGND.n62 0.063
R118 VGND.n62 VGND.n9 0.063
R119 VGND.n58 VGND.n9 0.063
R120 VGND.n58 VGND.n57 0.063
R121 VGND.n57 VGND.n12 0.063
R122 VGND.n53 VGND.n12 0.063
R123 VGND.n53 VGND.n52 0.063
R124 VGND.n52 VGND.n51 0.063
R125 VGND.n51 VGND.n14 0.063
R126 VGND.n46 VGND.n14 0.063
R127 VGND.n46 VGND.n45 0.063
R128 VGND.n45 VGND.n44 0.063
R129 VGND.n44 VGND.n16 0.063
R130 VGND.n40 VGND.n16 0.063
R131 VGND.n40 VGND.n39 0.063
R132 VGND.n39 VGND.n38 0.063
R133 VGND.n38 VGND.n18 0.063
R134 VGND.n33 VGND.n18 0.063
R135 VGND.n33 VGND.n32 0.063
R136 VGND.n32 VGND.n31 0.063
R137 VGND.n31 VGND.n20 0.063
R138 VGND.n27 VGND.n20 0.063
R139 VGND.n27 VGND.n26 0.063
R140 VGND.n26 VGND.n25 0.063
R141 VGND.n25 VGND.n22 0.063
R142 VGND.n22 VGND 0.03175
R143 VPWR.n51 VPWR.t9 683.168
R144 VPWR.n14 VPWR.t10 683.168
R145 VPWR.n12 VPWR.t3 683.168
R146 VPWR.n11 VPWR.t7 683.168
R147 VPWR.n87 VPWR.t6 661.976
R148 VPWR.n22 VPWR.t11 661.976
R149 VPWR.n24 VPWR.t2 661.976
R150 VPWR.n5 VPWR.n4 597.801
R151 VPWR.n20 VPWR.t0 359.127
R152 VPWR.n3 VPWR.t5 359.127
R153 VPWR.n89 VPWR.t4 328.07
R154 VPWR.n4 VPWR.t1 85.3672
R155 VPWR.n4 VPWR.t8 85.3672
R156 VPWR.n89 VPWR.n88 31.9387
R157 VPWR VPWR.n89 16.0005
R158 VPWR.n25 VPWR.n24 15.7005
R159 VPWR.n87 VPWR.n86 12.8005
R160 VPWR.n86 VPWR.n85 12.8005
R161 VPWR.n85 VPWR.n1 12.8005
R162 VPWR.n81 VPWR.n80 12.8005
R163 VPWR.n80 VPWR.n79 12.8005
R164 VPWR.n79 VPWR.n5 12.8005
R165 VPWR.n75 VPWR.n5 12.8005
R166 VPWR.n75 VPWR.n74 12.8005
R167 VPWR.n74 VPWR.n73 12.8005
R168 VPWR.n73 VPWR.n7 12.8005
R169 VPWR.n69 VPWR.n7 12.8005
R170 VPWR.n69 VPWR.n68 12.8005
R171 VPWR.n68 VPWR.n67 12.8005
R172 VPWR.n67 VPWR.n9 12.8005
R173 VPWR.n63 VPWR.n62 12.8005
R174 VPWR.n62 VPWR.n61 12.8005
R175 VPWR.n58 VPWR.n57 12.8005
R176 VPWR.n57 VPWR.n56 12.8005
R177 VPWR.n53 VPWR.n52 12.8005
R178 VPWR.n50 VPWR.n16 12.8005
R179 VPWR.n46 VPWR.n16 12.8005
R180 VPWR.n46 VPWR.n45 12.8005
R181 VPWR.n45 VPWR.n44 12.8005
R182 VPWR.n44 VPWR.n18 12.8005
R183 VPWR.n40 VPWR.n18 12.8005
R184 VPWR.n40 VPWR.n39 12.8005
R185 VPWR.n39 VPWR.n38 12.8005
R186 VPWR.n35 VPWR.n34 12.8005
R187 VPWR.n34 VPWR.n33 12.8005
R188 VPWR.n33 VPWR.n22 12.8005
R189 VPWR.n29 VPWR.n22 12.8005
R190 VPWR.n29 VPWR.n28 12.8005
R191 VPWR.n28 VPWR.n27 12.8005
R192 VPWR.n27 VPWR.n26 9.3005
R193 VPWR.n28 VPWR.n23 9.3005
R194 VPWR.n30 VPWR.n29 9.3005
R195 VPWR.n31 VPWR.n22 9.3005
R196 VPWR.n33 VPWR.n32 9.3005
R197 VPWR.n34 VPWR.n21 9.3005
R198 VPWR.n36 VPWR.n35 9.3005
R199 VPWR.n38 VPWR.n37 9.3005
R200 VPWR.n39 VPWR.n19 9.3005
R201 VPWR.n41 VPWR.n40 9.3005
R202 VPWR.n42 VPWR.n18 9.3005
R203 VPWR.n44 VPWR.n43 9.3005
R204 VPWR.n45 VPWR.n17 9.3005
R205 VPWR.n47 VPWR.n46 9.3005
R206 VPWR.n48 VPWR.n16 9.3005
R207 VPWR.n50 VPWR.n49 9.3005
R208 VPWR.n52 VPWR.n15 9.3005
R209 VPWR.n54 VPWR.n53 9.3005
R210 VPWR.n56 VPWR.n55 9.3005
R211 VPWR.n57 VPWR.n13 9.3005
R212 VPWR.n59 VPWR.n58 9.3005
R213 VPWR.n61 VPWR.n60 9.3005
R214 VPWR.n62 VPWR.n10 9.3005
R215 VPWR.n64 VPWR.n63 9.3005
R216 VPWR.n65 VPWR.n9 9.3005
R217 VPWR.n67 VPWR.n66 9.3005
R218 VPWR.n68 VPWR.n8 9.3005
R219 VPWR.n70 VPWR.n69 9.3005
R220 VPWR.n71 VPWR.n7 9.3005
R221 VPWR.n73 VPWR.n72 9.3005
R222 VPWR.n74 VPWR.n6 9.3005
R223 VPWR.n76 VPWR.n75 9.3005
R224 VPWR.n77 VPWR.n5 9.3005
R225 VPWR.n79 VPWR.n78 9.3005
R226 VPWR.n80 VPWR.n2 9.3005
R227 VPWR.n82 VPWR.n81 9.3005
R228 VPWR.n83 VPWR.n1 9.3005
R229 VPWR.n85 VPWR.n84 9.3005
R230 VPWR.n86 VPWR.n0 9.3005
R231 VPWR.n3 VPWR.n1 6.4005
R232 VPWR.n81 VPWR.n3 6.4005
R233 VPWR.n11 VPWR.n9 6.4005
R234 VPWR.n63 VPWR.n11 6.4005
R235 VPWR.n61 VPWR.n12 6.4005
R236 VPWR.n58 VPWR.n12 6.4005
R237 VPWR.n56 VPWR.n14 6.4005
R238 VPWR.n53 VPWR.n14 6.4005
R239 VPWR.n52 VPWR.n51 6.4005
R240 VPWR.n51 VPWR.n50 6.4005
R241 VPWR.n38 VPWR.n20 6.4005
R242 VPWR.n35 VPWR.n20 6.4005
R243 VPWR.n27 VPWR.n24 6.4005
R244 VPWR.n88 VPWR.n87 6.08215
R245 VPWR.n88 VPWR.n0 0.2391
R246 VPWR.n84 VPWR.n0 0.063
R247 VPWR.n84 VPWR.n83 0.063
R248 VPWR.n83 VPWR.n82 0.063
R249 VPWR.n82 VPWR.n2 0.063
R250 VPWR.n78 VPWR.n2 0.063
R251 VPWR.n78 VPWR.n77 0.063
R252 VPWR.n77 VPWR.n76 0.063
R253 VPWR.n76 VPWR.n6 0.063
R254 VPWR.n72 VPWR.n6 0.063
R255 VPWR.n72 VPWR.n71 0.063
R256 VPWR.n71 VPWR.n70 0.063
R257 VPWR.n70 VPWR.n8 0.063
R258 VPWR.n66 VPWR.n8 0.063
R259 VPWR.n66 VPWR.n65 0.063
R260 VPWR.n65 VPWR.n64 0.063
R261 VPWR.n64 VPWR.n10 0.063
R262 VPWR.n60 VPWR.n10 0.063
R263 VPWR.n60 VPWR.n59 0.063
R264 VPWR.n59 VPWR.n13 0.063
R265 VPWR.n55 VPWR.n13 0.063
R266 VPWR.n55 VPWR.n54 0.063
R267 VPWR.n54 VPWR.n15 0.063
R268 VPWR.n49 VPWR.n15 0.063
R269 VPWR.n49 VPWR.n48 0.063
R270 VPWR.n48 VPWR.n47 0.063
R271 VPWR.n47 VPWR.n17 0.063
R272 VPWR.n43 VPWR.n17 0.063
R273 VPWR.n43 VPWR.n42 0.063
R274 VPWR.n42 VPWR.n41 0.063
R275 VPWR.n41 VPWR.n19 0.063
R276 VPWR.n37 VPWR.n19 0.063
R277 VPWR.n37 VPWR.n36 0.063
R278 VPWR.n36 VPWR.n21 0.063
R279 VPWR.n32 VPWR.n21 0.063
R280 VPWR.n32 VPWR.n31 0.063
R281 VPWR.n31 VPWR.n30 0.063
R282 VPWR.n30 VPWR.n23 0.063
R283 VPWR.n26 VPWR.n23 0.063
R284 VPWR.n26 VPWR.n25 0.063
R285 VPWR.n25 VPWR 0.03175
R286 SET_B.n0 SET_B.t0 424.697
R287 SET_B.n1 SET_B.t1 410.389
R288 SET_B SET_B.n0 210.548
R289 SET_B.n0 SET_B.t2 193.337
R290 SET_B.n1 SET_B.t3 179.03
R291 SET_B SET_B.n1 158.4
R292 D.n0 D.t0 261.887
R293 D.n0 D.t1 232.968
R294 D D.n0 158.4
R295 CLK.n0 CLK.t1 319.728
R296 CLK.n0 CLK.t0 232.968
R297 CLK CLK.n0 158.4
R298 VPB.t14 VPB.t4 777.274
R299 VPB.t3 VPB.t1 604.545
R300 VPB.t2 VPB.t3 604.545
R301 VPB.t15 VPB.t2 604.545
R302 VPB.t6 VPB.t7 604.545
R303 VPB.t11 VPB.t13 604.545
R304 VPB.t12 VPB.t11 604.545
R305 VPB.t0 VPB.t9 518.183
R306 VPB.t10 VPB.t8 518.183
R307 VPB.t9 VPB.t5 431.818
R308 VPB.t8 VPB.t6 431.818
R309 VPB.t13 VPB.t10 345.455
R310 VPB VPB.t12 302.274
R311 VPB.t5 VPB.t15 259.091
R312 VPB.t4 VPB.t0 259.091
R313 VPB.t7 VPB.t14 259.091
R314 VNB.t14 VNB.t6 3600
R315 VNB.t1 VNB.t2 2800
R316 VNB.t0 VNB.t1 2800
R317 VNB.t15 VNB.t0 2800
R318 VNB.t5 VNB.t7 2800
R319 VNB.t3 VNB.t13 2800
R320 VNB.t12 VNB.t3 2800
R321 VNB.t8 VNB.t11 2400
R322 VNB.t10 VNB.t9 2400
R323 VNB.t11 VNB.t4 2000
R324 VNB.t9 VNB.t5 2000
R325 VNB.t13 VNB.t10 1600
R326 VNB VNB.t12 1400
R327 VNB.t4 VNB.t15 1200
R328 VNB.t6 VNB.t8 1200
R329 VNB.t7 VNB.t14 1200
R330 a_2373_36.t0 a_2373_36.t1 104.001
R331 a_2193_36.t0 a_2193_36.t1 200
R332 a_1869_36.t0 a_1869_36.t1 104.001
R333 a_1437_36.t0 a_1437_36.t1 104.001
R334 a_1005_36.t1 a_1005_36.t0 219
R335 a_2193_450.t0 a_2193_450.t1 328.334
R336 a_1869_450.t0 a_1869_450.t1 170.733
R337 a_1005_450.t0 a_1005_450.t1 328.334
R338 a_645_36.n0 a_645_36.t3 47.1434
R339 a_645_36.t1 a_645_36.n0 125.001
R340 a_645_36.n0 a_645_36.n1 907.601
R341 a_645_36.n1 a_645_36.t2 61.0462
R342 a_645_36.n1 a_645_36.t0 164.167
R343 a_2985_36.t0 a_2985_36.n0 259.401
R344 a_2985_36.n0 a_2985_36.n1 177.601
R345 a_2985_36.n1 a_2985_36.t2 204.048
R346 a_2985_36.n1 a_2985_36.t3 247.428
R347 a_2985_36.n0 a_2985_36.t1 681.177
R348 a_1977_36.t0 a_1977_36.n0 321.767
R349 a_1977_36.n0 a_1977_36.t2 85.3672
R350 a_1977_36.n0 a_1977_36.n2 652.201
R351 a_1977_36.n2 a_1977_36.n5 140.8
R352 a_1977_36.n5 a_1977_36.n3 216
R353 a_1977_36.n5 a_1977_36.t4 737.567
R354 a_1977_36.n3 a_1977_36.n4 168.701
R355 a_1977_36.n4 a_1977_36.t7 303.661
R356 a_1977_36.n4 a_1977_36.t5 216.9
R357 a_1977_36.n3 a_1977_36.t6 202.44
R358 a_1977_36.n3 a_1977_36.t8 274.74
R359 a_1977_36.n2 a_1977_36.n1 242.601
R360 a_1977_36.n1 a_1977_36.t1 196
R361 a_1977_36.n1 a_1977_36.t3 52.0005
R362 a_2325_171.t1 a_2325_171.n1 241.133
R363 a_2325_171.n1 a_2325_171.t0 429.526
R364 a_2325_171.n1 a_2325_171.n0 280
R365 a_2325_171.n0 a_2325_171.t2 164.319
R366 a_2325_171.n0 a_2325_171.t3 453.519
R367 a_789_36.n0 a_789_36.t3 245
R368 a_789_36.t1 a_789_36.n0 65.0005
R369 a_789_36.n0 a_789_36.n2 242.601
R370 a_789_36.n4 a_789_36.n3 152
R371 a_789_36.n2 a_789_36.n4 166.4
R372 a_789_36.n4 a_789_36.n5 305.601
R373 a_789_36.n5 a_789_36.t4 251.177
R374 a_789_36.n5 a_789_36.t6 366.856
R375 a_789_36.n3 a_789_36.t5 251.177
R376 a_789_36.n3 a_789_36.t7 366.856
R377 a_789_36.n2 a_789_36.n1 652.201
R378 a_789_36.n1 a_789_36.t2 321.767
R379 a_789_36.n1 a_789_36.t0 85.3672
R380 a_1137_171.t0 a_1137_171.n0 85.3672
R381 a_1137_171.n0 a_1137_171.t2 85.3672
R382 a_1137_171.n0 a_1137_171.n2 823.4
R383 a_1137_171.n2 a_1137_171.n1 213.054
R384 a_1137_171.n1 a_1137_171.t3 164.319
R385 a_1137_171.n1 a_1137_171.t1 453
R386 a_1137_171.n2 a_1137_171.t4 193.337
R387 a_393_36.t0 a_393_36.n0 253
R388 a_393_36.n0 a_393_36.n1 10.305
R389 a_393_36.n1 a_393_36.n2 0.321929
R390 a_393_36.n2 a_393_36.n3 11.3898
R391 a_393_36.n3 a_393_36.t4 424.978
R392 a_393_36.n3 a_393_36.t2 289.005
R393 a_393_36.n2 a_393_36.t3 308.091
R394 a_393_36.n1 a_393_36.t5 680.521
R395 a_393_36.n0 a_393_36.t1 700.376
R396 a_141_36.t1 a_141_36.n4 259.401
R397 a_141_36.n4 a_141_36.n5 177.601
R398 a_141_36.n5 a_141_36.t4 232.968
R399 a_141_36.n5 a_141_36.t7 319.728
R400 a_141_36.n4 a_141_36.n0 12.8005
R401 a_141_36.n0 a_141_36.n2 10.5286
R402 a_141_36.n2 a_141_36.n1 0.563
R403 a_141_36.n1 a_141_36.n3 2.48041
R404 a_141_36.n3 a_141_36.t2 295.56
R405 a_141_36.n3 a_141_36.t5 679.629
R406 a_141_36.n2 a_141_36.t3 375.257
R407 a_141_36.n1 a_141_36.t6 351.471
R408 a_141_36.n0 a_141_36.t0 668.376
C18 Q VNB 0.27176f
C19 VGND VNB 2.17821f
C20 VPWR VNB 1.47258f
C21 SET_B VNB 1.23229f
C22 D VNB 0.19692f
C23 CLK VNB 0.25868f
C24 VPB VNB 4.07649f
C25 a_141_36.t1 VNB 0.08803f
C26 a_141_36.t0 VNB 0.12362f
C27 a_141_36.n0 VNB 0.24661f
C28 a_141_36.t6 VNB 0.07083f
C29 a_141_36.n1 VNB 0.63947f
C30 a_141_36.t3 VNB 0.06928f
C31 a_141_36.n2 VNB 0.72838f
C32 a_141_36.t5 VNB 0.11903f
C33 a_141_36.n3 VNB 0.82252f
C34 a_141_36.t2 VNB 0.06815f
C35 a_141_36.n4 VNB 0.41127f
C36 a_141_36.t7 VNB 0.05281f
C37 a_141_36.t4 VNB 0.03492f
C38 a_141_36.n5 VNB 0.18001f
C39 a_393_36.t0 VNB 0.09283f
C40 a_393_36.t1 VNB 0.15034f
C41 a_393_36.n0 VNB 0.56695f
C42 a_393_36.t5 VNB 0.13199f
C43 a_393_36.n1 VNB 0.61579f
C44 a_393_36.t3 VNB 0.07171f
C45 a_393_36.n2 VNB 0.87557f
C46 a_393_36.n3 VNB 0.52462f
C47 a_393_36.t2 VNB 0.0594f
C48 a_393_36.t4 VNB 0.14902f
C49 a_1137_171.t0 VNB 0.02336f
C50 a_1137_171.n0 VNB 0.15402f
C51 a_1137_171.t4 VNB 0.02887f
C52 a_1137_171.n1 VNB 0.24682f
C53 a_1137_171.t1 VNB 0.19403f
C54 a_1137_171.t3 VNB 0.02514f
C55 a_1137_171.n2 VNB 0.43156f
C56 a_1137_171.t2 VNB 0.02336f
C57 a_789_36.t1 VNB 0.02145f
C58 a_789_36.n0 VNB 0.12894f
C59 a_789_36.t2 VNB 0.10106f
C60 a_789_36.t0 VNB 0.02681f
C61 a_789_36.n1 VNB 0.14157f
C62 a_789_36.n2 VNB 0.44477f
C63 a_789_36.t7 VNB 0.05721f
C64 a_789_36.t5 VNB 0.04106f
C65 a_789_36.n3 VNB 0.12394f
C66 a_789_36.n4 VNB 0.28187f
C67 a_789_36.t6 VNB 0.05721f
C68 a_789_36.t4 VNB 0.04106f
C69 a_789_36.n5 VNB 0.17867f
C70 a_789_36.t3 VNB 0.08085f
C71 a_2325_171.t1 VNB 0.09038f
C72 a_2325_171.t3 VNB 0.05563f
C73 a_2325_171.t2 VNB 0.02317f
C74 a_2325_171.n0 VNB 0.16555f
C75 a_2325_171.n1 VNB 0.49581f
C76 a_2325_171.t0 VNB 0.17313f
C77 a_1977_36.t0 VNB 0.07573f
C78 a_1977_36.n0 VNB 0.10609f
C79 a_1977_36.t1 VNB 0.07573f
C80 a_1977_36.t3 VNB 0.02009f
C81 a_1977_36.n1 VNB 0.11579f
C82 a_1977_36.n2 VNB 0.31845f
C83 a_1977_36.t8 VNB 0.04482f
C84 a_1977_36.t6 VNB 0.02782f
C85 a_1977_36.n3 VNB 0.18591f
C86 a_1977_36.t5 VNB 0.02627f
C87 a_1977_36.t7 VNB 0.04173f
C88 a_1977_36.n4 VNB 0.17434f
C89 a_1977_36.t4 VNB 0.07973f
C90 a_1977_36.n5 VNB 0.27808f
C91 a_1977_36.t2 VNB 0.02009f
C92 a_2985_36.t0 VNB 0.05411f
C93 a_2985_36.t1 VNB 0.07849f
C94 a_2985_36.n0 VNB 0.38326f
C95 a_2985_36.t3 VNB 0.03832f
C96 a_2985_36.t2 VNB 0.02387f
C97 a_2985_36.n1 VNB 0.1024f
C98 a_645_36.t1 VNB 0.02783f
C99 a_645_36.n0 VNB 0.22853f
C100 a_645_36.t2 VNB 0.0443f
C101 a_645_36.t0 VNB 0.03479f
C102 a_645_36.n1 VNB 0.13431f
C103 a_645_36.t3 VNB 0.03401f
C104 a_1005_450.t0 VNB 0.02078f
C105 a_1005_450.t1 VNB 0.02078f
C106 a_1869_450.t0 VNB 0.0095f
C107 a_1869_450.t1 VNB 0.0095f
C108 a_2193_450.t0 VNB 0.02074f
C109 a_2193_450.t1 VNB 0.02074f
C110 a_1005_36.t1 VNB 0.01755f
C111 a_1005_36.t0 VNB 0.02166f
C112 a_1437_36.t0 VNB 0.01152f
C113 a_1437_36.t1 VNB 0.01152f
C114 a_1869_36.t0 VNB 0.0095f
C115 a_1869_36.t1 VNB 0.0095f
C116 a_2193_36.t0 VNB 0.01852f
C117 a_2193_36.t1 VNB 0.01852f
C118 a_2373_36.t0 VNB 0.00991f
C119 a_2373_36.t1 VNB 0.00991f
C120 VPB.t1 VNB 0.25736f
C121 VPB.t3 VNB 0.22519f
C122 VPB.t2 VNB 0.22519f
C123 VPB.t15 VNB 0.16085f
C124 VPB.t5 VNB 0.12868f
C125 VPB.t9 VNB 0.17693f
C126 VPB.t0 VNB 0.14477f
C127 VPB.t4 VNB 0.19302f
C128 VPB.t14 VNB 0.19302f
C129 VPB.t7 VNB 0.16085f
C130 VPB.t6 VNB 0.19302f
C131 VPB.t8 VNB 0.17693f
C132 VPB.t10 VNB 0.16085f
C133 VPB.t13 VNB 0.17693f
C134 VPB.t11 VNB 0.22519f
C135 VPB.t12 VNB 0.16889f
C136 CLK.t1 VNB 0.04658f
C137 CLK.t0 VNB 0.0308f
C138 CLK.n0 VNB 0.14723f
C139 D.t1 VNB 0.05557f
C140 D.t0 VNB 0.05125f
C141 D.n0 VNB 0.17848f
C142 SET_B.t2 VNB 0.03848f
C143 SET_B.t0 VNB 0.07589f
C144 SET_B.n0 VNB 0.38263f
C145 SET_B.t3 VNB 0.03683f
C146 SET_B.t1 VNB 0.07381f
C147 SET_B.n1 VNB 0.20986f
C148 VPWR.n0 VNB 0.24328f
C149 VPWR.t6 VNB 0.03457f
C150 VPWR.n1 VNB 0.01492f
C151 VPWR.n2 VNB 0.03978f
C152 VPWR.t5 VNB 0.04419f
C153 VPWR.n3 VNB 0.06708f
C154 VPWR.t1 VNB 0.00673f
C155 VPWR.t8 VNB 0.00673f
C156 VPWR.n4 VNB 0.014f
C157 VPWR.n5 VNB 0.05417f
C158 VPWR.n6 VNB 0.03978f
C159 VPWR.n7 VNB 0.01989f
C160 VPWR.n8 VNB 0.03978f
C161 VPWR.n9 VNB 0.01492f
C162 VPWR.n10 VNB 0.03978f
C163 VPWR.t7 VNB 0.02397f
C164 VPWR.n11 VNB 0.04668f
C165 VPWR.t3 VNB 0.02397f
C166 VPWR.n12 VNB 0.04668f
C167 VPWR.n13 VNB 0.03978f
C168 VPWR.t10 VNB 0.02397f
C169 VPWR.n14 VNB 0.04668f
C170 VPWR.n15 VNB 0.03978f
C171 VPWR.t9 VNB 0.02397f
C172 VPWR.n16 VNB 0.01989f
C173 VPWR.n17 VNB 0.03978f
C174 VPWR.n18 VNB 0.01989f
C175 VPWR.n19 VNB 0.03978f
C176 VPWR.t0 VNB 0.04419f
C177 VPWR.n20 VNB 0.06708f
C178 VPWR.n21 VNB 0.03978f
C179 VPWR.t11 VNB 0.03457f
C180 VPWR.n22 VNB 0.06634f
C181 VPWR.n23 VNB 0.03978f
C182 VPWR.t2 VNB 0.03457f
C183 VPWR.n24 VNB 0.06523f
C184 VPWR.n25 VNB 0.03592f
C185 VPWR.n26 VNB 0.03978f
C186 VPWR.n27 VNB 0.01492f
C187 VPWR.n28 VNB 0.01989f
C188 VPWR.n29 VNB 0.01989f
C189 VPWR.n30 VNB 0.03978f
C190 VPWR.n31 VNB 0.03978f
C191 VPWR.n32 VNB 0.03978f
C192 VPWR.n33 VNB 0.01989f
C193 VPWR.n34 VNB 0.01989f
C194 VPWR.n35 VNB 0.01492f
C195 VPWR.n36 VNB 0.03978f
C196 VPWR.n37 VNB 0.03978f
C197 VPWR.n38 VNB 0.01492f
C198 VPWR.n39 VNB 0.01989f
C199 VPWR.n40 VNB 0.01989f
C200 VPWR.n41 VNB 0.03978f
C201 VPWR.n42 VNB 0.03978f
C202 VPWR.n43 VNB 0.03978f
C203 VPWR.n44 VNB 0.01989f
C204 VPWR.n45 VNB 0.01989f
C205 VPWR.n46 VNB 0.01989f
C206 VPWR.n47 VNB 0.03978f
C207 VPWR.n48 VNB 0.03978f
C208 VPWR.n49 VNB 0.03978f
C209 VPWR.n50 VNB 0.01492f
C210 VPWR.n51 VNB 0.04668f
C211 VPWR.n52 VNB 0.01492f
C212 VPWR.n53 VNB 0.01492f
C213 VPWR.n54 VNB 0.03978f
C214 VPWR.n55 VNB 0.03978f
C215 VPWR.n56 VNB 0.01492f
C216 VPWR.n57 VNB 0.01989f
C217 VPWR.n58 VNB 0.01492f
C218 VPWR.n59 VNB 0.03978f
C219 VPWR.n60 VNB 0.03978f
C220 VPWR.n61 VNB 0.01492f
C221 VPWR.n62 VNB 0.01989f
C222 VPWR.n63 VNB 0.01492f
C223 VPWR.n64 VNB 0.03978f
C224 VPWR.n65 VNB 0.03978f
C225 VPWR.n66 VNB 0.03978f
C226 VPWR.n67 VNB 0.01989f
C227 VPWR.n68 VNB 0.01989f
C228 VPWR.n69 VNB 0.01989f
C229 VPWR.n70 VNB 0.03978f
C230 VPWR.n71 VNB 0.03978f
C231 VPWR.n72 VNB 0.03978f
C232 VPWR.n73 VNB 0.01989f
C233 VPWR.n74 VNB 0.01989f
C234 VPWR.n75 VNB 0.01989f
C235 VPWR.n76 VNB 0.03978f
C236 VPWR.n77 VNB 0.03978f
C237 VPWR.n78 VNB 0.03978f
C238 VPWR.n79 VNB 0.01989f
C239 VPWR.n80 VNB 0.01989f
C240 VPWR.n81 VNB 0.01492f
C241 VPWR.n82 VNB 0.03978f
C242 VPWR.n83 VNB 0.03978f
C243 VPWR.n84 VNB 0.03978f
C244 VPWR.n85 VNB 0.01989f
C245 VPWR.n86 VNB 0.01989f
C246 VPWR.n87 VNB 0.07441f
C247 VPWR.n88 VNB 0.19433f
C248 VPWR.t4 VNB 0.05717f
C249 VPWR.n89 VNB 0.04912f
C250 VGND.t2 VNB 0.02351f
C251 VGND.n0 VNB 0.17389f
C252 VGND.t1 VNB 0.01671f
C253 VGND.n1 VNB 0.01066f
C254 VGND.n2 VNB 0.02843f
C255 VGND.t0 VNB 0.02001f
C256 VGND.n3 VNB 0.03063f
C257 VGND.t5 VNB 0.01639f
C258 VGND.n4 VNB 0.01422f
C259 VGND.n5 VNB 0.02843f
C260 VGND.n6 VNB 0.01422f
C261 VGND.n7 VNB 0.02843f
C262 VGND.n8 VNB 0.01066f
C263 VGND.n9 VNB 0.02843f
C264 VGND.t9 VNB 0.01671f
C265 VGND.n10 VNB 0.03379f
C266 VGND.t6 VNB 0.01671f
C267 VGND.n11 VNB 0.03379f
C268 VGND.n12 VNB 0.02843f
C269 VGND.n13 VNB 0.01422f
C270 VGND.n14 VNB 0.02843f
C271 VGND.t8 VNB 0.01639f
C272 VGND.n15 VNB 0.01422f
C273 VGND.n16 VNB 0.02843f
C274 VGND.n17 VNB 0.01422f
C275 VGND.n18 VNB 0.02843f
C276 VGND.t3 VNB 0.02466f
C277 VGND.n19 VNB 0.01422f
C278 VGND.n20 VNB 0.02843f
C279 VGND.t7 VNB 0.01671f
C280 VGND.n21 VNB 0.01422f
C281 VGND.n22 VNB 0.02567f
C282 VGND.t4 VNB 0.01671f
C283 VGND.n23 VNB 0.04011f
C284 VGND.n24 VNB 0.01066f
C285 VGND.n25 VNB 0.02843f
C286 VGND.n26 VNB 0.02843f
C287 VGND.n27 VNB 0.02843f
C288 VGND.n28 VNB 0.01422f
C289 VGND.n29 VNB 0.0409f
C290 VGND.n30 VNB 0.01422f
C291 VGND.n31 VNB 0.02843f
C292 VGND.n32 VNB 0.02843f
C293 VGND.n33 VNB 0.02843f
C294 VGND.n34 VNB 0.01066f
C295 VGND.n35 VNB 0.04035f
C296 VGND.n36 VNB 0.01066f
C297 VGND.n37 VNB 0.01422f
C298 VGND.n38 VNB 0.02843f
C299 VGND.n39 VNB 0.02843f
C300 VGND.n40 VNB 0.02843f
C301 VGND.n41 VNB 0.01422f
C302 VGND.n42 VNB 0.01422f
C303 VGND.n43 VNB 0.01422f
C304 VGND.n44 VNB 0.02843f
C305 VGND.n45 VNB 0.02843f
C306 VGND.n46 VNB 0.02843f
C307 VGND.n47 VNB 0.01422f
C308 VGND.n48 VNB 0.01066f
C309 VGND.n49 VNB 0.03056f
C310 VGND.n50 VNB 0.01066f
C311 VGND.n51 VNB 0.02843f
C312 VGND.n52 VNB 0.02843f
C313 VGND.n53 VNB 0.02843f
C314 VGND.n54 VNB 0.01422f
C315 VGND.n55 VNB 0.01422f
C316 VGND.n56 VNB 0.01066f
C317 VGND.n57 VNB 0.02843f
C318 VGND.n58 VNB 0.02843f
C319 VGND.n59 VNB 0.01066f
C320 VGND.n60 VNB 0.01422f
C321 VGND.n61 VNB 0.01066f
C322 VGND.n62 VNB 0.02843f
C323 VGND.n63 VNB 0.02843f
C324 VGND.n64 VNB 0.02843f
C325 VGND.n65 VNB 0.01422f
C326 VGND.n66 VNB 0.01422f
C327 VGND.n67 VNB 0.01422f
C328 VGND.n68 VNB 0.02843f
C329 VGND.n69 VNB 0.02843f
C330 VGND.n70 VNB 0.02843f
C331 VGND.n71 VNB 0.01422f
C332 VGND.n72 VNB 0.01422f
C333 VGND.n73 VNB 0.01422f
C334 VGND.n74 VNB 0.02843f
C335 VGND.n75 VNB 0.02843f
C336 VGND.n76 VNB 0.02843f
C337 VGND.n77 VNB 0.01066f
C338 VGND.n78 VNB 0.03056f
C339 VGND.n79 VNB 0.01066f
C340 VGND.n80 VNB 0.01066f
C341 VGND.n81 VNB 0.02843f
C342 VGND.n82 VNB 0.02843f
C343 VGND.n83 VNB 0.02843f
C344 VGND.n84 VNB 0.01422f
C345 VGND.n85 VNB 0.01422f
C346 VGND.n86 VNB 0.04667f
C347 VGND.n87 VNB 0.12507f
C348 Q.t0 VNB 0.08174f
C349 Q.t1 VNB 0.04374f
C350 Q.n0 VNB 0.03699f
.ends

.subckt sky130_efx_lvdig__dfstp_2 CLK D SET_B Q VGND VNB VPB VPWR
X0 a_1137_171.t1 a_789_36.t7 VPWR.t2 VPB.t1 sky130_fd_pr__pfet_01v8_hvt ad=0.08775 pd=0.84 as=0.16875 ps=1.65 w=0.45 l=0.15
X1 nmos_n3f5_f1_l150_0.D0.t1 a_1977_36.t5 VGND.t8 VNB.t5 sky130_fd_pr__nfet_01v8 ad=0.23625 pd=2.01 as=0.23625 ps=2.01 w=0.63 l=0.15
X2 a_141_36.t0 CLK.t1 VPWR.t0 VPB.t10 sky130_fd_pr__pfet_01v8_hvt ad=0.23625 pd=2.01 as=0.23625 ps=2.01 w=0.63 l=0.15
X3 a_645_36.t2 D.t0 VGND.t6 VNB.t15 sky130_fd_pr__nfet_01v8 ad=0.13702 pd=1.2 as=0.23625 ps=2.01 w=0.63 l=0.15
X4 a_789_36.t0 a_393_36.t5 a_645_36.t0 VPB.t8 sky130_fd_pr__pfet_01v8_hvt ad=0.20925 pd=1.38 as=0.17415 ps=1.38 w=0.45 l=0.15
X5 VPWR.t10 SET_B.t3 a_1137_171.t0 VPB.t11 sky130_fd_pr__pfet_01v8_hvt ad=0.16875 pd=1.65 as=0.08775 ps=0.84 w=0.45 l=0.15
X6 a_1869_36.t0 a_789_36.t4 VGND.t9 VNB.t6 sky130_fd_pr__nfet_01v8 ad=0.08775 pd=0.84 as=0.16875 ps=1.65 w=0.45 l=0.15
X7 a_1977_36.t0 a_393_36.t2 a_1869_36.t1 VNB.t8 sky130_fd_pr__nfet_01v8 ad=0.20925 pd=1.38 as=0.08775 ps=0.84 w=0.45 l=0.15
X8 a_645_36.t1 D.t1 VPWR.t6 VPB.t14 sky130_fd_pr__pfet_01v8_hvt ad=0.17415 pd=1.38 as=0.30375 ps=2.37 w=0.81 l=0.15
X9 nmos_n3f5_f1_l150_0.D0.t0 a_1977_36.t7 VPWR.t3 VPB.t2 sky130_fd_pr__pfet_01v8_hvt ad=0.405 pd=2.91 as=0.405 ps=2.91 w=1.08 l=0.15
X10 VPWR.t4 a_1137_171.t4 a_1005_450.t0 VPB.t3 sky130_fd_pr__pfet_01v8_hvt ad=0.16875 pd=1.65 as=0.16875 ps=1.2 w=0.45 l=0.15
X11 a_1005_450.t1 a_141_36.t6 a_789_36.t3 VPB.t16 sky130_fd_pr__pfet_01v8_hvt ad=0.16875 pd=1.2 as=0.20925 ps=1.38 w=0.45 l=0.15
X12 VPWR.t8 a_2325_171.t3 a_2193_450.t0 VPB.t6 sky130_fd_pr__pfet_01v8_hvt ad=0.08775 pd=0.84 as=0.16875 ps=1.2 w=0.45 l=0.15
X13 a_2193_36.t1 a_141_36.t2 a_1977_36.t2 VNB.t12 sky130_fd_pr__nfet_01v8 ad=0.16875 pd=1.2 as=0.20925 ps=1.38 w=0.45 l=0.15
X14 a_1005_36.t1 a_393_36.t3 a_789_36.t1 VNB.t10 sky130_fd_pr__special_nfet_01v8 ad=0.15593 pd=1.2 as=0.1674 ps=1.29 w=0.36 l=0.15
X15 VGND.t4 a_1137_171.t3 a_1005_36.t0 VNB.t3 sky130_fd_pr__nfet_01v8 ad=0.16875 pd=1.65 as=0.15593 ps=1.2 w=0.45 l=0.15
X16 a_1869_450.t0 a_789_36.t6 VPWR.t11 VPB.t7 sky130_fd_pr__pfet_01v8_hvt ad=0.08775 pd=0.84 as=0.16875 ps=1.65 w=0.45 l=0.15
X17 a_2193_450.t1 a_393_36.t4 a_1977_36.t1 VPB.t9 sky130_fd_pr__pfet_01v8_hvt ad=0.16875 pd=1.2 as=0.20925 ps=1.38 w=0.45 l=0.15
X18 a_1977_36.t3 SET_B.t2 VPWR.t9 VPB.t12 sky130_fd_pr__pfet_01v8_hvt ad=0.16875 pd=1.65 as=0.08775 ps=0.84 w=0.45 l=0.15
X19 a_789_36.t2 a_141_36.t3 a_645_36.t3 VNB.t16 sky130_fd_pr__special_nfet_01v8 ad=0.1674 pd=1.29 as=0.13702 ps=1.2 w=0.36 l=0.15
X20 a_141_36.t1 CLK.t0 VGND.t7 VNB.t11 sky130_fd_pr__nfet_01v8 ad=0.16875 pd=1.65 as=0.16875 ps=1.65 w=0.45 l=0.15
X21 a_2373_36.t0 a_2325_171.t2 a_2193_36.t0 VNB.t0 sky130_fd_pr__nfet_01v8 ad=0.08775 pd=0.84 as=0.16875 ps=1.2 w=0.45 l=0.15
X22 VGND.t0 SET_B.t0 a_2373_36.t1 VNB.t14 sky130_fd_pr__nfet_01v8 ad=0.16875 pd=1.65 as=0.08775 ps=0.84 w=0.45 l=0.15
X23 a_1977_36.t4 a_141_36.t5 a_1869_450.t1 VPB.t15 sky130_fd_pr__pfet_01v8_hvt ad=0.20925 pd=1.38 as=0.08775 ps=0.84 w=0.45 l=0.15
X24 a_393_36.t1 a_141_36.t7 VPWR.t12 VPB.t13 sky130_fd_pr__pfet_01v8_hvt ad=0.23625 pd=2.01 as=0.23625 ps=2.01 w=0.63 l=0.15
X25 a_2325_171.t0 a_1977_36.t8 VPWR.t5 VPB.t4 sky130_fd_pr__pfet_01v8_hvt ad=0.30375 pd=2.37 as=0.30375 ps=2.37 w=0.81 l=0.15
X26 Q.t0 nmos_n3f5_f1_l150_0.D0.t3 VGND.t1 VNB.t1 sky130_fd_pr__nfet_01v8 ad=0.12285 pd=1.02 as=0.23625 ps=2.01 w=0.63 l=0.15
X27 VGND.t3 nmos_n3f5_f1_l150_0.D0.t2 Q.t2 VNB.t2 sky130_fd_pr__nfet_01v8 ad=0.23625 pd=2.01 as=0.12285 ps=1.02 w=0.63 l=0.15
X28 a_1437_36.t0 a_789_36.t5 a_1137_171.t2 VNB.t7 sky130_fd_pr__nfet_01v8 ad=0.08775 pd=0.84 as=0.16875 ps=1.65 w=0.45 l=0.15
X29 VGND.t2 SET_B.t1 a_1437_36.t1 VNB.t13 sky130_fd_pr__nfet_01v8 ad=0.16875 pd=1.65 as=0.08775 ps=0.84 w=0.45 l=0.15
X30 Q.t1 nmos_n3f5_f1_l150_0.D0.t5 VPWR.t1 VPB.t0 sky130_fd_pr__pfet_01v8_hvt ad=0.2106 pd=1.47 as=0.405 ps=2.91 w=1.08 l=0.15
X31 a_2325_171.t1 a_1977_36.t6 VGND.t5 VNB.t4 sky130_fd_pr__nfet_01v8 ad=0.2025 pd=1.83 as=0.2025 ps=1.83 w=0.54 l=0.15
X32 a_393_36.t0 a_141_36.t4 VGND.t10 VNB.t9 sky130_fd_pr__nfet_01v8 ad=0.16875 pd=1.65 as=0.16875 ps=1.65 w=0.45 l=0.15
X33 VPWR.t7 nmos_n3f5_f1_l150_0.D0.t4 Q.t3 VPB.t5 sky130_fd_pr__pfet_01v8_hvt ad=0.405 pd=2.91 as=0.2106 ps=1.47 w=1.08 l=0.15
C0 VGND VPB 0.04497f
C1 nmos_n3f5_f1_l150_0.D0 VPB 0.12483f
C2 VPB D 0.08736f
C3 VGND Q 0.15357f
C4 VPB CLK 0.09785f
C5 nmos_n3f5_f1_l150_0.D0 Q 0.1198f
C6 VGND SET_B 0.06773f
C7 nmos_n3f5_f1_l150_0.D0 SET_B 0.00143f
C10 VGND VPWR 0.15021f
C11 nmos_n3f5_f1_l150_0.D0 VPWR 0.29706f
C12 VPB Q 0.00762f
C13 D VPWR 0.0516f
C14 CLK VPWR 0.04196f
C15 VPB SET_B 0.31395f
C17 VPB VPWR 0.75738f
C18 Q VPWR 0.22627f
C19 VGND nmos_n3f5_f1_l150_0.D0 0.22602f
C20 SET_B VPWR 0.58108f
C21 VGND D 0.04181f
C22 VGND CLK 0.04537f
R0 Q Q.n0 308.5
R1 Q Q.n1 204.201
R2 Q.n1 Q.t2 37.1434
R3 Q.n1 Q.t0 37.1434
R4 Q.n0 Q.t3 35.5699
R5 Q.n0 Q.t1 35.5699
R6 VGND.n27 VGND.t10 253
R7 VGND.n70 VGND.t9 253
R8 VGND.n64 VGND.t2 253
R9 VGND.n29 VGND.t7 253
R10 VGND.n12 VGND.t0 249.8
R11 VGND.n56 VGND.t4 249.8
R12 VGND.n3 VGND.t3 247.951
R13 VGND.n4 VGND.t1 241.344
R14 VGND.n25 VGND.t6 241.344
R15 VGND.n89 VGND.t5 241.133
R16 VGND VGND.t8 231.744
R17 VGND.n30 VGND.n29 15.7005
R18 VGND.n6 VGND.n5 12.8005
R19 VGND.n6 VGND.n0 12.8005
R20 VGND.n95 VGND.n0 12.8005
R21 VGND.n95 VGND.n1 12.8005
R22 VGND.n91 VGND.n1 12.8005
R23 VGND.n91 VGND.n90 12.8005
R24 VGND.n88 VGND.n10 12.8005
R25 VGND.n84 VGND.n83 12.8005
R26 VGND.n83 VGND.n82 12.8005
R27 VGND.n82 VGND.n13 12.8005
R28 VGND.n78 VGND.n13 12.8005
R29 VGND.n78 VGND.n77 12.8005
R30 VGND.n77 VGND.n76 12.8005
R31 VGND.n76 VGND.n15 12.8005
R32 VGND.n72 VGND.n15 12.8005
R33 VGND.n72 VGND.n71 12.8005
R34 VGND.n69 VGND.n17 12.8005
R35 VGND.n65 VGND.n17 12.8005
R36 VGND.n63 VGND.n62 12.8005
R37 VGND.n62 VGND.n19 12.8005
R38 VGND.n58 VGND.n19 12.8005
R39 VGND.n58 VGND.n57 12.8005
R40 VGND.n55 VGND.n21 12.8005
R41 VGND.n51 VGND.n21 12.8005
R42 VGND.n51 VGND.n50 12.8005
R43 VGND.n50 VGND.n49 12.8005
R44 VGND.n49 VGND.n23 12.8005
R45 VGND.n45 VGND.n23 12.8005
R46 VGND.n45 VGND.n44 12.8005
R47 VGND.n44 VGND.n43 12.8005
R48 VGND.n40 VGND.n39 12.8005
R49 VGND.n39 VGND.n38 12.8005
R50 VGND.n38 VGND.n27 12.8005
R51 VGND.n34 VGND.n27 12.8005
R52 VGND.n34 VGND.n33 12.8005
R53 VGND.n33 VGND.n32 12.8005
R54 VGND.n4 VGND.n3 12.1406
R55 VGND VGND.n95 9.6005
R56 VGND.n32 VGND.n31 9.3005
R57 VGND.n33 VGND.n28 9.3005
R58 VGND.n35 VGND.n34 9.3005
R59 VGND.n36 VGND.n27 9.3005
R60 VGND.n38 VGND.n37 9.3005
R61 VGND.n39 VGND.n26 9.3005
R62 VGND.n41 VGND.n40 9.3005
R63 VGND.n43 VGND.n42 9.3005
R64 VGND.n44 VGND.n24 9.3005
R65 VGND.n46 VGND.n45 9.3005
R66 VGND.n47 VGND.n23 9.3005
R67 VGND.n49 VGND.n48 9.3005
R68 VGND.n50 VGND.n22 9.3005
R69 VGND.n52 VGND.n51 9.3005
R70 VGND.n53 VGND.n21 9.3005
R71 VGND.n55 VGND.n54 9.3005
R72 VGND.n57 VGND.n20 9.3005
R73 VGND.n59 VGND.n58 9.3005
R74 VGND.n60 VGND.n19 9.3005
R75 VGND.n62 VGND.n61 9.3005
R76 VGND.n63 VGND.n18 9.3005
R77 VGND.n66 VGND.n65 9.3005
R78 VGND.n67 VGND.n17 9.3005
R79 VGND.n69 VGND.n68 9.3005
R80 VGND.n71 VGND.n16 9.3005
R81 VGND.n73 VGND.n72 9.3005
R82 VGND.n74 VGND.n15 9.3005
R83 VGND.n76 VGND.n75 9.3005
R84 VGND.n77 VGND.n14 9.3005
R85 VGND.n79 VGND.n78 9.3005
R86 VGND.n80 VGND.n13 9.3005
R87 VGND.n82 VGND.n81 9.3005
R88 VGND.n83 VGND.n11 9.3005
R89 VGND.n85 VGND.n84 9.3005
R90 VGND.n86 VGND.n10 9.3005
R91 VGND.n88 VGND.n87 9.3005
R92 VGND.n90 VGND.n9 9.3005
R93 VGND.n92 VGND.n91 9.3005
R94 VGND.n93 VGND.n1 9.3005
R95 VGND.n95 VGND.n94 9.3005
R96 VGND.n8 VGND.n0 9.3005
R97 VGND.n7 VGND.n6 9.3005
R98 VGND.n5 VGND.n2 9.3005
R99 VGND.n5 VGND.n4 6.4005
R100 VGND.n90 VGND.n89 6.4005
R101 VGND.n89 VGND.n88 6.4005
R102 VGND.n12 VGND.n10 6.4005
R103 VGND.n84 VGND.n12 6.4005
R104 VGND.n71 VGND.n70 6.4005
R105 VGND.n70 VGND.n69 6.4005
R106 VGND.n65 VGND.n64 6.4005
R107 VGND.n64 VGND.n63 6.4005
R108 VGND.n57 VGND.n56 6.4005
R109 VGND.n56 VGND.n55 6.4005
R110 VGND.n43 VGND.n25 6.4005
R111 VGND.n40 VGND.n25 6.4005
R112 VGND.n32 VGND.n29 6.4005
R113 VGND.n3 VGND.n2 0.584022
R114 VGND.n7 VGND.n2 0.063
R115 VGND.n8 VGND.n7 0.063
R116 VGND.n94 VGND.n8 0.063
R117 VGND.n94 VGND.n93 0.063
R118 VGND.n93 VGND.n92 0.063
R119 VGND.n92 VGND.n9 0.063
R120 VGND.n87 VGND.n9 0.063
R121 VGND.n87 VGND.n86 0.063
R122 VGND.n86 VGND.n85 0.063
R123 VGND.n85 VGND.n11 0.063
R124 VGND.n81 VGND.n11 0.063
R125 VGND.n81 VGND.n80 0.063
R126 VGND.n80 VGND.n79 0.063
R127 VGND.n79 VGND.n14 0.063
R128 VGND.n75 VGND.n14 0.063
R129 VGND.n75 VGND.n74 0.063
R130 VGND.n74 VGND.n73 0.063
R131 VGND.n73 VGND.n16 0.063
R132 VGND.n68 VGND.n16 0.063
R133 VGND.n68 VGND.n67 0.063
R134 VGND.n67 VGND.n66 0.063
R135 VGND.n66 VGND.n18 0.063
R136 VGND.n61 VGND.n18 0.063
R137 VGND.n61 VGND.n60 0.063
R138 VGND.n60 VGND.n59 0.063
R139 VGND.n59 VGND.n20 0.063
R140 VGND.n54 VGND.n20 0.063
R141 VGND.n54 VGND.n53 0.063
R142 VGND.n53 VGND.n52 0.063
R143 VGND.n52 VGND.n22 0.063
R144 VGND.n48 VGND.n22 0.063
R145 VGND.n48 VGND.n47 0.063
R146 VGND.n47 VGND.n46 0.063
R147 VGND.n46 VGND.n24 0.063
R148 VGND.n42 VGND.n24 0.063
R149 VGND.n42 VGND.n41 0.063
R150 VGND.n41 VGND.n26 0.063
R151 VGND.n37 VGND.n26 0.063
R152 VGND.n37 VGND.n36 0.063
R153 VGND.n36 VGND.n35 0.063
R154 VGND.n35 VGND.n28 0.063
R155 VGND.n31 VGND.n28 0.063
R156 VGND.n31 VGND.n30 0.063
R157 VGND.n30 VGND 0.03175
R158 VPWR.n55 VPWR.t4 683.168
R159 VPWR.n18 VPWR.t2 683.168
R160 VPWR.n16 VPWR.t10 683.168
R161 VPWR.n15 VPWR.t11 683.168
R162 VPWR.n26 VPWR.t12 661.976
R163 VPWR.n28 VPWR.t0 661.976
R164 VPWR.n9 VPWR.n8 597.801
R165 VPWR.n24 VPWR.t6 359.127
R166 VPWR.n7 VPWR.t5 359.127
R167 VPWR.n4 VPWR.t3 328.07
R168 VPWR.n1 VPWR.t1 328.07
R169 VPWR.n99 VPWR.t7 328.07
R170 VPWR.n8 VPWR.t9 85.3672
R171 VPWR.n8 VPWR.t8 85.3672
R172 VPWR.n99 VPWR.n98 32.2074
R173 VPWR.n91 VPWR.n4 25.6005
R174 VPWR.n97 VPWR.n1 25.6005
R175 VPWR.n4 VPWR 16.0005
R176 VPWR.n1 VPWR 16.0005
R177 VPWR VPWR.n99 16.0005
R178 VPWR.n29 VPWR.n28 15.7005
R179 VPWR.n96 VPWR.n95 12.8005
R180 VPWR.n95 VPWR.n2 12.8005
R181 VPWR.n91 VPWR.n2 12.8005
R182 VPWR.n91 VPWR.n90 12.8005
R183 VPWR.n90 VPWR.n89 12.8005
R184 VPWR.n89 VPWR.n5 12.8005
R185 VPWR.n85 VPWR.n84 12.8005
R186 VPWR.n84 VPWR.n83 12.8005
R187 VPWR.n83 VPWR.n9 12.8005
R188 VPWR.n79 VPWR.n9 12.8005
R189 VPWR.n79 VPWR.n78 12.8005
R190 VPWR.n78 VPWR.n77 12.8005
R191 VPWR.n77 VPWR.n11 12.8005
R192 VPWR.n73 VPWR.n11 12.8005
R193 VPWR.n73 VPWR.n72 12.8005
R194 VPWR.n72 VPWR.n71 12.8005
R195 VPWR.n71 VPWR.n13 12.8005
R196 VPWR.n67 VPWR.n66 12.8005
R197 VPWR.n66 VPWR.n65 12.8005
R198 VPWR.n62 VPWR.n61 12.8005
R199 VPWR.n61 VPWR.n60 12.8005
R200 VPWR.n57 VPWR.n56 12.8005
R201 VPWR.n54 VPWR.n20 12.8005
R202 VPWR.n50 VPWR.n20 12.8005
R203 VPWR.n50 VPWR.n49 12.8005
R204 VPWR.n49 VPWR.n48 12.8005
R205 VPWR.n48 VPWR.n22 12.8005
R206 VPWR.n44 VPWR.n22 12.8005
R207 VPWR.n44 VPWR.n43 12.8005
R208 VPWR.n43 VPWR.n42 12.8005
R209 VPWR.n39 VPWR.n38 12.8005
R210 VPWR.n38 VPWR.n37 12.8005
R211 VPWR.n37 VPWR.n26 12.8005
R212 VPWR.n33 VPWR.n26 12.8005
R213 VPWR.n33 VPWR.n32 12.8005
R214 VPWR.n32 VPWR.n31 12.8005
R215 VPWR.n98 VPWR.n97 12.1406
R216 VPWR.n31 VPWR.n30 9.3005
R217 VPWR.n32 VPWR.n27 9.3005
R218 VPWR.n34 VPWR.n33 9.3005
R219 VPWR.n35 VPWR.n26 9.3005
R220 VPWR.n37 VPWR.n36 9.3005
R221 VPWR.n38 VPWR.n25 9.3005
R222 VPWR.n40 VPWR.n39 9.3005
R223 VPWR.n42 VPWR.n41 9.3005
R224 VPWR.n43 VPWR.n23 9.3005
R225 VPWR.n45 VPWR.n44 9.3005
R226 VPWR.n46 VPWR.n22 9.3005
R227 VPWR.n48 VPWR.n47 9.3005
R228 VPWR.n49 VPWR.n21 9.3005
R229 VPWR.n51 VPWR.n50 9.3005
R230 VPWR.n52 VPWR.n20 9.3005
R231 VPWR.n54 VPWR.n53 9.3005
R232 VPWR.n56 VPWR.n19 9.3005
R233 VPWR.n58 VPWR.n57 9.3005
R234 VPWR.n60 VPWR.n59 9.3005
R235 VPWR.n61 VPWR.n17 9.3005
R236 VPWR.n63 VPWR.n62 9.3005
R237 VPWR.n65 VPWR.n64 9.3005
R238 VPWR.n66 VPWR.n14 9.3005
R239 VPWR.n68 VPWR.n67 9.3005
R240 VPWR.n69 VPWR.n13 9.3005
R241 VPWR.n71 VPWR.n70 9.3005
R242 VPWR.n72 VPWR.n12 9.3005
R243 VPWR.n74 VPWR.n73 9.3005
R244 VPWR.n75 VPWR.n11 9.3005
R245 VPWR.n77 VPWR.n76 9.3005
R246 VPWR.n78 VPWR.n10 9.3005
R247 VPWR.n80 VPWR.n79 9.3005
R248 VPWR.n81 VPWR.n9 9.3005
R249 VPWR.n83 VPWR.n82 9.3005
R250 VPWR.n84 VPWR.n6 9.3005
R251 VPWR.n86 VPWR.n85 9.3005
R252 VPWR.n87 VPWR.n5 9.3005
R253 VPWR.n89 VPWR.n88 9.3005
R254 VPWR.n90 VPWR.n3 9.3005
R255 VPWR.n92 VPWR.n91 9.3005
R256 VPWR.n93 VPWR.n2 9.3005
R257 VPWR.n95 VPWR.n94 9.3005
R258 VPWR.n96 VPWR.n0 9.3005
R259 VPWR.n97 VPWR.n96 6.4005
R260 VPWR.n7 VPWR.n5 6.4005
R261 VPWR.n85 VPWR.n7 6.4005
R262 VPWR.n15 VPWR.n13 6.4005
R263 VPWR.n67 VPWR.n15 6.4005
R264 VPWR.n65 VPWR.n16 6.4005
R265 VPWR.n62 VPWR.n16 6.4005
R266 VPWR.n60 VPWR.n18 6.4005
R267 VPWR.n57 VPWR.n18 6.4005
R268 VPWR.n56 VPWR.n55 6.4005
R269 VPWR.n55 VPWR.n54 6.4005
R270 VPWR.n42 VPWR.n24 6.4005
R271 VPWR.n39 VPWR.n24 6.4005
R272 VPWR.n31 VPWR.n28 6.4005
R273 VPWR.n98 VPWR.n0 0.584022
R274 VPWR.n94 VPWR.n0 0.063
R275 VPWR.n94 VPWR.n93 0.063
R276 VPWR.n93 VPWR.n92 0.063
R277 VPWR.n92 VPWR.n3 0.063
R278 VPWR.n88 VPWR.n3 0.063
R279 VPWR.n88 VPWR.n87 0.063
R280 VPWR.n87 VPWR.n86 0.063
R281 VPWR.n86 VPWR.n6 0.063
R282 VPWR.n82 VPWR.n6 0.063
R283 VPWR.n82 VPWR.n81 0.063
R284 VPWR.n81 VPWR.n80 0.063
R285 VPWR.n80 VPWR.n10 0.063
R286 VPWR.n76 VPWR.n10 0.063
R287 VPWR.n76 VPWR.n75 0.063
R288 VPWR.n75 VPWR.n74 0.063
R289 VPWR.n74 VPWR.n12 0.063
R290 VPWR.n70 VPWR.n12 0.063
R291 VPWR.n70 VPWR.n69 0.063
R292 VPWR.n69 VPWR.n68 0.063
R293 VPWR.n68 VPWR.n14 0.063
R294 VPWR.n64 VPWR.n14 0.063
R295 VPWR.n64 VPWR.n63 0.063
R296 VPWR.n63 VPWR.n17 0.063
R297 VPWR.n59 VPWR.n17 0.063
R298 VPWR.n59 VPWR.n58 0.063
R299 VPWR.n58 VPWR.n19 0.063
R300 VPWR.n53 VPWR.n19 0.063
R301 VPWR.n53 VPWR.n52 0.063
R302 VPWR.n52 VPWR.n51 0.063
R303 VPWR.n51 VPWR.n21 0.063
R304 VPWR.n47 VPWR.n21 0.063
R305 VPWR.n47 VPWR.n46 0.063
R306 VPWR.n46 VPWR.n45 0.063
R307 VPWR.n45 VPWR.n23 0.063
R308 VPWR.n41 VPWR.n23 0.063
R309 VPWR.n41 VPWR.n40 0.063
R310 VPWR.n40 VPWR.n25 0.063
R311 VPWR.n36 VPWR.n25 0.063
R312 VPWR.n36 VPWR.n35 0.063
R313 VPWR.n35 VPWR.n34 0.063
R314 VPWR.n34 VPWR.n27 0.063
R315 VPWR.n30 VPWR.n27 0.063
R316 VPWR.n30 VPWR.n29 0.063
R317 VPWR.n29 VPWR 0.03175
R318 SET_B.n0 SET_B.t0 424.697
R319 SET_B.n1 SET_B.t1 410.389
R320 SET_B SET_B.n0 210.548
R321 SET_B.n0 SET_B.t2 193.337
R322 SET_B.n1 SET_B.t3 179.03
R323 SET_B SET_B.n1 158.4
R324 D.n0 D.t0 261.887
R325 D.n0 D.t1 232.968
R326 D D.n0 158.4
R327 CLK.n0 CLK.t1 319.728
R328 CLK.n0 CLK.t0 232.968
R329 CLK CLK.n0 158.4
R330 VPB.t11 VPB.t7 777.274
R331 VPB.t2 VPB.t0 604.545
R332 VPB.t4 VPB.t2 604.545
R333 VPB.t12 VPB.t4 604.545
R334 VPB.t3 VPB.t1 604.545
R335 VPB.t13 VPB.t14 604.545
R336 VPB.t10 VPB.t13 604.545
R337 VPB.t15 VPB.t9 518.183
R338 VPB.t8 VPB.t16 518.183
R339 VPB.t9 VPB.t6 431.818
R340 VPB.t16 VPB.t3 431.818
R341 VPB.t14 VPB.t8 345.455
R342 VPB VPB.t10 302.274
R343 VPB.t0 VPB.t5 259.091
R344 VPB.t6 VPB.t12 259.091
R345 VPB.t7 VPB.t15 259.091
R346 VPB.t1 VPB.t11 259.091
R347 VNB.t13 VNB.t6 3600
R348 VNB.t5 VNB.t1 2800
R349 VNB.t4 VNB.t5 2800
R350 VNB.t14 VNB.t4 2800
R351 VNB.t3 VNB.t7 2800
R352 VNB.t9 VNB.t15 2800
R353 VNB.t11 VNB.t9 2800
R354 VNB.t8 VNB.t12 2400
R355 VNB.t16 VNB.t10 2400
R356 VNB.t12 VNB.t0 2000
R357 VNB.t10 VNB.t3 2000
R358 VNB.t15 VNB.t16 1600
R359 VNB VNB.t11 1400
R360 VNB.t1 VNB.t2 1200
R361 VNB.t0 VNB.t14 1200
R362 VNB.t6 VNB.t8 1200
R363 VNB.t7 VNB.t13 1200
R364 a_2373_36.t0 a_2373_36.t1 104.001
R365 a_2193_36.t0 a_2193_36.t1 200
R366 a_1869_36.t0 a_1869_36.t1 104.001
R367 a_1437_36.t0 a_1437_36.t1 104.001
R368 a_1005_36.t1 a_1005_36.t0 219
R369 a_2193_450.t0 a_2193_450.t1 328.334
R370 a_1869_450.t0 a_1869_450.t1 170.733
R371 a_1005_450.t0 a_1005_450.t1 328.334
R372 a_645_36.n0 a_645_36.t2 47.1434
R373 a_645_36.t3 a_645_36.n0 125.001
R374 a_645_36.n0 a_645_36.n1 907.601
R375 a_645_36.n1 a_645_36.t1 61.0462
R376 a_645_36.n1 a_645_36.t0 164.167
R377 nmos_n3f5_f1_l150_0.D0.t1 nmos_n3f5_f1_l150_0.D0.n3 222.143
R378 nmos_n3f5_f1_l150_0.D0 nmos_n3f5_f1_l150_0.D0.n3 9.6005
R379 nmos_n3f5_f1_l150_0.D0.n3 nmos_n3f5_f1_l150_0.D0.n0 19.2005
R380 nmos_n3f5_f1_l150_0.D0.n0 nmos_n3f5_f1_l150_0.D0.n2 213.75
R381 nmos_n3f5_f1_l150_0.D0.n2 nmos_n3f5_f1_l150_0.D0.n1 72.3005
R382 nmos_n3f5_f1_l150_0.D0.n2 nmos_n3f5_f1_l150_0.D0.t5 231.361
R383 nmos_n3f5_f1_l150_0.D0.n2 nmos_n3f5_f1_l150_0.D0.t3 187.981
R384 nmos_n3f5_f1_l150_0.D0.n1 nmos_n3f5_f1_l150_0.D0.t4 231.361
R385 nmos_n3f5_f1_l150_0.D0.n1 nmos_n3f5_f1_l150_0.D0.t2 187.981
R386 nmos_n3f5_f1_l150_0.D0.n0 nmos_n3f5_f1_l150_0.D0 9.6005
R387 nmos_n3f5_f1_l150_0.D0.t0 nmos_n3f5_f1_l150_0.D0 344.07
R388 a_1977_36.t0 a_1977_36.n0 196
R389 a_1977_36.n0 a_1977_36.t2 52.0005
R390 a_1977_36.n0 a_1977_36.n2 242.601
R391 a_1977_36.n2 a_1977_36.n5 140.8
R392 a_1977_36.n5 a_1977_36.n3 216
R393 a_1977_36.n5 a_1977_36.t3 737.567
R394 a_1977_36.n3 a_1977_36.n4 168.701
R395 a_1977_36.n4 a_1977_36.t7 231.361
R396 a_1977_36.n4 a_1977_36.t5 187.981
R397 a_1977_36.n3 a_1977_36.t6 202.44
R398 a_1977_36.n3 a_1977_36.t8 274.74
R399 a_1977_36.n2 a_1977_36.n1 652.201
R400 a_1977_36.n1 a_1977_36.t4 321.767
R401 a_1977_36.n1 a_1977_36.t1 85.3672
R402 a_2325_171.t1 a_2325_171.n1 241.133
R403 a_2325_171.n1 a_2325_171.t0 429.526
R404 a_2325_171.n1 a_2325_171.n0 280
R405 a_2325_171.n0 a_2325_171.t2 164.319
R406 a_2325_171.n0 a_2325_171.t3 453.519
R407 a_789_36.n0 a_789_36.t2 245
R408 a_789_36.t1 a_789_36.n0 65.0005
R409 a_789_36.n0 a_789_36.n2 242.601
R410 a_789_36.n4 a_789_36.n3 152
R411 a_789_36.n2 a_789_36.n4 166.4
R412 a_789_36.n4 a_789_36.n5 305.601
R413 a_789_36.n5 a_789_36.t4 251.177
R414 a_789_36.n5 a_789_36.t6 366.856
R415 a_789_36.n3 a_789_36.t5 251.177
R416 a_789_36.n3 a_789_36.t7 366.856
R417 a_789_36.n2 a_789_36.n1 652.201
R418 a_789_36.n1 a_789_36.t0 321.767
R419 a_789_36.n1 a_789_36.t3 85.3672
R420 a_1137_171.n0 a_1137_171.t1 85.3672
R421 a_1137_171.t0 a_1137_171.n0 85.3672
R422 a_1137_171.n0 a_1137_171.n2 823.4
R423 a_1137_171.n2 a_1137_171.n1 213.054
R424 a_1137_171.n1 a_1137_171.t3 164.319
R425 a_1137_171.n1 a_1137_171.t2 453
R426 a_1137_171.n2 a_1137_171.t4 193.337
R427 a_393_36.t0 a_393_36.n0 253
R428 a_393_36.n0 a_393_36.n1 10.305
R429 a_393_36.n1 a_393_36.n2 0.321929
R430 a_393_36.n2 a_393_36.n3 11.3898
R431 a_393_36.n3 a_393_36.t4 424.978
R432 a_393_36.n3 a_393_36.t2 289.005
R433 a_393_36.n2 a_393_36.t3 308.091
R434 a_393_36.n1 a_393_36.t5 680.521
R435 a_393_36.n0 a_393_36.t1 700.376
R436 a_141_36.t1 a_141_36.n4 259.401
R437 a_141_36.n4 a_141_36.n5 177.601
R438 a_141_36.n5 a_141_36.t4 232.968
R439 a_141_36.n5 a_141_36.t7 319.728
R440 a_141_36.n4 a_141_36.n0 12.8005
R441 a_141_36.n0 a_141_36.n2 10.5286
R442 a_141_36.n2 a_141_36.n1 0.563
R443 a_141_36.n1 a_141_36.n3 2.48041
R444 a_141_36.n3 a_141_36.t2 295.56
R445 a_141_36.n3 a_141_36.t5 679.629
R446 a_141_36.n2 a_141_36.t3 375.257
R447 a_141_36.n1 a_141_36.t6 351.471
R448 a_141_36.n0 a_141_36.t0 668.376
C23 Q VNB 0.31814f
C24 VGND VNB 2.22694f
C25 VPWR VNB 1.5729f
C26 SET_B VNB 1.23237f
C27 D VNB 0.19692f
C28 CLK VNB 0.25868f
C29 VPB VNB 4.1605f
C30 nmos_n3f5_f1_l150_0.D0 VNB 0.42642f
C31 a_141_36.t1 VNB 0.08803f
C32 a_141_36.t0 VNB 0.12362f
C33 a_141_36.n0 VNB 0.24662f
C34 a_141_36.t6 VNB 0.07083f
C35 a_141_36.n1 VNB 0.63949f
C36 a_141_36.t3 VNB 0.06928f
C37 a_141_36.n2 VNB 0.72841f
C38 a_141_36.t5 VNB 0.11903f
C39 a_141_36.n3 VNB 0.82256f
C40 a_141_36.t2 VNB 0.06815f
C41 a_141_36.n4 VNB 0.41129f
C42 a_141_36.t7 VNB 0.05281f
C43 a_141_36.t4 VNB 0.03492f
C44 a_141_36.n5 VNB 0.18001f
C45 a_393_36.t0 VNB 0.09283f
C46 a_393_36.t1 VNB 0.15034f
C47 a_393_36.n0 VNB 0.56695f
C48 a_393_36.t5 VNB 0.13199f
C49 a_393_36.n1 VNB 0.61579f
C50 a_393_36.t3 VNB 0.07171f
C51 a_393_36.n2 VNB 0.87557f
C52 a_393_36.n3 VNB 0.52462f
C53 a_393_36.t2 VNB 0.0594f
C54 a_393_36.t4 VNB 0.14902f
C55 a_1137_171.t0 VNB 0.02336f
C56 a_1137_171.n0 VNB 0.15402f
C57 a_1137_171.t4 VNB 0.02887f
C58 a_1137_171.n1 VNB 0.24682f
C59 a_1137_171.t2 VNB 0.19403f
C60 a_1137_171.t3 VNB 0.02514f
C61 a_1137_171.n2 VNB 0.43156f
C62 a_1137_171.t1 VNB 0.02336f
C63 a_789_36.t1 VNB 0.02145f
C64 a_789_36.n0 VNB 0.12894f
C65 a_789_36.t0 VNB 0.10106f
C66 a_789_36.t3 VNB 0.02681f
C67 a_789_36.n1 VNB 0.14157f
C68 a_789_36.n2 VNB 0.44477f
C69 a_789_36.t7 VNB 0.05721f
C70 a_789_36.t5 VNB 0.04106f
C71 a_789_36.n3 VNB 0.12394f
C72 a_789_36.n4 VNB 0.28187f
C73 a_789_36.t6 VNB 0.05721f
C74 a_789_36.t4 VNB 0.04106f
C75 a_789_36.n5 VNB 0.17867f
C76 a_789_36.t2 VNB 0.08085f
C77 a_2325_171.t1 VNB 0.09133f
C78 a_2325_171.t3 VNB 0.05622f
C79 a_2325_171.t2 VNB 0.02342f
C80 a_2325_171.n0 VNB 0.1673f
C81 a_2325_171.n1 VNB 0.50105f
C82 a_2325_171.t0 VNB 0.17496f
C83 a_1977_36.t0 VNB 0.07369f
C84 a_1977_36.n0 VNB 0.11267f
C85 a_1977_36.t4 VNB 0.07369f
C86 a_1977_36.t1 VNB 0.01955f
C87 a_1977_36.n1 VNB 0.10323f
C88 a_1977_36.n2 VNB 0.30987f
C89 a_1977_36.t8 VNB 0.04361f
C90 a_1977_36.t6 VNB 0.02707f
C91 a_1977_36.n3 VNB 0.1809f
C92 a_1977_36.t5 VNB 0.02857f
C93 a_1977_36.t7 VNB 0.04812f
C94 a_1977_36.n4 VNB 0.15911f
C95 a_1977_36.t3 VNB 0.07759f
C96 a_1977_36.n5 VNB 0.27058f
C97 a_1977_36.t2 VNB 0.01955f
C98 nmos_n3f5_f1_l150_0.D0.t1 VNB 0.06439f
C99 nmos_n3f5_f1_l150_0.D0.t0 VNB 0.12032f
C100 nmos_n3f5_f1_l150_0.D0.n0 VNB 0.16501f
C101 nmos_n3f5_f1_l150_0.D0.t2 VNB 0.01995f
C102 nmos_n3f5_f1_l150_0.D0.t4 VNB 0.03359f
C103 nmos_n3f5_f1_l150_0.D0.n1 VNB 0.07076f
C104 nmos_n3f5_f1_l150_0.D0.t3 VNB 0.01995f
C105 nmos_n3f5_f1_l150_0.D0.t5 VNB 0.03359f
C106 nmos_n3f5_f1_l150_0.D0.n2 VNB 0.11235f
C107 nmos_n3f5_f1_l150_0.D0.n3 VNB 0.05444f
C108 a_645_36.t3 VNB 0.02783f
C109 a_645_36.n0 VNB 0.22853f
C110 a_645_36.t1 VNB 0.0443f
C111 a_645_36.t0 VNB 0.03479f
C112 a_645_36.n1 VNB 0.13431f
C113 a_645_36.t2 VNB 0.03401f
C114 a_1005_450.t0 VNB 0.02078f
C115 a_1005_450.t1 VNB 0.02078f
C116 a_1869_450.t0 VNB 0.0095f
C117 a_1869_450.t1 VNB 0.0095f
C118 a_2193_450.t0 VNB 0.02074f
C119 a_2193_450.t1 VNB 0.02074f
C120 a_1005_36.t1 VNB 0.01755f
C121 a_1005_36.t0 VNB 0.02166f
C122 a_1437_36.t0 VNB 0.01152f
C123 a_1437_36.t1 VNB 0.01152f
C124 a_1869_36.t0 VNB 0.0095f
C125 a_1869_36.t1 VNB 0.0095f
C126 a_2193_36.t0 VNB 0.01852f
C127 a_2193_36.t1 VNB 0.01852f
C128 a_2373_36.t0 VNB 0.00991f
C129 a_2373_36.t1 VNB 0.00991f
C130 VPB.t5 VNB 0.15648f
C131 VPB.t0 VNB 0.15648f
C132 VPB.t2 VNB 0.21907f
C133 VPB.t4 VNB 0.21907f
C134 VPB.t12 VNB 0.15648f
C135 VPB.t6 VNB 0.12518f
C136 VPB.t9 VNB 0.17213f
C137 VPB.t15 VNB 0.14083f
C138 VPB.t7 VNB 0.18777f
C139 VPB.t11 VNB 0.18777f
C140 VPB.t1 VNB 0.15648f
C141 VPB.t3 VNB 0.18777f
C142 VPB.t16 VNB 0.17213f
C143 VPB.t8 VNB 0.15648f
C144 VPB.t14 VNB 0.17213f
C145 VPB.t13 VNB 0.21907f
C146 VPB.t10 VNB 0.1643f
C147 CLK.t1 VNB 0.04658f
C148 CLK.t0 VNB 0.0308f
C149 CLK.n0 VNB 0.14723f
C150 D.t1 VNB 0.05557f
C151 D.t0 VNB 0.05125f
C152 D.n0 VNB 0.17848f
C153 SET_B.t2 VNB 0.03846f
C154 SET_B.t0 VNB 0.07585f
C155 SET_B.n0 VNB 0.38243f
C156 SET_B.t3 VNB 0.03681f
C157 SET_B.t1 VNB 0.07377f
C158 SET_B.n1 VNB 0.20975f
C159 VPWR.n0 VNB 0.18075f
C160 VPWR.t1 VNB 0.05685f
C161 VPWR.n1 VNB 0.0371f
C162 VPWR.n2 VNB 0.01978f
C163 VPWR.n3 VNB 0.03956f
C164 VPWR.t3 VNB 0.05685f
C165 VPWR.n4 VNB 0.0371f
C166 VPWR.n5 VNB 0.01483f
C167 VPWR.n6 VNB 0.03956f
C168 VPWR.t5 VNB 0.04394f
C169 VPWR.n7 VNB 0.0667f
C170 VPWR.t9 VNB 0.0067f
C171 VPWR.t8 VNB 0.0067f
C172 VPWR.n8 VNB 0.01392f
C173 VPWR.n9 VNB 0.05386f
C174 VPWR.n10 VNB 0.03956f
C175 VPWR.n11 VNB 0.01978f
C176 VPWR.n12 VNB 0.03956f
C177 VPWR.n13 VNB 0.01483f
C178 VPWR.n14 VNB 0.03956f
C179 VPWR.t11 VNB 0.02383f
C180 VPWR.n15 VNB 0.04642f
C181 VPWR.t10 VNB 0.02383f
C182 VPWR.n16 VNB 0.04642f
C183 VPWR.n17 VNB 0.03956f
C184 VPWR.t2 VNB 0.02383f
C185 VPWR.n18 VNB 0.04642f
C186 VPWR.n19 VNB 0.03956f
C187 VPWR.t4 VNB 0.02383f
C188 VPWR.n20 VNB 0.01978f
C189 VPWR.n21 VNB 0.03956f
C190 VPWR.n22 VNB 0.01978f
C191 VPWR.n23 VNB 0.03956f
C192 VPWR.t6 VNB 0.04394f
C193 VPWR.n24 VNB 0.0667f
C194 VPWR.n25 VNB 0.03956f
C195 VPWR.t12 VNB 0.03437f
C196 VPWR.n26 VNB 0.06596f
C197 VPWR.n27 VNB 0.03956f
C198 VPWR.t0 VNB 0.03437f
C199 VPWR.n28 VNB 0.06486f
C200 VPWR.n29 VNB 0.03571f
C201 VPWR.n30 VNB 0.03956f
C202 VPWR.n31 VNB 0.01483f
C203 VPWR.n32 VNB 0.01978f
C204 VPWR.n33 VNB 0.01978f
C205 VPWR.n34 VNB 0.03956f
C206 VPWR.n35 VNB 0.03956f
C207 VPWR.n36 VNB 0.03956f
C208 VPWR.n37 VNB 0.01978f
C209 VPWR.n38 VNB 0.01978f
C210 VPWR.n39 VNB 0.01483f
C211 VPWR.n40 VNB 0.03956f
C212 VPWR.n41 VNB 0.03956f
C213 VPWR.n42 VNB 0.01483f
C214 VPWR.n43 VNB 0.01978f
C215 VPWR.n44 VNB 0.01978f
C216 VPWR.n45 VNB 0.03956f
C217 VPWR.n46 VNB 0.03956f
C218 VPWR.n47 VNB 0.03956f
C219 VPWR.n48 VNB 0.01978f
C220 VPWR.n49 VNB 0.01978f
C221 VPWR.n50 VNB 0.01978f
C222 VPWR.n51 VNB 0.03956f
C223 VPWR.n52 VNB 0.03956f
C224 VPWR.n53 VNB 0.03956f
C225 VPWR.n54 VNB 0.01483f
C226 VPWR.n55 VNB 0.04642f
C227 VPWR.n56 VNB 0.01483f
C228 VPWR.n57 VNB 0.01483f
C229 VPWR.n58 VNB 0.03956f
C230 VPWR.n59 VNB 0.03956f
C231 VPWR.n60 VNB 0.01483f
C232 VPWR.n61 VNB 0.01978f
C233 VPWR.n62 VNB 0.01483f
C234 VPWR.n63 VNB 0.03956f
C235 VPWR.n64 VNB 0.03956f
C236 VPWR.n65 VNB 0.01483f
C237 VPWR.n66 VNB 0.01978f
C238 VPWR.n67 VNB 0.01483f
C239 VPWR.n68 VNB 0.03956f
C240 VPWR.n69 VNB 0.03956f
C241 VPWR.n70 VNB 0.03956f
C242 VPWR.n71 VNB 0.01978f
C243 VPWR.n72 VNB 0.01978f
C244 VPWR.n73 VNB 0.01978f
C245 VPWR.n74 VNB 0.03956f
C246 VPWR.n75 VNB 0.03956f
C247 VPWR.n76 VNB 0.03956f
C248 VPWR.n77 VNB 0.01978f
C249 VPWR.n78 VNB 0.01978f
C250 VPWR.n79 VNB 0.01978f
C251 VPWR.n80 VNB 0.03956f
C252 VPWR.n81 VNB 0.03956f
C253 VPWR.n82 VNB 0.03956f
C254 VPWR.n83 VNB 0.01978f
C255 VPWR.n84 VNB 0.01978f
C256 VPWR.n85 VNB 0.01483f
C257 VPWR.n86 VNB 0.03956f
C258 VPWR.n87 VNB 0.03956f
C259 VPWR.n88 VNB 0.03956f
C260 VPWR.n89 VNB 0.01978f
C261 VPWR.n90 VNB 0.01978f
C262 VPWR.n91 VNB 0.03956f
C263 VPWR.n92 VNB 0.03956f
C264 VPWR.n93 VNB 0.03956f
C265 VPWR.n94 VNB 0.03956f
C266 VPWR.n95 VNB 0.01978f
C267 VPWR.n96 VNB 0.01483f
C268 VPWR.n97 VNB 0.03946f
C269 VPWR.n98 VNB 0.09115f
C270 VPWR.t7 VNB 0.05685f
C271 VPWR.n99 VNB 0.04714f
C272 VGND.t8 VNB 0.0236f
C273 VGND.n0 VNB 0.01427f
C274 VGND.n1 VNB 0.01427f
C275 VGND.n2 VNB 0.13045f
C276 VGND.t1 VNB 0.02476f
C277 VGND.t3 VNB 0.02621f
C278 VGND.n3 VNB 0.09069f
C279 VGND.n4 VNB 0.04758f
C280 VGND.n5 VNB 0.01071f
C281 VGND.n6 VNB 0.01427f
C282 VGND.n7 VNB 0.02855f
C283 VGND.n8 VNB 0.02855f
C284 VGND.n9 VNB 0.02855f
C285 VGND.t5 VNB 0.0201f
C286 VGND.n10 VNB 0.01071f
C287 VGND.n11 VNB 0.02855f
C288 VGND.t0 VNB 0.01646f
C289 VGND.n12 VNB 0.03068f
C290 VGND.n13 VNB 0.01427f
C291 VGND.n14 VNB 0.02855f
C292 VGND.n15 VNB 0.01427f
C293 VGND.n16 VNB 0.02855f
C294 VGND.t9 VNB 0.01678f
C295 VGND.n17 VNB 0.01427f
C296 VGND.n18 VNB 0.02855f
C297 VGND.t2 VNB 0.01678f
C298 VGND.n19 VNB 0.01427f
C299 VGND.n20 VNB 0.02855f
C300 VGND.t4 VNB 0.01646f
C301 VGND.n21 VNB 0.01427f
C302 VGND.n22 VNB 0.02855f
C303 VGND.n23 VNB 0.01427f
C304 VGND.n24 VNB 0.02855f
C305 VGND.t6 VNB 0.02476f
C306 VGND.n25 VNB 0.04052f
C307 VGND.n26 VNB 0.02855f
C308 VGND.t10 VNB 0.01678f
C309 VGND.n27 VNB 0.04107f
C310 VGND.n28 VNB 0.02855f
C311 VGND.t7 VNB 0.01678f
C312 VGND.n29 VNB 0.04027f
C313 VGND.n30 VNB 0.02578f
C314 VGND.n31 VNB 0.02855f
C315 VGND.n32 VNB 0.01071f
C316 VGND.n33 VNB 0.01427f
C317 VGND.n34 VNB 0.01427f
C318 VGND.n35 VNB 0.02855f
C319 VGND.n36 VNB 0.02855f
C320 VGND.n37 VNB 0.02855f
C321 VGND.n38 VNB 0.01427f
C322 VGND.n39 VNB 0.01427f
C323 VGND.n40 VNB 0.01071f
C324 VGND.n41 VNB 0.02855f
C325 VGND.n42 VNB 0.02855f
C326 VGND.n43 VNB 0.01071f
C327 VGND.n44 VNB 0.01427f
C328 VGND.n45 VNB 0.01427f
C329 VGND.n46 VNB 0.02855f
C330 VGND.n47 VNB 0.02855f
C331 VGND.n48 VNB 0.02855f
C332 VGND.n49 VNB 0.01427f
C333 VGND.n50 VNB 0.01427f
C334 VGND.n51 VNB 0.01427f
C335 VGND.n52 VNB 0.02855f
C336 VGND.n53 VNB 0.02855f
C337 VGND.n54 VNB 0.02855f
C338 VGND.n55 VNB 0.01071f
C339 VGND.n56 VNB 0.03068f
C340 VGND.n57 VNB 0.01071f
C341 VGND.n58 VNB 0.01427f
C342 VGND.n59 VNB 0.02855f
C343 VGND.n60 VNB 0.02855f
C344 VGND.n61 VNB 0.02855f
C345 VGND.n62 VNB 0.01427f
C346 VGND.n63 VNB 0.01071f
C347 VGND.n64 VNB 0.03393f
C348 VGND.n65 VNB 0.01071f
C349 VGND.n66 VNB 0.02855f
C350 VGND.n67 VNB 0.02855f
C351 VGND.n68 VNB 0.02855f
C352 VGND.n69 VNB 0.01071f
C353 VGND.n70 VNB 0.03393f
C354 VGND.n71 VNB 0.01071f
C355 VGND.n72 VNB 0.01427f
C356 VGND.n73 VNB 0.02855f
C357 VGND.n74 VNB 0.02855f
C358 VGND.n75 VNB 0.02855f
C359 VGND.n76 VNB 0.01427f
C360 VGND.n77 VNB 0.01427f
C361 VGND.n78 VNB 0.01427f
C362 VGND.n79 VNB 0.02855f
C363 VGND.n80 VNB 0.02855f
C364 VGND.n81 VNB 0.02855f
C365 VGND.n82 VNB 0.01427f
C366 VGND.n83 VNB 0.01427f
C367 VGND.n84 VNB 0.01071f
C368 VGND.n85 VNB 0.02855f
C369 VGND.n86 VNB 0.02855f
C370 VGND.n87 VNB 0.02855f
C371 VGND.n88 VNB 0.01071f
C372 VGND.n89 VNB 0.03076f
C373 VGND.n90 VNB 0.01071f
C374 VGND.n91 VNB 0.01427f
C375 VGND.n92 VNB 0.02855f
C376 VGND.n93 VNB 0.02855f
C377 VGND.n94 VNB 0.02855f
C378 VGND.n95 VNB 0.01963f
C379 Q.t3 VNB 0.03398f
C380 Q.t1 VNB 0.03398f
C381 Q.n0 VNB 0.07258f
C382 Q.t2 VNB 0.01982f
C383 Q.t0 VNB 0.01982f
C384 Q.n1 VNB 0.04653f
.ends

.subckt sky130_efx_lvdig__dfxbp_2 CLK D Q Q_N VGND VNB VPB VPWR
X0 VGND.t9 a_1736_165.t5 a_1617_36.t0 VNB.t9 sky130_fd_pr__nfet_01v8 ad=0.1134 pd=1.02 as=0.15593 ps=1.2 w=0.45 l=0.15
X1 a_1736_165.t1 a_1401_36.t4 VGND.t10 VNB.t10 sky130_fd_pr__nfet_01v8 ad=0.23625 pd=2.01 as=0.1134 ps=1.02 w=0.63 l=0.15
X2 a_969_450.t1 a_141_36.t6 a_753_36.t3 VPB.t13 sky130_fd_pr__pfet_01v8_hvt ad=0.16875 pd=1.2 as=0.20925 ps=1.38 w=0.45 l=0.15
X3 VPWR.t6 a_1088_165.t5 a_969_450.t0 VPB.t4 sky130_fd_pr__pfet_01v8_hvt ad=0.12622 pd=1.11 as=0.16875 ps=1.2 w=0.45 l=0.15
X4 Q_N.t0 a_2517_36.t5 VPWR.t2 VPB.t0 sky130_fd_pr__pfet_01v8_hvt ad=0.2106 pd=1.47 as=0.405 ps=2.91 w=1.08 l=0.15
X5 a_141_36.t0 CLK.t1 VPWR.t1 VPB.t15 sky130_fd_pr__pfet_01v8_hvt ad=0.23625 pd=2.01 as=0.23625 ps=2.01 w=0.63 l=0.15
X6 a_645_36.t3 D.t0 VGND.t0 VNB.t14 sky130_fd_pr__nfet_01v8 ad=0.08258 pd=0.84 as=0.16875 ps=1.65 w=0.45 l=0.15
X7 a_753_36.t2 a_141_36.t3 a_645_36.t1 VNB.t13 sky130_fd_pr__special_nfet_01v8 ad=0.1674 pd=1.29 as=0.08258 ps=0.84 w=0.36 l=0.15
X8 Q_N.t3 a_2517_36.t3 VGND.t6 VNB.t5 sky130_fd_pr__nfet_01v8 ad=0.12285 pd=1.02 as=0.23625 ps=2.01 w=0.63 l=0.15
X9 VGND.t2 a_2517_36.t2 Q_N.t1 VNB.t0 sky130_fd_pr__nfet_01v8 ad=0.23625 pd=2.01 as=0.12285 ps=1.02 w=0.63 l=0.15
X10 VPWR.t3 a_2517_36.t4 Q_N.t2 VPB.t1 sky130_fd_pr__pfet_01v8_hvt ad=0.405 pd=2.91 as=0.2106 ps=1.47 w=1.08 l=0.15
X11 a_1088_165.t2 a_753_36.t5 VPWR.t8 VPB.t6 sky130_fd_pr__pfet_01v8_hvt ad=0.16267 pd=1.29 as=0.12622 ps=1.11 w=0.72 l=0.15
X12 a_1736_165.t0 a_1401_36.t5 VPWR.t4 VPB.t2 sky130_fd_pr__pfet_01v8_hvt ad=0.405 pd=2.91 as=0.17752 ps=1.47 w=1.08 l=0.15
X13 a_2517_36.t1 a_1736_165.t6 VPWR.t10 VPB.t10 sky130_fd_pr__pfet_01v8_hvt ad=0.23625 pd=2.01 as=0.23625 ps=2.01 w=0.63 l=0.15
X14 a_1401_36.t0 a_393_36.t2 a_1088_165.t0 VNB.t6 sky130_fd_pr__special_nfet_01v8 ad=0.1674 pd=1.29 as=0.13702 ps=1.2 w=0.36 l=0.15
X15 a_1401_36.t2 a_141_36.t5 a_1088_165.t1 VPB.t11 sky130_fd_pr__pfet_01v8_hvt ad=0.20925 pd=1.38 as=0.16267 ps=1.29 w=0.45 l=0.15
X16 a_141_36.t1 CLK.t0 VGND.t1 VNB.t15 sky130_fd_pr__nfet_01v8 ad=0.16875 pd=1.65 as=0.16875 ps=1.65 w=0.45 l=0.15
X17 Q.t3 a_1736_165.t4 VGND.t8 VNB.t8 sky130_fd_pr__nfet_01v8 ad=0.12285 pd=1.02 as=0.23625 ps=2.01 w=0.63 l=0.15
X18 VGND.t7 a_1736_165.t3 Q.t2 VNB.t7 sky130_fd_pr__nfet_01v8 ad=0.23625 pd=2.01 as=0.12285 ps=1.02 w=0.63 l=0.15
X19 a_393_36.t1 a_141_36.t7 VPWR.t11 VPB.t12 sky130_fd_pr__pfet_01v8_hvt ad=0.23625 pd=2.01 as=0.23625 ps=2.01 w=0.63 l=0.15
X20 a_969_36.t1 a_393_36.t3 a_753_36.t0 VNB.t4 sky130_fd_pr__special_nfet_01v8 ad=0.15593 pd=1.2 as=0.1674 ps=1.29 w=0.36 l=0.15
X21 VGND.t5 a_1088_165.t4 a_969_36.t0 VNB.t3 sky130_fd_pr__nfet_01v8 ad=0.1134 pd=1.02 as=0.15593 ps=1.2 w=0.45 l=0.15
X22 a_1088_165.t3 a_753_36.t4 VGND.t4 VNB.t2 sky130_fd_pr__nfet_01v8 ad=0.13702 pd=1.2 as=0.1134 ps=1.02 w=0.63 l=0.15
X23 VPWR.t7 a_1736_165.t9 a_1617_450.t0 VPB.t5 sky130_fd_pr__pfet_01v8_hvt ad=0.17752 pd=1.47 as=0.16875 ps=1.2 w=0.45 l=0.15
X24 a_1617_450.t1 a_393_36.t4 a_1401_36.t1 VPB.t7 sky130_fd_pr__pfet_01v8_hvt ad=0.16875 pd=1.2 as=0.20925 ps=1.38 w=0.45 l=0.15
X25 a_645_36.t2 D.t1 VPWR.t0 VPB.t14 sky130_fd_pr__pfet_01v8_hvt ad=0.08775 pd=0.84 as=0.16875 ps=1.65 w=0.45 l=0.15
X26 Q.t0 a_1736_165.t8 VPWR.t5 VPB.t3 sky130_fd_pr__pfet_01v8_hvt ad=0.2106 pd=1.47 as=0.405 ps=2.91 w=1.08 l=0.15
X27 a_753_36.t1 a_393_36.t5 a_645_36.t0 VPB.t9 sky130_fd_pr__pfet_01v8_hvt ad=0.20925 pd=1.38 as=0.08775 ps=0.84 w=0.45 l=0.15
X28 a_393_36.t0 a_141_36.t4 VGND.t11 VNB.t11 sky130_fd_pr__nfet_01v8 ad=0.16875 pd=1.65 as=0.16875 ps=1.65 w=0.45 l=0.15
X29 a_2517_36.t0 a_1736_165.t2 VGND.t3 VNB.t1 sky130_fd_pr__nfet_01v8 ad=0.16875 pd=1.65 as=0.16875 ps=1.65 w=0.45 l=0.15
X30 VPWR.t9 a_1736_165.t7 Q.t1 VPB.t8 sky130_fd_pr__pfet_01v8_hvt ad=0.405 pd=2.91 as=0.2106 ps=1.47 w=1.08 l=0.15
X31 a_1617_36.t1 a_141_36.t2 a_1401_36.t3 VNB.t12 sky130_fd_pr__special_nfet_01v8 ad=0.15593 pd=1.2 as=0.1674 ps=1.29 w=0.36 l=0.15
C0 VPWR Q 0.22627f
C1 D VPB 0.11625f
C2 D VGND 0.03533f
C3 VPWR VPB 0.66289f
C4 VPWR VGND 0.19171f
C5 VPB CLK 0.09785f
C6 VGND CLK 0.04537f
C7 VPB Q_N 0.00808f
C8 VGND Q_N 0.15357f
C9 VPB Q 0.00889f
C10 VGND Q 0.15357f
C11 VPB VGND 0.04665f
C12 D VPWR 0.03564f
C13 VPWR CLK 0.04196f
C14 VPWR Q_N 0.22627f
R0 Q_N Q_N.n0 308.5
R1 Q_N Q_N.n1 204.201
R2 Q_N.n1 Q_N.t1 37.1434
R3 Q_N.n1 Q_N.t3 37.1434
R4 Q_N.n0 Q_N.t2 35.5699
R5 Q_N.n0 Q_N.t0 35.5699
R6 Q Q.n0 308.5
R7 Q Q.n1 204.201
R8 Q.n1 Q.t2 37.1434
R9 Q.n1 Q.t3 37.1434
R10 Q.n0 Q.t1 35.5699
R11 Q.n0 Q.t0 35.5699
R12 VGND.n74 VGND.t11 253
R13 VGND.n27 VGND.t3 253
R14 VGND.n67 VGND.t0 253
R15 VGND.n80 VGND.t1 253
R16 VGND.n20 VGND.t2 246.113
R17 VGND.n21 VGND.t6 241.344
R18 VGND.n29 VGND.t7 241.344
R19 VGND.n36 VGND.t8 241.344
R20 VGND.n42 VGND.n14 197.8
R21 VGND.n55 VGND.n9 197.8
R22 VGND.n14 VGND.t9 52.0005
R23 VGND.n9 VGND.t5 52.0005
R24 VGND.n14 VGND.t10 40.9529
R25 VGND.n9 VGND.t4 40.9529
R26 VGND.n81 VGND.n80 15.7005
R27 VGND.n22 VGND.n21 12.8005
R28 VGND.n22 VGND.n19 12.8005
R29 VGND.n26 VGND.n19 12.8005
R30 VGND.n30 VGND.n28 12.8005
R31 VGND.n34 VGND.n17 12.8005
R32 VGND.n35 VGND.n34 12.8005
R33 VGND.n37 VGND.n15 12.8005
R34 VGND.n41 VGND.n15 12.8005
R35 VGND.n42 VGND.n41 12.8005
R36 VGND.n43 VGND.n42 12.8005
R37 VGND.n43 VGND.n12 12.8005
R38 VGND.n47 VGND.n12 12.8005
R39 VGND.n48 VGND.n47 12.8005
R40 VGND.n49 VGND.n48 12.8005
R41 VGND.n49 VGND.n10 12.8005
R42 VGND.n53 VGND.n10 12.8005
R43 VGND.n54 VGND.n53 12.8005
R44 VGND.n55 VGND.n54 12.8005
R45 VGND.n55 VGND.n7 12.8005
R46 VGND.n59 VGND.n7 12.8005
R47 VGND.n60 VGND.n59 12.8005
R48 VGND.n61 VGND.n60 12.8005
R49 VGND.n61 VGND.n5 12.8005
R50 VGND.n65 VGND.n5 12.8005
R51 VGND.n66 VGND.n65 12.8005
R52 VGND.n68 VGND.n66 12.8005
R53 VGND.n72 VGND.n3 12.8005
R54 VGND.n73 VGND.n72 12.8005
R55 VGND.n74 VGND.n73 12.8005
R56 VGND.n74 VGND.n1 12.8005
R57 VGND.n78 VGND.n1 12.8005
R58 VGND.n79 VGND.n78 12.8005
R59 VGND.n79 VGND.n0 9.3005
R60 VGND.n78 VGND.n77 9.3005
R61 VGND.n76 VGND.n1 9.3005
R62 VGND.n75 VGND.n74 9.3005
R63 VGND.n73 VGND.n2 9.3005
R64 VGND.n72 VGND.n71 9.3005
R65 VGND.n70 VGND.n3 9.3005
R66 VGND.n69 VGND.n68 9.3005
R67 VGND.n66 VGND.n4 9.3005
R68 VGND.n65 VGND.n64 9.3005
R69 VGND.n63 VGND.n5 9.3005
R70 VGND.n62 VGND.n61 9.3005
R71 VGND.n60 VGND.n6 9.3005
R72 VGND.n59 VGND.n58 9.3005
R73 VGND.n57 VGND.n7 9.3005
R74 VGND.n56 VGND.n55 9.3005
R75 VGND.n54 VGND.n8 9.3005
R76 VGND.n53 VGND.n52 9.3005
R77 VGND.n51 VGND.n10 9.3005
R78 VGND.n50 VGND.n49 9.3005
R79 VGND.n48 VGND.n11 9.3005
R80 VGND.n47 VGND.n46 9.3005
R81 VGND.n45 VGND.n12 9.3005
R82 VGND.n44 VGND.n43 9.3005
R83 VGND.n42 VGND.n13 9.3005
R84 VGND.n41 VGND.n40 9.3005
R85 VGND.n39 VGND.n15 9.3005
R86 VGND.n38 VGND.n37 9.3005
R87 VGND.n35 VGND.n16 9.3005
R88 VGND.n34 VGND.n33 9.3005
R89 VGND.n32 VGND.n17 9.3005
R90 VGND.n31 VGND.n30 9.3005
R91 VGND.n28 VGND.n18 9.3005
R92 VGND.n26 VGND.n25 9.3005
R93 VGND.n24 VGND.n19 9.3005
R94 VGND.n23 VGND.n22 9.3005
R95 VGND.n27 VGND.n26 6.4005
R96 VGND.n28 VGND.n27 6.4005
R97 VGND.n30 VGND.n29 6.4005
R98 VGND.n29 VGND.n17 6.4005
R99 VGND.n36 VGND.n35 6.4005
R100 VGND.n37 VGND.n36 6.4005
R101 VGND.n68 VGND.n67 6.4005
R102 VGND.n67 VGND.n3 6.4005
R103 VGND.n80 VGND.n79 6.4005
R104 VGND.n21 VGND.n20 6.00163
R105 VGND.n23 VGND.n20 0.319971
R106 VGND.n24 VGND.n23 0.063
R107 VGND.n25 VGND.n24 0.063
R108 VGND.n25 VGND.n18 0.063
R109 VGND.n31 VGND.n18 0.063
R110 VGND.n32 VGND.n31 0.063
R111 VGND.n33 VGND.n32 0.063
R112 VGND.n33 VGND.n16 0.063
R113 VGND.n38 VGND.n16 0.063
R114 VGND.n39 VGND.n38 0.063
R115 VGND.n40 VGND.n39 0.063
R116 VGND.n40 VGND.n13 0.063
R117 VGND.n44 VGND.n13 0.063
R118 VGND.n45 VGND.n44 0.063
R119 VGND.n46 VGND.n45 0.063
R120 VGND.n46 VGND.n11 0.063
R121 VGND.n50 VGND.n11 0.063
R122 VGND.n51 VGND.n50 0.063
R123 VGND.n52 VGND.n51 0.063
R124 VGND.n52 VGND.n8 0.063
R125 VGND.n56 VGND.n8 0.063
R126 VGND.n57 VGND.n56 0.063
R127 VGND.n58 VGND.n57 0.063
R128 VGND.n58 VGND.n6 0.063
R129 VGND.n62 VGND.n6 0.063
R130 VGND.n63 VGND.n62 0.063
R131 VGND.n64 VGND.n63 0.063
R132 VGND.n64 VGND.n4 0.063
R133 VGND.n69 VGND.n4 0.063
R134 VGND.n70 VGND.n69 0.063
R135 VGND.n71 VGND.n70 0.063
R136 VGND.n71 VGND.n2 0.063
R137 VGND.n75 VGND.n2 0.063
R138 VGND.n76 VGND.n75 0.063
R139 VGND.n77 VGND.n76 0.063
R140 VGND.n77 VGND.n0 0.063
R141 VGND.n81 VGND.n0 0.063
R142 VGND VGND.n81 0.03175
R143 VPWR.n46 VPWR.t0 683.168
R144 VPWR.n40 VPWR.t11 661.976
R145 VPWR.n34 VPWR.t1 661.976
R146 VPWR.n12 VPWR.t10 661.976
R147 VPWR.n72 VPWR.n20 597.801
R148 VPWR.n59 VPWR.n25 597.801
R149 VPWR.n6 VPWR.t3 328.07
R150 VPWR.n4 VPWR.t2 328.07
R151 VPWR.n17 VPWR.t5 328.07
R152 VPWR.n85 VPWR.t9 328.07
R153 VPWR.n20 VPWR.t7 85.3672
R154 VPWR.n25 VPWR.t6 85.3672
R155 VPWR.n25 VPWR.t8 61.563
R156 VPWR.n20 VPWR.t4 48.3385
R157 VPWR.n7 VPWR.n6 30.3698
R158 VPWR.n5 VPWR.n4 25.6005
R159 VPWR.n78 VPWR.n17 25.6005
R160 VPWR.n85 VPWR.n84 25.6005
R161 VPWR.n6 VPWR 16.0005
R162 VPWR.n4 VPWR 16.0005
R163 VPWR.n17 VPWR 16.0005
R164 VPWR VPWR.n85 16.0005
R165 VPWR.n34 VPWR.n33 15.7005
R166 VPWR.n5 VPWR.n3 12.8005
R167 VPWR.n10 VPWR.n3 12.8005
R168 VPWR.n11 VPWR.n10 12.8005
R169 VPWR.n13 VPWR.n0 12.8005
R170 VPWR.n83 VPWR.n1 12.8005
R171 VPWR.n79 VPWR.n1 12.8005
R172 VPWR.n77 VPWR.n76 12.8005
R173 VPWR.n76 VPWR.n18 12.8005
R174 VPWR.n72 VPWR.n18 12.8005
R175 VPWR.n72 VPWR.n71 12.8005
R176 VPWR.n71 VPWR.n70 12.8005
R177 VPWR.n70 VPWR.n21 12.8005
R178 VPWR.n66 VPWR.n21 12.8005
R179 VPWR.n66 VPWR.n65 12.8005
R180 VPWR.n65 VPWR.n64 12.8005
R181 VPWR.n64 VPWR.n23 12.8005
R182 VPWR.n60 VPWR.n23 12.8005
R183 VPWR.n60 VPWR.n59 12.8005
R184 VPWR.n59 VPWR.n58 12.8005
R185 VPWR.n58 VPWR.n26 12.8005
R186 VPWR.n54 VPWR.n26 12.8005
R187 VPWR.n54 VPWR.n53 12.8005
R188 VPWR.n53 VPWR.n52 12.8005
R189 VPWR.n52 VPWR.n28 12.8005
R190 VPWR.n48 VPWR.n28 12.8005
R191 VPWR.n48 VPWR.n47 12.8005
R192 VPWR.n45 VPWR.n30 12.8005
R193 VPWR.n41 VPWR.n30 12.8005
R194 VPWR.n41 VPWR.n40 12.8005
R195 VPWR.n40 VPWR.n39 12.8005
R196 VPWR.n39 VPWR.n32 12.8005
R197 VPWR.n35 VPWR.n32 12.8005
R198 VPWR.n36 VPWR.n35 9.3005
R199 VPWR.n37 VPWR.n32 9.3005
R200 VPWR.n39 VPWR.n38 9.3005
R201 VPWR.n40 VPWR.n31 9.3005
R202 VPWR.n42 VPWR.n41 9.3005
R203 VPWR.n43 VPWR.n30 9.3005
R204 VPWR.n45 VPWR.n44 9.3005
R205 VPWR.n47 VPWR.n29 9.3005
R206 VPWR.n49 VPWR.n48 9.3005
R207 VPWR.n50 VPWR.n28 9.3005
R208 VPWR.n52 VPWR.n51 9.3005
R209 VPWR.n53 VPWR.n27 9.3005
R210 VPWR.n55 VPWR.n54 9.3005
R211 VPWR.n56 VPWR.n26 9.3005
R212 VPWR.n58 VPWR.n57 9.3005
R213 VPWR.n59 VPWR.n24 9.3005
R214 VPWR.n61 VPWR.n60 9.3005
R215 VPWR.n62 VPWR.n23 9.3005
R216 VPWR.n64 VPWR.n63 9.3005
R217 VPWR.n65 VPWR.n22 9.3005
R218 VPWR.n67 VPWR.n66 9.3005
R219 VPWR.n68 VPWR.n21 9.3005
R220 VPWR.n70 VPWR.n69 9.3005
R221 VPWR.n71 VPWR.n19 9.3005
R222 VPWR.n73 VPWR.n72 9.3005
R223 VPWR.n74 VPWR.n18 9.3005
R224 VPWR.n76 VPWR.n75 9.3005
R225 VPWR.n77 VPWR.n16 9.3005
R226 VPWR.n80 VPWR.n79 9.3005
R227 VPWR.n81 VPWR.n1 9.3005
R228 VPWR.n83 VPWR.n82 9.3005
R229 VPWR.n15 VPWR.n0 9.3005
R230 VPWR.n14 VPWR.n13 9.3005
R231 VPWR.n11 VPWR.n2 9.3005
R232 VPWR.n10 VPWR.n9 9.3005
R233 VPWR.n8 VPWR.n3 9.3005
R234 VPWR.n12 VPWR.n11 6.4005
R235 VPWR.n13 VPWR.n12 6.4005
R236 VPWR.n84 VPWR.n0 6.4005
R237 VPWR.n84 VPWR.n83 6.4005
R238 VPWR.n79 VPWR.n78 6.4005
R239 VPWR.n78 VPWR.n77 6.4005
R240 VPWR.n47 VPWR.n46 6.4005
R241 VPWR.n46 VPWR.n45 6.4005
R242 VPWR.n35 VPWR.n34 6.4005
R243 VPWR.n7 VPWR.n5 6.00163
R244 VPWR.n8 VPWR.n7 0.319971
R245 VPWR.n9 VPWR.n8 0.063
R246 VPWR.n9 VPWR.n2 0.063
R247 VPWR.n14 VPWR.n2 0.063
R248 VPWR.n15 VPWR.n14 0.063
R249 VPWR.n82 VPWR.n15 0.063
R250 VPWR.n82 VPWR.n81 0.063
R251 VPWR.n81 VPWR.n80 0.063
R252 VPWR.n80 VPWR.n16 0.063
R253 VPWR.n75 VPWR.n16 0.063
R254 VPWR.n75 VPWR.n74 0.063
R255 VPWR.n74 VPWR.n73 0.063
R256 VPWR.n73 VPWR.n19 0.063
R257 VPWR.n69 VPWR.n19 0.063
R258 VPWR.n69 VPWR.n68 0.063
R259 VPWR.n68 VPWR.n67 0.063
R260 VPWR.n67 VPWR.n22 0.063
R261 VPWR.n63 VPWR.n22 0.063
R262 VPWR.n63 VPWR.n62 0.063
R263 VPWR.n62 VPWR.n61 0.063
R264 VPWR.n61 VPWR.n24 0.063
R265 VPWR.n57 VPWR.n24 0.063
R266 VPWR.n57 VPWR.n56 0.063
R267 VPWR.n56 VPWR.n55 0.063
R268 VPWR.n55 VPWR.n27 0.063
R269 VPWR.n51 VPWR.n27 0.063
R270 VPWR.n51 VPWR.n50 0.063
R271 VPWR.n50 VPWR.n49 0.063
R272 VPWR.n49 VPWR.n29 0.063
R273 VPWR.n44 VPWR.n29 0.063
R274 VPWR.n44 VPWR.n43 0.063
R275 VPWR.n43 VPWR.n42 0.063
R276 VPWR.n42 VPWR.n31 0.063
R277 VPWR.n38 VPWR.n31 0.063
R278 VPWR.n38 VPWR.n37 0.063
R279 VPWR.n37 VPWR.n36 0.063
R280 VPWR.n36 VPWR.n33 0.063
R281 VPWR.n33 VPWR 0.03175
R282 D.n0 D.t1 290.808
R283 D.n0 D.t0 290.808
R284 D D.n0 158.4
R285 CLK.n0 CLK.t1 319.728
R286 CLK.n0 CLK.t0 232.968
R287 CLK CLK.n0 158.4
R288 VPB.t10 VPB.t0 604.545
R289 VPB.t8 VPB.t10 604.545
R290 VPB.t2 VPB.t3 604.545
R291 VPB.t12 VPB.t14 604.545
R292 VPB.t15 VPB.t12 604.545
R293 VPB.t11 VPB.t7 518.183
R294 VPB.t9 VPB.t13 518.183
R295 VPB.t7 VPB.t5 431.818
R296 VPB.t13 VPB.t4 431.818
R297 VPB.t6 VPB.t11 345.455
R298 VPB VPB.t15 302.274
R299 VPB.t0 VPB.t1 259.091
R300 VPB.t3 VPB.t8 259.091
R301 VPB.t5 VPB.t2 259.091
R302 VPB.t4 VPB.t6 259.091
R303 VPB.t14 VPB.t9 259.091
R304 VNB.t1 VNB.t5 2800
R305 VNB.t7 VNB.t1 2800
R306 VNB.t10 VNB.t8 2800
R307 VNB.t11 VNB.t14 2800
R308 VNB.t15 VNB.t11 2800
R309 VNB.t6 VNB.t12 2400
R310 VNB.t13 VNB.t4 2400
R311 VNB.t12 VNB.t9 2000
R312 VNB.t4 VNB.t3 2000
R313 VNB.t2 VNB.t6 1600
R314 VNB VNB.t15 1400
R315 VNB.t5 VNB.t0 1200
R316 VNB.t8 VNB.t7 1200
R317 VNB.t9 VNB.t10 1200
R318 VNB.t3 VNB.t2 1200
R319 VNB.t14 VNB.t13 1200
R320 a_1617_36.t1 a_1617_36.t0 219
R321 a_969_36.t1 a_969_36.t0 219
R322 a_1617_450.t0 a_1617_450.t1 328.334
R323 a_969_450.t0 a_969_450.t1 328.334
R324 a_645_36.n0 a_645_36.t3 56.0005
R325 a_645_36.t1 a_645_36.n0 65.0005
R326 a_645_36.n0 a_645_36.n1 907.601
R327 a_645_36.n1 a_645_36.t2 85.3672
R328 a_645_36.n1 a_645_36.t0 85.3672
R329 a_2517_36.t0 a_2517_36.n0 259.401
R330 a_2517_36.n0 a_2517_36.n2 213.75
R331 a_2517_36.n2 a_2517_36.n1 72.3005
R332 a_2517_36.n2 a_2517_36.t5 231.361
R333 a_2517_36.n2 a_2517_36.t3 187.981
R334 a_2517_36.n1 a_2517_36.t4 231.361
R335 a_2517_36.n1 a_2517_36.t2 187.981
R336 a_2517_36.n0 a_2517_36.t1 681.177
R337 a_1401_36.t0 a_1401_36.n0 245
R338 a_1401_36.n0 a_1401_36.t3 65.0005
R339 a_1401_36.n0 a_1401_36.n2 242.601
R340 a_1401_36.n2 a_1401_36.n3 267.2
R341 a_1401_36.n3 a_1401_36.t4 222.256
R342 a_1401_36.n3 a_1401_36.t5 265.637
R343 a_1401_36.n2 a_1401_36.n1 652.201
R344 a_1401_36.n1 a_1401_36.t2 321.767
R345 a_1401_36.n1 a_1401_36.t1 85.3672
R346 a_1736_165.t1 a_1736_165.n1 231.744
R347 a_1736_165.n1 a_1736_165.n2 16.0005
R348 a_1736_165.n2 a_1736_165.n5 210.55
R349 a_1736_165.n5 a_1736_165.n4 72.3005
R350 a_1736_165.n4 a_1736_165.n3 168.701
R351 a_1736_165.n5 a_1736_165.t8 231.361
R352 a_1736_165.n5 a_1736_165.t4 187.981
R353 a_1736_165.n4 a_1736_165.t7 231.361
R354 a_1736_165.n4 a_1736_165.t3 187.981
R355 a_1736_165.n3 a_1736_165.t6 303.661
R356 a_1736_165.n3 a_1736_165.t2 216.9
R357 a_1736_165.n2 a_1736_165.t0 360.07
R358 a_1736_165.n1 a_1736_165.n0 196.978
R359 a_1736_165.n0 a_1736_165.t5 161.036
R360 a_1736_165.n0 a_1736_165.t9 450.236
R361 a_753_36.n0 a_753_36.t2 245
R362 a_753_36.t0 a_753_36.n0 65.0005
R363 a_753_36.n0 a_753_36.n2 242.601
R364 a_753_36.n2 a_753_36.n3 267.2
R365 a_753_36.n3 a_753_36.t4 222.256
R366 a_753_36.n3 a_753_36.t5 323.476
R367 a_753_36.n2 a_753_36.n1 652.201
R368 a_753_36.n1 a_753_36.t1 321.767
R369 a_753_36.n1 a_753_36.t3 85.3672
R370 a_1088_165.n0 a_1088_165.t3 107.144
R371 a_1088_165.t0 a_1088_165.n0 65.0005
R372 a_1088_165.n0 a_1088_165.n2 204.201
R373 a_1088_165.n2 a_1088_165.n3 216.179
R374 a_1088_165.n3 a_1088_165.t4 161.036
R375 a_1088_165.n3 a_1088_165.t5 450.236
R376 a_1088_165.n2 a_1088_165.n1 690.601
R377 a_1088_165.n1 a_1088_165.t2 143.647
R378 a_1088_165.n1 a_1088_165.t1 85.3672
R379 a_393_36.t0 a_393_36.n0 253
R380 a_393_36.n0 a_393_36.n1 10.2246
R381 a_393_36.n1 a_393_36.n2 0.321929
R382 a_393_36.n2 a_393_36.n3 10.1844
R383 a_393_36.n3 a_393_36.t4 425.334
R384 a_393_36.n3 a_393_36.t2 301.957
R385 a_393_36.n2 a_393_36.t3 308.091
R386 a_393_36.n1 a_393_36.t5 680.521
R387 a_393_36.n0 a_393_36.t1 700.376
R388 a_141_36.t1 a_141_36.n4 259.401
R389 a_141_36.n4 a_141_36.n5 177.601
R390 a_141_36.n5 a_141_36.t4 232.968
R391 a_141_36.n5 a_141_36.t7 319.728
R392 a_141_36.n4 a_141_36.n0 12.8005
R393 a_141_36.n0 a_141_36.n1 10.45
R394 a_141_36.n1 a_141_36.n2 0.561253
R395 a_141_36.n2 a_141_36.n3 1.27729
R396 a_141_36.n3 a_141_36.t2 308.413
R397 a_141_36.n3 a_141_36.t5 680.521
R398 a_141_36.n2 a_141_36.t6 351.471
R399 a_141_36.n1 a_141_36.t3 375.257
R400 a_141_36.n0 a_141_36.t0 668.376
C15 Q_N VNB 0.31809f
C16 Q VNB 0.30896f
C17 VGND VNB 1.92165f
C18 VPWR VNB 1.41888f
C19 D VNB 0.22199f
C20 CLK VNB 0.25867f
C21 VPB VNB 3.6455f
C22 a_141_36.t1 VNB 0.08503f
C23 a_141_36.t0 VNB 0.1194f
C24 a_141_36.n0 VNB 0.23467f
C25 a_141_36.t3 VNB 0.06692f
C26 a_141_36.n1 VNB 0.68089f
C27 a_141_36.t6 VNB 0.06841f
C28 a_141_36.n2 VNB 0.40173f
C29 a_141_36.t5 VNB 0.11526f
C30 a_141_36.n3 VNB 0.61691f
C31 a_141_36.t2 VNB 0.06277f
C32 a_141_36.n4 VNB 0.39725f
C33 a_141_36.t7 VNB 0.05101f
C34 a_141_36.t4 VNB 0.03373f
C35 a_141_36.n5 VNB 0.17387f
C36 a_393_36.t0 VNB 0.09001f
C37 a_393_36.t1 VNB 0.14577f
C38 a_393_36.n0 VNB 0.54691f
C39 a_393_36.t5 VNB 0.12798f
C40 a_393_36.n1 VNB 0.57049f
C41 a_393_36.t3 VNB 0.06953f
C42 a_393_36.n2 VNB 0.46652f
C43 a_393_36.n3 VNB 0.45078f
C44 a_393_36.t2 VNB 0.05368f
C45 a_393_36.t4 VNB 0.14481f
C46 a_1088_165.t0 VNB 0.01853f
C47 a_1088_165.n0 VNB 0.06273f
C48 a_1088_165.t2 VNB 0.0786f
C49 a_1088_165.t1 VNB 0.02316f
C50 a_1088_165.n1 VNB 0.09163f
C51 a_1088_165.n2 VNB 0.39515f
C52 a_1088_165.t5 VNB 0.05962f
C53 a_1088_165.t4 VNB 0.02503f
C54 a_1088_165.n3 VNB 0.14339f
C55 a_1088_165.t3 VNB 0.06984f
C56 a_753_36.t0 VNB 0.01772f
C57 a_753_36.n0 VNB 0.1065f
C58 a_753_36.t1 VNB 0.08348f
C59 a_753_36.t3 VNB 0.02215f
C60 a_753_36.n1 VNB 0.11694f
C61 a_753_36.n2 VNB 0.37187f
C62 a_753_36.t5 VNB 0.05245f
C63 a_753_36.t4 VNB 0.03744f
C64 a_753_36.n3 VNB 0.12185f
C65 a_753_36.t2 VNB 0.06678f
C66 a_1736_165.t1 VNB 0.08579f
C67 a_1736_165.t9 VNB 0.04494f
C68 a_1736_165.t5 VNB 0.01887f
C69 a_1736_165.n0 VNB 0.10055f
C70 a_1736_165.n1 VNB 0.19036f
C71 a_1736_165.t0 VNB 0.16128f
C72 a_1736_165.n2 VNB 0.30561f
C73 a_1736_165.t2 VNB 0.02283f
C74 a_1736_165.t6 VNB 0.03626f
C75 a_1736_165.n3 VNB 0.15148f
C76 a_1736_165.t3 VNB 0.02552f
C77 a_1736_165.t7 VNB 0.04297f
C78 a_1736_165.n4 VNB 0.16786f
C79 a_1736_165.t4 VNB 0.02552f
C80 a_1736_165.t8 VNB 0.04297f
C81 a_1736_165.n5 VNB 0.14188f
C82 a_1401_36.t0 VNB 0.05994f
C83 a_1401_36.n0 VNB 0.0956f
C84 a_1401_36.t2 VNB 0.07493f
C85 a_1401_36.t1 VNB 0.01988f
C86 a_1401_36.n1 VNB 0.10496f
C87 a_1401_36.n2 VNB 0.33379f
C88 a_1401_36.t5 VNB 0.05333f
C89 a_1401_36.t4 VNB 0.0336f
C90 a_1401_36.n3 VNB 0.10312f
C91 a_1401_36.t3 VNB 0.0159f
C92 a_2517_36.t0 VNB 0.05375f
C93 a_2517_36.t1 VNB 0.07796f
C94 a_2517_36.n0 VNB 0.38863f
C95 a_2517_36.t2 VNB 0.02129f
C96 a_2517_36.t4 VNB 0.03586f
C97 a_2517_36.n1 VNB 0.07552f
C98 a_2517_36.t3 VNB 0.02129f
C99 a_2517_36.t5 VNB 0.03586f
C100 a_2517_36.n2 VNB 0.11991f
C101 a_645_36.t1 VNB 0.01928f
C102 a_645_36.n0 VNB 0.28051f
C103 a_645_36.t2 VNB 0.0241f
C104 a_645_36.t0 VNB 0.0241f
C105 a_645_36.n1 VNB 0.14118f
C106 a_645_36.t3 VNB 0.02724f
C107 a_969_450.t0 VNB 0.02059f
C108 a_969_450.t1 VNB 0.02059f
C109 a_1617_450.t0 VNB 0.01939f
C110 a_1617_450.t1 VNB 0.01939f
C111 a_969_36.t1 VNB 0.01775f
C112 a_969_36.t0 VNB 0.0219f
C113 a_1617_36.t1 VNB 0.01663f
C114 a_1617_36.t0 VNB 0.02052f
C115 VPB.t1 VNB 0.18167f
C116 VPB.t0 VNB 0.15139f
C117 VPB.t10 VNB 0.21195f
C118 VPB.t8 VNB 0.15139f
C119 VPB.t3 VNB 0.15139f
C120 VPB.t2 VNB 0.15139f
C121 VPB.t5 VNB 0.12112f
C122 VPB.t7 VNB 0.16653f
C123 VPB.t11 VNB 0.15139f
C124 VPB.t6 VNB 0.10598f
C125 VPB.t4 VNB 0.12112f
C126 VPB.t13 VNB 0.16653f
C127 VPB.t9 VNB 0.13625f
C128 VPB.t14 VNB 0.15139f
C129 VPB.t12 VNB 0.21195f
C130 VPB.t15 VNB 0.15896f
C131 CLK.t1 VNB 0.04658f
C132 CLK.t0 VNB 0.0308f
C133 CLK.n0 VNB 0.14721f
C134 D.t1 VNB 0.05519f
C135 D.t0 VNB 0.05519f
C136 D.n0 VNB 0.22483f
C137 VPWR.n0 VNB 0.01377f
C138 VPWR.n1 VNB 0.01836f
C139 VPWR.n2 VNB 0.03673f
C140 VPWR.t10 VNB 0.03191f
C141 VPWR.n3 VNB 0.01836f
C142 VPWR.t2 VNB 0.05278f
C143 VPWR.n4 VNB 0.03444f
C144 VPWR.n5 VNB 0.04363f
C145 VPWR.t3 VNB 0.05278f
C146 VPWR.n6 VNB 0.04307f
C147 VPWR.n7 VNB 0.11695f
C148 VPWR.n8 VNB 0.17968f
C149 VPWR.n9 VNB 0.03673f
C150 VPWR.n10 VNB 0.01836f
C151 VPWR.n11 VNB 0.01377f
C152 VPWR.n12 VNB 0.05206f
C153 VPWR.n13 VNB 0.01377f
C154 VPWR.n14 VNB 0.03673f
C155 VPWR.n15 VNB 0.03673f
C156 VPWR.n16 VNB 0.03673f
C157 VPWR.t5 VNB 0.05278f
C158 VPWR.n17 VNB 0.03444f
C159 VPWR.n18 VNB 0.01836f
C160 VPWR.n19 VNB 0.03673f
C161 VPWR.t4 VNB 0.0225f
C162 VPWR.t7 VNB 0.00622f
C163 VPWR.n20 VNB 0.02208f
C164 VPWR.n21 VNB 0.01836f
C165 VPWR.n22 VNB 0.03673f
C166 VPWR.n23 VNB 0.01836f
C167 VPWR.n24 VNB 0.03673f
C168 VPWR.t8 VNB 0.0125f
C169 VPWR.t6 VNB 0.00622f
C170 VPWR.n25 VNB 0.01755f
C171 VPWR.n26 VNB 0.01836f
C172 VPWR.n27 VNB 0.03673f
C173 VPWR.n28 VNB 0.01836f
C174 VPWR.n29 VNB 0.03673f
C175 VPWR.t0 VNB 0.02213f
C176 VPWR.n30 VNB 0.01836f
C177 VPWR.n31 VNB 0.03673f
C178 VPWR.t11 VNB 0.03191f
C179 VPWR.n32 VNB 0.01836f
C180 VPWR.n33 VNB 0.03316f
C181 VPWR.t1 VNB 0.03191f
C182 VPWR.n34 VNB 0.06022f
C183 VPWR.n35 VNB 0.01377f
C184 VPWR.n36 VNB 0.03673f
C185 VPWR.n37 VNB 0.03673f
C186 VPWR.n38 VNB 0.03673f
C187 VPWR.n39 VNB 0.01836f
C188 VPWR.n40 VNB 0.06124f
C189 VPWR.n41 VNB 0.01836f
C190 VPWR.n42 VNB 0.03673f
C191 VPWR.n43 VNB 0.03673f
C192 VPWR.n44 VNB 0.03673f
C193 VPWR.n45 VNB 0.01377f
C194 VPWR.n46 VNB 0.0431f
C195 VPWR.n47 VNB 0.01377f
C196 VPWR.n48 VNB 0.01836f
C197 VPWR.n49 VNB 0.03673f
C198 VPWR.n50 VNB 0.03673f
C199 VPWR.n51 VNB 0.03673f
C200 VPWR.n52 VNB 0.01836f
C201 VPWR.n53 VNB 0.01836f
C202 VPWR.n54 VNB 0.01836f
C203 VPWR.n55 VNB 0.03673f
C204 VPWR.n56 VNB 0.03673f
C205 VPWR.n57 VNB 0.03673f
C206 VPWR.n58 VNB 0.01836f
C207 VPWR.n59 VNB 0.05001f
C208 VPWR.n60 VNB 0.01836f
C209 VPWR.n61 VNB 0.03673f
C210 VPWR.n62 VNB 0.03673f
C211 VPWR.n63 VNB 0.03673f
C212 VPWR.n64 VNB 0.01836f
C213 VPWR.n65 VNB 0.01836f
C214 VPWR.n66 VNB 0.01836f
C215 VPWR.n67 VNB 0.03673f
C216 VPWR.n68 VNB 0.03673f
C217 VPWR.n69 VNB 0.03673f
C218 VPWR.n70 VNB 0.01836f
C219 VPWR.n71 VNB 0.01836f
C220 VPWR.n72 VNB 0.05001f
C221 VPWR.n73 VNB 0.03673f
C222 VPWR.n74 VNB 0.03673f
C223 VPWR.n75 VNB 0.03673f
C224 VPWR.n76 VNB 0.01836f
C225 VPWR.n77 VNB 0.01377f
C226 VPWR.n78 VNB 0.02754f
C227 VPWR.n79 VNB 0.01377f
C228 VPWR.n80 VNB 0.03673f
C229 VPWR.n81 VNB 0.03673f
C230 VPWR.n82 VNB 0.03673f
C231 VPWR.n83 VNB 0.01377f
C232 VPWR.n84 VNB 0.02754f
C233 VPWR.t9 VNB 0.05278f
C234 VPWR.n85 VNB 0.03444f
C235 VGND.n0 VNB 0.02964f
C236 VGND.t1 VNB 0.01741f
C237 VGND.n1 VNB 0.01482f
C238 VGND.n2 VNB 0.02964f
C239 VGND.t11 VNB 0.01741f
C240 VGND.n3 VNB 0.01111f
C241 VGND.n4 VNB 0.02964f
C242 VGND.n5 VNB 0.01482f
C243 VGND.n6 VNB 0.02964f
C244 VGND.n7 VNB 0.01482f
C245 VGND.n8 VNB 0.02964f
C246 VGND.t4 VNB 0.00828f
C247 VGND.t5 VNB 0.00502f
C248 VGND.n9 VNB 0.0136f
C249 VGND.n10 VNB 0.01482f
C250 VGND.n11 VNB 0.02964f
C251 VGND.n12 VNB 0.01482f
C252 VGND.n13 VNB 0.02964f
C253 VGND.t10 VNB 0.00828f
C254 VGND.t9 VNB 0.00502f
C255 VGND.n14 VNB 0.0136f
C256 VGND.n15 VNB 0.01482f
C257 VGND.n16 VNB 0.02964f
C258 VGND.t8 VNB 0.02571f
C259 VGND.n17 VNB 0.01111f
C260 VGND.n18 VNB 0.02964f
C261 VGND.t3 VNB 0.01741f
C262 VGND.n19 VNB 0.01482f
C263 VGND.t2 VNB 0.02695f
C264 VGND.n20 VNB 0.11993f
C265 VGND.t6 VNB 0.02571f
C266 VGND.n21 VNB 0.05504f
C267 VGND.n22 VNB 0.01482f
C268 VGND.n23 VNB 0.145f
C269 VGND.n24 VNB 0.02964f
C270 VGND.n25 VNB 0.02964f
C271 VGND.n26 VNB 0.01111f
C272 VGND.n27 VNB 0.03522f
C273 VGND.n28 VNB 0.01111f
C274 VGND.t7 VNB 0.02571f
C275 VGND.n29 VNB 0.04206f
C276 VGND.n30 VNB 0.01111f
C277 VGND.n31 VNB 0.02964f
C278 VGND.n32 VNB 0.02964f
C279 VGND.n33 VNB 0.02964f
C280 VGND.n34 VNB 0.01482f
C281 VGND.n35 VNB 0.01111f
C282 VGND.n36 VNB 0.04206f
C283 VGND.n37 VNB 0.01111f
C284 VGND.n38 VNB 0.02964f
C285 VGND.n39 VNB 0.02964f
C286 VGND.n40 VNB 0.02964f
C287 VGND.n41 VNB 0.01482f
C288 VGND.n42 VNB 0.03609f
C289 VGND.n43 VNB 0.01482f
C290 VGND.n44 VNB 0.02964f
C291 VGND.n45 VNB 0.02964f
C292 VGND.n46 VNB 0.02964f
C293 VGND.n47 VNB 0.01482f
C294 VGND.n48 VNB 0.01482f
C295 VGND.n49 VNB 0.01482f
C296 VGND.n50 VNB 0.02964f
C297 VGND.n51 VNB 0.02964f
C298 VGND.n52 VNB 0.02964f
C299 VGND.n53 VNB 0.01482f
C300 VGND.n54 VNB 0.01482f
C301 VGND.n55 VNB 0.03609f
C302 VGND.n56 VNB 0.02964f
C303 VGND.n57 VNB 0.02964f
C304 VGND.n58 VNB 0.02964f
C305 VGND.n59 VNB 0.01482f
C306 VGND.n60 VNB 0.01482f
C307 VGND.n61 VNB 0.01482f
C308 VGND.n62 VNB 0.02964f
C309 VGND.n63 VNB 0.02964f
C310 VGND.n64 VNB 0.02964f
C311 VGND.n65 VNB 0.01482f
C312 VGND.n66 VNB 0.01482f
C313 VGND.t0 VNB 0.01741f
C314 VGND.n67 VNB 0.03522f
C315 VGND.n68 VNB 0.01111f
C316 VGND.n69 VNB 0.02964f
C317 VGND.n70 VNB 0.02964f
C318 VGND.n71 VNB 0.02964f
C319 VGND.n72 VNB 0.01482f
C320 VGND.n73 VNB 0.01482f
C321 VGND.n74 VNB 0.04263f
C322 VGND.n75 VNB 0.02964f
C323 VGND.n76 VNB 0.02964f
C324 VGND.n77 VNB 0.02964f
C325 VGND.n78 VNB 0.01482f
C326 VGND.n79 VNB 0.01111f
C327 VGND.n80 VNB 0.04181f
C328 VGND.n81 VNB 0.02676f
C329 Q.t1 VNB 0.03579f
C330 Q.t0 VNB 0.03579f
C331 Q.n0 VNB 0.07643f
C332 Q.t2 VNB 0.02088f
C333 Q.t3 VNB 0.02088f
C334 Q.n1 VNB 0.049f
C335 Q_N.t2 VNB 0.03403f
C336 Q_N.t0 VNB 0.03403f
C337 Q_N.n0 VNB 0.07268f
C338 Q_N.t1 VNB 0.01985f
C339 Q_N.t3 VNB 0.01985f
C340 Q_N.n1 VNB 0.0466f
.ends

.subckt sky130_efx_lvdig__dfxtp_2 CLK D Q VGND VNB VPB VPWR
X0 VGND.t8 a_1736_165.t4 a_1617_36.t1 VNB.t12 sky130_fd_pr__nfet_01v8 ad=0.1134 pd=1.02 as=0.15593 ps=1.2 w=0.45 l=0.15
X1 a_1736_165.t1 a_1401_36.t4 VGND.t5 VNB.t9 sky130_fd_pr__nfet_01v8 ad=0.23625 pd=2.01 as=0.1134 ps=1.02 w=0.63 l=0.15
X2 a_969_450.t0 a_141_36.t6 a_753_36.t2 VPB.t4 sky130_fd_pr__pfet_01v8_hvt ad=0.16875 pd=1.2 as=0.20925 ps=1.38 w=0.45 l=0.15
X3 VPWR.t2 a_1088_165.t5 a_969_450.t1 VPB.t8 sky130_fd_pr__pfet_01v8_hvt ad=0.12622 pd=1.11 as=0.16875 ps=1.2 w=0.45 l=0.15
X4 a_141_36.t0 CLK.t1 VPWR.t5 VPB.t6 sky130_fd_pr__pfet_01v8_hvt ad=0.23625 pd=2.01 as=0.23625 ps=2.01 w=0.63 l=0.15
X5 a_645_36.t2 D.t0 VGND.t2 VNB.t4 sky130_fd_pr__nfet_01v8 ad=0.08258 pd=0.84 as=0.16875 ps=1.65 w=0.45 l=0.15
X6 a_753_36.t3 a_141_36.t3 a_645_36.t3 VNB.t7 sky130_fd_pr__special_nfet_01v8 ad=0.1674 pd=1.29 as=0.08258 ps=0.84 w=0.36 l=0.15
X7 a_1088_165.t1 a_753_36.t5 VPWR.t0 VPB.t0 sky130_fd_pr__pfet_01v8_hvt ad=0.16267 pd=1.29 as=0.12622 ps=1.11 w=0.72 l=0.15
X8 a_1736_165.t0 a_1401_36.t5 VPWR.t6 VPB.t10 sky130_fd_pr__pfet_01v8_hvt ad=0.405 pd=2.91 as=0.17752 ps=1.47 w=1.08 l=0.15
X9 a_1401_36.t1 a_393_36.t2 a_1088_165.t0 VNB.t1 sky130_fd_pr__special_nfet_01v8 ad=0.1674 pd=1.29 as=0.13702 ps=1.2 w=0.36 l=0.15
X10 a_1401_36.t2 a_141_36.t5 a_1088_165.t3 VPB.t7 sky130_fd_pr__pfet_01v8_hvt ad=0.20925 pd=1.38 as=0.16267 ps=1.29 w=0.45 l=0.15
X11 a_141_36.t1 CLK.t0 VGND.t3 VNB.t5 sky130_fd_pr__nfet_01v8 ad=0.16875 pd=1.65 as=0.16875 ps=1.65 w=0.45 l=0.15
X12 Q.t1 a_1736_165.t3 VGND.t6 VNB.t10 sky130_fd_pr__nfet_01v8 ad=0.12285 pd=1.02 as=0.23625 ps=2.01 w=0.63 l=0.15
X13 VGND.t7 a_1736_165.t2 Q.t2 VNB.t11 sky130_fd_pr__nfet_01v8 ad=0.23625 pd=2.01 as=0.12285 ps=1.02 w=0.63 l=0.15
X14 a_393_36.t1 a_141_36.t7 VPWR.t1 VPB.t3 sky130_fd_pr__pfet_01v8_hvt ad=0.23625 pd=2.01 as=0.23625 ps=2.01 w=0.63 l=0.15
X15 a_969_36.t0 a_393_36.t3 a_753_36.t0 VNB.t0 sky130_fd_pr__special_nfet_01v8 ad=0.15593 pd=1.2 as=0.1674 ps=1.29 w=0.36 l=0.15
X16 VGND.t1 a_1088_165.t4 a_969_36.t1 VNB.t3 sky130_fd_pr__nfet_01v8 ad=0.1134 pd=1.02 as=0.15593 ps=1.2 w=0.45 l=0.15
X17 a_1088_165.t2 a_753_36.t4 VGND.t4 VNB.t8 sky130_fd_pr__nfet_01v8 ad=0.13702 pd=1.2 as=0.1134 ps=1.02 w=0.63 l=0.15
X18 VPWR.t3 a_1736_165.t7 a_1617_450.t1 VPB.t9 sky130_fd_pr__pfet_01v8_hvt ad=0.17752 pd=1.47 as=0.16875 ps=1.2 w=0.45 l=0.15
X19 a_1617_450.t0 a_393_36.t4 a_1401_36.t0 VPB.t1 sky130_fd_pr__pfet_01v8_hvt ad=0.16875 pd=1.2 as=0.20925 ps=1.38 w=0.45 l=0.15
X20 a_645_36.t1 D.t1 VPWR.t4 VPB.t5 sky130_fd_pr__pfet_01v8_hvt ad=0.08775 pd=0.84 as=0.16875 ps=1.65 w=0.45 l=0.15
X21 Q.t0 a_1736_165.t6 VPWR.t7 VPB.t11 sky130_fd_pr__pfet_01v8_hvt ad=0.2106 pd=1.47 as=0.405 ps=2.91 w=1.08 l=0.15
X22 a_753_36.t1 a_393_36.t5 a_645_36.t0 VPB.t2 sky130_fd_pr__pfet_01v8_hvt ad=0.20925 pd=1.38 as=0.08775 ps=0.84 w=0.45 l=0.15
X23 a_393_36.t0 a_141_36.t4 VGND.t0 VNB.t2 sky130_fd_pr__nfet_01v8 ad=0.16875 pd=1.65 as=0.16875 ps=1.65 w=0.45 l=0.15
X24 VPWR.t8 a_1736_165.t5 Q.t3 VPB.t12 sky130_fd_pr__pfet_01v8_hvt ad=0.405 pd=2.91 as=0.2106 ps=1.47 w=1.08 l=0.15
X25 a_1617_36.t0 a_141_36.t2 a_1401_36.t3 VNB.t6 sky130_fd_pr__special_nfet_01v8 ad=0.15593 pd=1.2 as=0.1674 ps=1.29 w=0.36 l=0.15
C0 VGND CLK 0.04537f
C1 VPWR CLK 0.04196f
C2 VPB CLK 0.09785f
C3 VGND VPWR 0.10833f
C4 VGND VPB 0.02729f
C5 VGND Q 0.15357f
C6 Q VPWR 0.22627f
C7 VPB VPWR 0.49683f
C8 Q VPB 0.00762f
C9 VGND D 0.03533f
C10 VPWR D 0.03564f
C11 VPB D 0.11625f
R0 Q Q.n0 308.5
R1 Q Q.n1 204.201
R2 Q.n1 Q.t2 37.1434
R3 Q.n1 Q.t1 37.1434
R4 Q.n0 Q.t3 35.5699
R5 Q.n0 Q.t0 35.5699
R6 VGND.n55 VGND.t0 253
R7 VGND.n48 VGND.t2 253
R8 VGND.n61 VGND.t3 253
R9 VGND.n16 VGND.t7 247.951
R10 VGND.n17 VGND.t6 241.344
R11 VGND.n23 VGND.n14 197.8
R12 VGND.n36 VGND.n9 197.8
R13 VGND.n14 VGND.t8 52.0005
R14 VGND.n9 VGND.t1 52.0005
R15 VGND.n14 VGND.t5 40.9529
R16 VGND.n9 VGND.t4 40.9529
R17 VGND.n62 VGND.n61 15.7005
R18 VGND.n18 VGND.n15 12.8005
R19 VGND.n22 VGND.n15 12.8005
R20 VGND.n23 VGND.n22 12.8005
R21 VGND.n24 VGND.n23 12.8005
R22 VGND.n24 VGND.n12 12.8005
R23 VGND.n28 VGND.n12 12.8005
R24 VGND.n29 VGND.n28 12.8005
R25 VGND.n30 VGND.n29 12.8005
R26 VGND.n30 VGND.n10 12.8005
R27 VGND.n34 VGND.n10 12.8005
R28 VGND.n35 VGND.n34 12.8005
R29 VGND.n36 VGND.n35 12.8005
R30 VGND.n36 VGND.n7 12.8005
R31 VGND.n40 VGND.n7 12.8005
R32 VGND.n41 VGND.n40 12.8005
R33 VGND.n42 VGND.n41 12.8005
R34 VGND.n42 VGND.n5 12.8005
R35 VGND.n46 VGND.n5 12.8005
R36 VGND.n47 VGND.n46 12.8005
R37 VGND.n49 VGND.n47 12.8005
R38 VGND.n53 VGND.n3 12.8005
R39 VGND.n54 VGND.n53 12.8005
R40 VGND.n55 VGND.n54 12.8005
R41 VGND.n55 VGND.n1 12.8005
R42 VGND.n59 VGND.n1 12.8005
R43 VGND.n60 VGND.n59 12.8005
R44 VGND.n17 VGND.n16 12.1406
R45 VGND.n60 VGND.n0 9.3005
R46 VGND.n59 VGND.n58 9.3005
R47 VGND.n57 VGND.n1 9.3005
R48 VGND.n56 VGND.n55 9.3005
R49 VGND.n54 VGND.n2 9.3005
R50 VGND.n53 VGND.n52 9.3005
R51 VGND.n51 VGND.n3 9.3005
R52 VGND.n50 VGND.n49 9.3005
R53 VGND.n47 VGND.n4 9.3005
R54 VGND.n46 VGND.n45 9.3005
R55 VGND.n44 VGND.n5 9.3005
R56 VGND.n43 VGND.n42 9.3005
R57 VGND.n41 VGND.n6 9.3005
R58 VGND.n40 VGND.n39 9.3005
R59 VGND.n38 VGND.n7 9.3005
R60 VGND.n37 VGND.n36 9.3005
R61 VGND.n35 VGND.n8 9.3005
R62 VGND.n34 VGND.n33 9.3005
R63 VGND.n32 VGND.n10 9.3005
R64 VGND.n31 VGND.n30 9.3005
R65 VGND.n29 VGND.n11 9.3005
R66 VGND.n28 VGND.n27 9.3005
R67 VGND.n26 VGND.n12 9.3005
R68 VGND.n25 VGND.n24 9.3005
R69 VGND.n23 VGND.n13 9.3005
R70 VGND.n22 VGND.n21 9.3005
R71 VGND.n20 VGND.n15 9.3005
R72 VGND.n19 VGND.n18 9.3005
R73 VGND.n18 VGND.n17 6.4005
R74 VGND.n49 VGND.n48 6.4005
R75 VGND.n48 VGND.n3 6.4005
R76 VGND.n61 VGND.n60 6.4005
R77 VGND.n19 VGND.n16 0.584022
R78 VGND.n20 VGND.n19 0.063
R79 VGND.n21 VGND.n20 0.063
R80 VGND.n21 VGND.n13 0.063
R81 VGND.n25 VGND.n13 0.063
R82 VGND.n26 VGND.n25 0.063
R83 VGND.n27 VGND.n26 0.063
R84 VGND.n27 VGND.n11 0.063
R85 VGND.n31 VGND.n11 0.063
R86 VGND.n32 VGND.n31 0.063
R87 VGND.n33 VGND.n32 0.063
R88 VGND.n33 VGND.n8 0.063
R89 VGND.n37 VGND.n8 0.063
R90 VGND.n38 VGND.n37 0.063
R91 VGND.n39 VGND.n38 0.063
R92 VGND.n39 VGND.n6 0.063
R93 VGND.n43 VGND.n6 0.063
R94 VGND.n44 VGND.n43 0.063
R95 VGND.n45 VGND.n44 0.063
R96 VGND.n45 VGND.n4 0.063
R97 VGND.n50 VGND.n4 0.063
R98 VGND.n51 VGND.n50 0.063
R99 VGND.n52 VGND.n51 0.063
R100 VGND.n52 VGND.n2 0.063
R101 VGND.n56 VGND.n2 0.063
R102 VGND.n57 VGND.n56 0.063
R103 VGND.n58 VGND.n57 0.063
R104 VGND.n58 VGND.n0 0.063
R105 VGND.n62 VGND.n0 0.063
R106 VGND VGND.n62 0.03175
R107 VPWR.n30 VPWR.t4 683.168
R108 VPWR.n24 VPWR.t1 661.976
R109 VPWR.n18 VPWR.t5 661.976
R110 VPWR.n56 VPWR.n4 597.801
R111 VPWR.n43 VPWR.n9 597.801
R112 VPWR.n1 VPWR.t7 328.07
R113 VPWR.n64 VPWR.t8 328.07
R114 VPWR.n4 VPWR.t3 85.3672
R115 VPWR.n9 VPWR.t2 85.3672
R116 VPWR.n9 VPWR.t0 61.563
R117 VPWR.n4 VPWR.t6 48.3385
R118 VPWR.n64 VPWR.n63 32.2074
R119 VPWR.n62 VPWR.n1 25.6005
R120 VPWR.n1 VPWR 16.0005
R121 VPWR VPWR.n64 16.0005
R122 VPWR.n18 VPWR.n17 15.7005
R123 VPWR.n61 VPWR.n60 12.8005
R124 VPWR.n60 VPWR.n2 12.8005
R125 VPWR.n56 VPWR.n2 12.8005
R126 VPWR.n56 VPWR.n55 12.8005
R127 VPWR.n55 VPWR.n54 12.8005
R128 VPWR.n54 VPWR.n5 12.8005
R129 VPWR.n50 VPWR.n5 12.8005
R130 VPWR.n50 VPWR.n49 12.8005
R131 VPWR.n49 VPWR.n48 12.8005
R132 VPWR.n48 VPWR.n7 12.8005
R133 VPWR.n44 VPWR.n7 12.8005
R134 VPWR.n44 VPWR.n43 12.8005
R135 VPWR.n43 VPWR.n42 12.8005
R136 VPWR.n42 VPWR.n10 12.8005
R137 VPWR.n38 VPWR.n10 12.8005
R138 VPWR.n38 VPWR.n37 12.8005
R139 VPWR.n37 VPWR.n36 12.8005
R140 VPWR.n36 VPWR.n12 12.8005
R141 VPWR.n32 VPWR.n12 12.8005
R142 VPWR.n32 VPWR.n31 12.8005
R143 VPWR.n29 VPWR.n14 12.8005
R144 VPWR.n25 VPWR.n14 12.8005
R145 VPWR.n25 VPWR.n24 12.8005
R146 VPWR.n24 VPWR.n23 12.8005
R147 VPWR.n23 VPWR.n16 12.8005
R148 VPWR.n19 VPWR.n16 12.8005
R149 VPWR.n63 VPWR.n62 12.1406
R150 VPWR.n20 VPWR.n19 9.3005
R151 VPWR.n21 VPWR.n16 9.3005
R152 VPWR.n23 VPWR.n22 9.3005
R153 VPWR.n24 VPWR.n15 9.3005
R154 VPWR.n26 VPWR.n25 9.3005
R155 VPWR.n27 VPWR.n14 9.3005
R156 VPWR.n29 VPWR.n28 9.3005
R157 VPWR.n31 VPWR.n13 9.3005
R158 VPWR.n33 VPWR.n32 9.3005
R159 VPWR.n34 VPWR.n12 9.3005
R160 VPWR.n36 VPWR.n35 9.3005
R161 VPWR.n37 VPWR.n11 9.3005
R162 VPWR.n39 VPWR.n38 9.3005
R163 VPWR.n40 VPWR.n10 9.3005
R164 VPWR.n42 VPWR.n41 9.3005
R165 VPWR.n43 VPWR.n8 9.3005
R166 VPWR.n45 VPWR.n44 9.3005
R167 VPWR.n46 VPWR.n7 9.3005
R168 VPWR.n48 VPWR.n47 9.3005
R169 VPWR.n49 VPWR.n6 9.3005
R170 VPWR.n51 VPWR.n50 9.3005
R171 VPWR.n52 VPWR.n5 9.3005
R172 VPWR.n54 VPWR.n53 9.3005
R173 VPWR.n55 VPWR.n3 9.3005
R174 VPWR.n57 VPWR.n56 9.3005
R175 VPWR.n58 VPWR.n2 9.3005
R176 VPWR.n60 VPWR.n59 9.3005
R177 VPWR.n61 VPWR.n0 9.3005
R178 VPWR.n62 VPWR.n61 6.4005
R179 VPWR.n31 VPWR.n30 6.4005
R180 VPWR.n30 VPWR.n29 6.4005
R181 VPWR.n19 VPWR.n18 6.4005
R182 VPWR.n63 VPWR.n0 0.584022
R183 VPWR.n59 VPWR.n0 0.063
R184 VPWR.n59 VPWR.n58 0.063
R185 VPWR.n58 VPWR.n57 0.063
R186 VPWR.n57 VPWR.n3 0.063
R187 VPWR.n53 VPWR.n3 0.063
R188 VPWR.n53 VPWR.n52 0.063
R189 VPWR.n52 VPWR.n51 0.063
R190 VPWR.n51 VPWR.n6 0.063
R191 VPWR.n47 VPWR.n6 0.063
R192 VPWR.n47 VPWR.n46 0.063
R193 VPWR.n46 VPWR.n45 0.063
R194 VPWR.n45 VPWR.n8 0.063
R195 VPWR.n41 VPWR.n8 0.063
R196 VPWR.n41 VPWR.n40 0.063
R197 VPWR.n40 VPWR.n39 0.063
R198 VPWR.n39 VPWR.n11 0.063
R199 VPWR.n35 VPWR.n11 0.063
R200 VPWR.n35 VPWR.n34 0.063
R201 VPWR.n34 VPWR.n33 0.063
R202 VPWR.n33 VPWR.n13 0.063
R203 VPWR.n28 VPWR.n13 0.063
R204 VPWR.n28 VPWR.n27 0.063
R205 VPWR.n27 VPWR.n26 0.063
R206 VPWR.n26 VPWR.n15 0.063
R207 VPWR.n22 VPWR.n15 0.063
R208 VPWR.n22 VPWR.n21 0.063
R209 VPWR.n21 VPWR.n20 0.063
R210 VPWR.n20 VPWR.n17 0.063
R211 VPWR.n17 VPWR 0.03175
R212 D.n0 D.t1 290.808
R213 D.n0 D.t0 290.808
R214 D D.n0 158.4
R215 CLK.n0 CLK.t1 319.728
R216 CLK.n0 CLK.t0 232.968
R217 CLK CLK.n0 158.4
R218 VPB.t10 VPB.t11 604.545
R219 VPB.t3 VPB.t5 604.545
R220 VPB.t6 VPB.t3 604.545
R221 VPB.t7 VPB.t1 518.183
R222 VPB.t2 VPB.t4 518.183
R223 VPB.t1 VPB.t9 431.818
R224 VPB.t4 VPB.t8 431.818
R225 VPB.t0 VPB.t7 345.455
R226 VPB VPB.t6 302.274
R227 VPB.t11 VPB.t12 259.091
R228 VPB.t9 VPB.t10 259.091
R229 VPB.t8 VPB.t0 259.091
R230 VPB.t5 VPB.t2 259.091
R231 VNB.t9 VNB.t10 2800
R232 VNB.t2 VNB.t4 2800
R233 VNB.t5 VNB.t2 2800
R234 VNB.t1 VNB.t6 2400
R235 VNB.t7 VNB.t0 2400
R236 VNB.t6 VNB.t12 2000
R237 VNB.t0 VNB.t3 2000
R238 VNB.t8 VNB.t1 1600
R239 VNB VNB.t5 1400
R240 VNB.t10 VNB.t11 1200
R241 VNB.t12 VNB.t9 1200
R242 VNB.t3 VNB.t8 1200
R243 VNB.t4 VNB.t7 1200
R244 a_1617_36.t0 a_1617_36.t1 219
R245 a_969_36.t0 a_969_36.t1 219
R246 a_1617_450.t0 a_1617_450.t1 328.334
R247 a_969_450.t0 a_969_450.t1 328.334
R248 a_645_36.n0 a_645_36.t2 56.0005
R249 a_645_36.t3 a_645_36.n0 65.0005
R250 a_645_36.n0 a_645_36.n1 907.601
R251 a_645_36.n1 a_645_36.t1 85.3672
R252 a_645_36.n1 a_645_36.t0 85.3672
R253 a_1401_36.t1 a_1401_36.n0 245
R254 a_1401_36.n0 a_1401_36.t3 65.0005
R255 a_1401_36.n0 a_1401_36.n2 242.601
R256 a_1401_36.n2 a_1401_36.n3 267.2
R257 a_1401_36.n3 a_1401_36.t4 222.256
R258 a_1401_36.n3 a_1401_36.t5 265.637
R259 a_1401_36.n2 a_1401_36.n1 652.201
R260 a_1401_36.n1 a_1401_36.t2 321.767
R261 a_1401_36.n1 a_1401_36.t0 85.3672
R262 a_1736_165.t1 a_1736_165.n1 231.744
R263 a_1736_165.n1 a_1736_165.n2 16.0005
R264 a_1736_165.n2 a_1736_165.n4 210.55
R265 a_1736_165.n4 a_1736_165.n3 72.3005
R266 a_1736_165.n4 a_1736_165.t6 231.361
R267 a_1736_165.n4 a_1736_165.t3 187.981
R268 a_1736_165.n3 a_1736_165.t5 231.361
R269 a_1736_165.n3 a_1736_165.t2 187.981
R270 a_1736_165.n2 a_1736_165.t0 360.07
R271 a_1736_165.n1 a_1736_165.n0 196.978
R272 a_1736_165.n0 a_1736_165.t4 161.036
R273 a_1736_165.n0 a_1736_165.t7 450.236
R274 a_753_36.n0 a_753_36.t3 245
R275 a_753_36.t0 a_753_36.n0 65.0005
R276 a_753_36.n0 a_753_36.n2 242.601
R277 a_753_36.n2 a_753_36.n3 267.2
R278 a_753_36.n3 a_753_36.t4 222.256
R279 a_753_36.n3 a_753_36.t5 323.476
R280 a_753_36.n2 a_753_36.n1 652.201
R281 a_753_36.n1 a_753_36.t1 321.767
R282 a_753_36.n1 a_753_36.t2 85.3672
R283 a_1088_165.n0 a_1088_165.t2 107.144
R284 a_1088_165.t0 a_1088_165.n0 65.0005
R285 a_1088_165.n0 a_1088_165.n2 204.201
R286 a_1088_165.n2 a_1088_165.n3 216.179
R287 a_1088_165.n3 a_1088_165.t4 161.036
R288 a_1088_165.n3 a_1088_165.t5 450.236
R289 a_1088_165.n2 a_1088_165.n1 690.601
R290 a_1088_165.n1 a_1088_165.t1 143.647
R291 a_1088_165.n1 a_1088_165.t3 85.3672
R292 a_393_36.t0 a_393_36.n0 253
R293 a_393_36.n0 a_393_36.n1 10.2246
R294 a_393_36.n1 a_393_36.n2 0.321929
R295 a_393_36.n2 a_393_36.n3 10.1844
R296 a_393_36.n3 a_393_36.t4 425.334
R297 a_393_36.n3 a_393_36.t2 301.957
R298 a_393_36.n2 a_393_36.t3 308.091
R299 a_393_36.n1 a_393_36.t5 680.521
R300 a_393_36.n0 a_393_36.t1 700.376
R301 a_141_36.t1 a_141_36.n4 259.401
R302 a_141_36.n4 a_141_36.n5 177.601
R303 a_141_36.n5 a_141_36.t4 232.968
R304 a_141_36.n5 a_141_36.t7 319.728
R305 a_141_36.n4 a_141_36.n0 12.8005
R306 a_141_36.n0 a_141_36.n1 10.45
R307 a_141_36.n1 a_141_36.n2 0.561253
R308 a_141_36.n2 a_141_36.n3 1.27729
R309 a_141_36.n3 a_141_36.t2 308.413
R310 a_141_36.n3 a_141_36.t5 680.521
R311 a_141_36.n2 a_141_36.t6 351.471
R312 a_141_36.n1 a_141_36.t3 375.257
R313 a_141_36.n0 a_141_36.t0 668.376
C12 Q VNB 0.31852f
C13 VGND VNB 1.52929f
C14 VPWR VNB 1.13604f
C15 D VNB 0.22199f
C16 CLK VNB 0.25867f
C17 VPB VNB 2.87731f
C18 a_141_36.t1 VNB 0.08497f
C19 a_141_36.t0 VNB 0.11932f
C20 a_141_36.n0 VNB 0.23451f
C21 a_141_36.t3 VNB 0.06687f
C22 a_141_36.n1 VNB 0.68044f
C23 a_141_36.t6 VNB 0.06837f
C24 a_141_36.n2 VNB 0.40147f
C25 a_141_36.t5 VNB 0.11518f
C26 a_141_36.n3 VNB 0.61651f
C27 a_141_36.t2 VNB 0.06273f
C28 a_141_36.n4 VNB 0.39699f
C29 a_141_36.t7 VNB 0.05098f
C30 a_141_36.t4 VNB 0.0337f
C31 a_141_36.n5 VNB 0.17376f
C32 a_393_36.t0 VNB 0.08997f
C33 a_393_36.t1 VNB 0.14571f
C34 a_393_36.n0 VNB 0.54668f
C35 a_393_36.t5 VNB 0.12793f
C36 a_393_36.n1 VNB 0.57024f
C37 a_393_36.t3 VNB 0.0695f
C38 a_393_36.n2 VNB 0.46632f
C39 a_393_36.n3 VNB 0.45059f
C40 a_393_36.t2 VNB 0.05366f
C41 a_393_36.t4 VNB 0.14475f
C42 a_1088_165.t0 VNB 0.01853f
C43 a_1088_165.n0 VNB 0.06273f
C44 a_1088_165.t1 VNB 0.0786f
C45 a_1088_165.t3 VNB 0.02316f
C46 a_1088_165.n1 VNB 0.09163f
C47 a_1088_165.n2 VNB 0.39515f
C48 a_1088_165.t5 VNB 0.05962f
C49 a_1088_165.t4 VNB 0.02503f
C50 a_1088_165.n3 VNB 0.14339f
C51 a_1088_165.t2 VNB 0.06984f
C52 a_753_36.t0 VNB 0.01772f
C53 a_753_36.n0 VNB 0.1065f
C54 a_753_36.t1 VNB 0.08348f
C55 a_753_36.t2 VNB 0.02215f
C56 a_753_36.n1 VNB 0.11694f
C57 a_753_36.n2 VNB 0.37187f
C58 a_753_36.t5 VNB 0.05245f
C59 a_753_36.t4 VNB 0.03744f
C60 a_753_36.n3 VNB 0.12185f
C61 a_753_36.t3 VNB 0.06678f
C62 a_1736_165.t1 VNB 0.0824f
C63 a_1736_165.t7 VNB 0.04316f
C64 a_1736_165.t4 VNB 0.01812f
C65 a_1736_165.n0 VNB 0.09658f
C66 a_1736_165.n1 VNB 0.18284f
C67 a_1736_165.t0 VNB 0.15491f
C68 a_1736_165.n2 VNB 0.29354f
C69 a_1736_165.t2 VNB 0.02451f
C70 a_1736_165.t5 VNB 0.04128f
C71 a_1736_165.n3 VNB 0.08694f
C72 a_1736_165.t3 VNB 0.02451f
C73 a_1736_165.t6 VNB 0.04128f
C74 a_1736_165.n4 VNB 0.13627f
C75 a_1401_36.t1 VNB 0.05994f
C76 a_1401_36.n0 VNB 0.0956f
C77 a_1401_36.t2 VNB 0.07493f
C78 a_1401_36.t0 VNB 0.01988f
C79 a_1401_36.n1 VNB 0.10496f
C80 a_1401_36.n2 VNB 0.33379f
C81 a_1401_36.t5 VNB 0.05333f
C82 a_1401_36.t4 VNB 0.0336f
C83 a_1401_36.n3 VNB 0.10312f
C84 a_1401_36.t3 VNB 0.0159f
C85 a_645_36.t3 VNB 0.01928f
C86 a_645_36.n0 VNB 0.28051f
C87 a_645_36.t1 VNB 0.0241f
C88 a_645_36.t0 VNB 0.0241f
C89 a_645_36.n1 VNB 0.14118f
C90 a_645_36.t2 VNB 0.02724f
C91 a_969_450.t0 VNB 0.02059f
C92 a_969_450.t1 VNB 0.02059f
C93 a_1617_450.t0 VNB 0.01939f
C94 a_1617_450.t1 VNB 0.01939f
C95 a_969_36.t0 VNB 0.01775f
C96 a_969_36.t1 VNB 0.0219f
C97 a_1617_36.t0 VNB 0.01663f
C98 a_1617_36.t1 VNB 0.02052f
C99 VPB.t12 VNB 0.15605f
C100 VPB.t11 VNB 0.15605f
C101 VPB.t10 VNB 0.15605f
C102 VPB.t9 VNB 0.12484f
C103 VPB.t1 VNB 0.17166f
C104 VPB.t7 VNB 0.15605f
C105 VPB.t0 VNB 0.10924f
C106 VPB.t8 VNB 0.12484f
C107 VPB.t4 VNB 0.17166f
C108 VPB.t2 VNB 0.14045f
C109 VPB.t5 VNB 0.15605f
C110 VPB.t3 VNB 0.21848f
C111 VPB.t6 VNB 0.16386f
C112 CLK.t1 VNB 0.04658f
C113 CLK.t0 VNB 0.0308f
C114 CLK.n0 VNB 0.14721f
C115 D.t1 VNB 0.05519f
C116 D.t0 VNB 0.05519f
C117 D.n0 VNB 0.22483f
C118 VPWR.n0 VNB 0.16864f
C119 VPWR.t7 VNB 0.05304f
C120 VPWR.n1 VNB 0.03461f
C121 VPWR.n2 VNB 0.01845f
C122 VPWR.n3 VNB 0.03691f
C123 VPWR.t6 VNB 0.02261f
C124 VPWR.t3 VNB 0.00625f
C125 VPWR.n4 VNB 0.02219f
C126 VPWR.n5 VNB 0.01845f
C127 VPWR.n6 VNB 0.03691f
C128 VPWR.n7 VNB 0.01845f
C129 VPWR.n8 VNB 0.03691f
C130 VPWR.t0 VNB 0.01256f
C131 VPWR.t2 VNB 0.00625f
C132 VPWR.n9 VNB 0.01763f
C133 VPWR.n10 VNB 0.01845f
C134 VPWR.n11 VNB 0.03691f
C135 VPWR.n12 VNB 0.01845f
C136 VPWR.n13 VNB 0.03691f
C137 VPWR.t4 VNB 0.02224f
C138 VPWR.n14 VNB 0.01845f
C139 VPWR.n15 VNB 0.03691f
C140 VPWR.t1 VNB 0.03207f
C141 VPWR.n16 VNB 0.01845f
C142 VPWR.n17 VNB 0.03332f
C143 VPWR.t5 VNB 0.03207f
C144 VPWR.n18 VNB 0.06051f
C145 VPWR.n19 VNB 0.01384f
C146 VPWR.n20 VNB 0.03691f
C147 VPWR.n21 VNB 0.03691f
C148 VPWR.n22 VNB 0.03691f
C149 VPWR.n23 VNB 0.01845f
C150 VPWR.n24 VNB 0.06154f
C151 VPWR.n25 VNB 0.01845f
C152 VPWR.n26 VNB 0.03691f
C153 VPWR.n27 VNB 0.03691f
C154 VPWR.n28 VNB 0.03691f
C155 VPWR.n29 VNB 0.01384f
C156 VPWR.n30 VNB 0.04331f
C157 VPWR.n31 VNB 0.01384f
C158 VPWR.n32 VNB 0.01845f
C159 VPWR.n33 VNB 0.03691f
C160 VPWR.n34 VNB 0.03691f
C161 VPWR.n35 VNB 0.03691f
C162 VPWR.n36 VNB 0.01845f
C163 VPWR.n37 VNB 0.01845f
C164 VPWR.n38 VNB 0.01845f
C165 VPWR.n39 VNB 0.03691f
C166 VPWR.n40 VNB 0.03691f
C167 VPWR.n41 VNB 0.03691f
C168 VPWR.n42 VNB 0.01845f
C169 VPWR.n43 VNB 0.05025f
C170 VPWR.n44 VNB 0.01845f
C171 VPWR.n45 VNB 0.03691f
C172 VPWR.n46 VNB 0.03691f
C173 VPWR.n47 VNB 0.03691f
C174 VPWR.n48 VNB 0.01845f
C175 VPWR.n49 VNB 0.01845f
C176 VPWR.n50 VNB 0.01845f
C177 VPWR.n51 VNB 0.03691f
C178 VPWR.n52 VNB 0.03691f
C179 VPWR.n53 VNB 0.03691f
C180 VPWR.n54 VNB 0.01845f
C181 VPWR.n55 VNB 0.01845f
C182 VPWR.n56 VNB 0.05025f
C183 VPWR.n57 VNB 0.03691f
C184 VPWR.n58 VNB 0.03691f
C185 VPWR.n59 VNB 0.03691f
C186 VPWR.n60 VNB 0.01845f
C187 VPWR.n61 VNB 0.01384f
C188 VPWR.n62 VNB 0.03682f
C189 VPWR.n63 VNB 0.08505f
C190 VPWR.t8 VNB 0.05304f
C191 VPWR.n64 VNB 0.04398f
C192 VGND.n0 VNB 0.03032f
C193 VGND.t3 VNB 0.01782f
C194 VGND.n1 VNB 0.01516f
C195 VGND.n2 VNB 0.03032f
C196 VGND.t0 VNB 0.01782f
C197 VGND.n3 VNB 0.01137f
C198 VGND.n4 VNB 0.03032f
C199 VGND.n5 VNB 0.01516f
C200 VGND.n6 VNB 0.03032f
C201 VGND.n7 VNB 0.01516f
C202 VGND.n8 VNB 0.03032f
C203 VGND.t4 VNB 0.00847f
C204 VGND.t1 VNB 0.00513f
C205 VGND.n9 VNB 0.01391f
C206 VGND.n10 VNB 0.01516f
C207 VGND.n11 VNB 0.03032f
C208 VGND.n12 VNB 0.01516f
C209 VGND.n13 VNB 0.03032f
C210 VGND.t5 VNB 0.00847f
C211 VGND.t8 VNB 0.00513f
C212 VGND.n14 VNB 0.01391f
C213 VGND.n15 VNB 0.01516f
C214 VGND.t7 VNB 0.02784f
C215 VGND.n16 VNB 0.09631f
C216 VGND.t6 VNB 0.0263f
C217 VGND.n17 VNB 0.05053f
C218 VGND.n18 VNB 0.01137f
C219 VGND.n19 VNB 0.13853f
C220 VGND.n20 VNB 0.03032f
C221 VGND.n21 VNB 0.03032f
C222 VGND.n22 VNB 0.01516f
C223 VGND.n23 VNB 0.03692f
C224 VGND.n24 VNB 0.01516f
C225 VGND.n25 VNB 0.03032f
C226 VGND.n26 VNB 0.03032f
C227 VGND.n27 VNB 0.03032f
C228 VGND.n28 VNB 0.01516f
C229 VGND.n29 VNB 0.01516f
C230 VGND.n30 VNB 0.01516f
C231 VGND.n31 VNB 0.03032f
C232 VGND.n32 VNB 0.03032f
C233 VGND.n33 VNB 0.03032f
C234 VGND.n34 VNB 0.01516f
C235 VGND.n35 VNB 0.01516f
C236 VGND.n36 VNB 0.03692f
C237 VGND.n37 VNB 0.03032f
C238 VGND.n38 VNB 0.03032f
C239 VGND.n39 VNB 0.03032f
C240 VGND.n40 VNB 0.01516f
C241 VGND.n41 VNB 0.01516f
C242 VGND.n42 VNB 0.01516f
C243 VGND.n43 VNB 0.03032f
C244 VGND.n44 VNB 0.03032f
C245 VGND.n45 VNB 0.03032f
C246 VGND.n46 VNB 0.01516f
C247 VGND.n47 VNB 0.01516f
C248 VGND.t2 VNB 0.01782f
C249 VGND.n48 VNB 0.03603f
C250 VGND.n49 VNB 0.01137f
C251 VGND.n50 VNB 0.03032f
C252 VGND.n51 VNB 0.03032f
C253 VGND.n52 VNB 0.03032f
C254 VGND.n53 VNB 0.01516f
C255 VGND.n54 VNB 0.01516f
C256 VGND.n55 VNB 0.04361f
C257 VGND.n56 VNB 0.03032f
C258 VGND.n57 VNB 0.03032f
C259 VGND.n58 VNB 0.03032f
C260 VGND.n59 VNB 0.01516f
C261 VGND.n60 VNB 0.01137f
C262 VGND.n61 VNB 0.04277f
C263 VGND.n62 VNB 0.02737f
C264 Q.t3 VNB 0.03403f
C265 Q.t0 VNB 0.03403f
C266 Q.n0 VNB 0.07267f
C267 Q.t2 VNB 0.01985f
C268 Q.t1 VNB 0.01985f
C269 Q.n1 VNB 0.04659f
.ends

.subckt sky130_efx_lvdig__dlygate4sd3_1 A X VGND VNB VPB VPWR
X0 X.t1 a_788_36.t2 VGND.t2 VNB.t2 sky130_fd_pr__nfet_01v8 ad=0.23625 pd=2.01 as=0.23625 ps=2.01 w=0.63 l=0.15
X1 a_464_36.t0 a_141_36.t3 VPWR.t3 VPB.t3 sky130_fd_pr__pfet_01v8_hvt ad=0.171 pd=1.66 as=0.171 ps=1.66 w=0.45 l=0.5
X2 a_788_36.t0 a_464_36.t2 VGND.t1 VNB.t1 sky130_fd_pr__nfet_01v8 ad=0.171 pd=1.66 as=0.171 ps=1.66 w=0.45 l=0.5
X3 a_788_36.t1 a_464_36.t3 VPWR.t2 VPB.t2 sky130_fd_pr__pfet_01v8_hvt ad=0.171 pd=1.66 as=0.171 ps=1.66 w=0.45 l=0.5
X4 a_141_36.t0 A.t1 VPWR.t0 VPB.t0 sky130_fd_pr__pfet_01v8_hvt ad=0.16875 pd=1.65 as=0.16875 ps=1.65 w=0.45 l=0.15
X5 X.t0 a_788_36.t3 VPWR.t1 VPB.t1 sky130_fd_pr__pfet_01v8_hvt ad=0.405 pd=2.91 as=0.405 ps=2.91 w=1.08 l=0.15
X6 a_141_36.t1 A.t0 VGND.t0 VNB.t0 sky130_fd_pr__nfet_01v8 ad=0.16875 pd=1.65 as=0.16875 ps=1.65 w=0.45 l=0.15
X7 a_464_36.t1 a_141_36.t2 VGND.t3 VNB.t3 sky130_fd_pr__nfet_01v8 ad=0.171 pd=1.66 as=0.171 ps=1.66 w=0.45 l=0.5
C0 X VPWR 0.13857f
C1 X VPB 0.01018f
C2 VGND A 0.04538f
C3 VGND VPWR 0.11363f
C4 VGND VPB 0.02434f
C5 VPWR A 0.03739f
C6 A VPB 0.11464f
C7 VGND X 0.10221f
C8 VPWR VPB 0.26331f
R0 VGND.n12 VGND.t3 254.333
R1 VGND.n5 VGND.t1 254.333
R2 VGND.n18 VGND.t0 253
R3 VGND.n4 VGND.t2 246.18
R4 VGND.n19 VGND.n18 15.7005
R5 VGND.n6 VGND.n3 12.8005
R6 VGND.n10 VGND.n3 12.8005
R7 VGND.n11 VGND.n10 12.8005
R8 VGND.n12 VGND.n11 12.8005
R9 VGND.n12 VGND.n1 12.8005
R10 VGND.n16 VGND.n1 12.8005
R11 VGND.n17 VGND.n16 12.8005
R12 VGND.n5 VGND.n4 12.5554
R13 VGND.n17 VGND.n0 9.3005
R14 VGND.n16 VGND.n15 9.3005
R15 VGND.n14 VGND.n1 9.3005
R16 VGND.n13 VGND.n12 9.3005
R17 VGND.n11 VGND.n2 9.3005
R18 VGND.n10 VGND.n9 9.3005
R19 VGND.n8 VGND.n3 9.3005
R20 VGND.n7 VGND.n6 9.3005
R21 VGND.n6 VGND.n5 6.4005
R22 VGND.n18 VGND.n17 6.4005
R23 VGND.n7 VGND.n4 0.165806
R24 VGND.n8 VGND.n7 0.063
R25 VGND.n9 VGND.n8 0.063
R26 VGND.n9 VGND.n2 0.063
R27 VGND.n13 VGND.n2 0.063
R28 VGND.n14 VGND.n13 0.063
R29 VGND.n15 VGND.n14 0.063
R30 VGND.n15 VGND.n0 0.063
R31 VGND.n19 VGND.n0 0.063
R32 VGND VGND.n19 0.03175
R33 X X.t0 366.469
R34 X X.t1 241.344
R35 VPWR.n12 VPWR.t3 685.356
R36 VPWR.n5 VPWR.t2 685.356
R37 VPWR.n18 VPWR.t0 683.168
R38 VPWR.n4 VPWR.t1 358.507
R39 VPWR.n19 VPWR.n18 15.7005
R40 VPWR.n6 VPWR.n3 12.8005
R41 VPWR.n10 VPWR.n3 12.8005
R42 VPWR.n11 VPWR.n10 12.8005
R43 VPWR.n12 VPWR.n11 12.8005
R44 VPWR.n12 VPWR.n1 12.8005
R45 VPWR.n16 VPWR.n1 12.8005
R46 VPWR.n17 VPWR.n16 12.8005
R47 VPWR.n5 VPWR.n4 12.5554
R48 VPWR.n17 VPWR.n0 9.3005
R49 VPWR.n16 VPWR.n15 9.3005
R50 VPWR.n14 VPWR.n1 9.3005
R51 VPWR.n13 VPWR.n12 9.3005
R52 VPWR.n11 VPWR.n2 9.3005
R53 VPWR.n10 VPWR.n9 9.3005
R54 VPWR.n8 VPWR.n3 9.3005
R55 VPWR.n7 VPWR.n6 9.3005
R56 VPWR.n6 VPWR.n5 6.4005
R57 VPWR.n18 VPWR.n17 6.4005
R58 VPWR.n7 VPWR.n4 0.165806
R59 VPWR.n8 VPWR.n7 0.063
R60 VPWR.n9 VPWR.n8 0.063
R61 VPWR.n9 VPWR.n2 0.063
R62 VPWR.n13 VPWR.n2 0.063
R63 VPWR.n14 VPWR.n13 0.063
R64 VPWR.n15 VPWR.n14 0.063
R65 VPWR.n15 VPWR.n0 0.063
R66 VPWR.n19 VPWR.n0 0.063
R67 VPWR VPWR.n19 0.03175
R68 A.n0 A.t1 348.647
R69 A.n0 A.t0 232.968
R70 A A.n0 158.4
R71 VPB.t3 VPB.t2 777.274
R72 VPB.t2 VPB.t1 690.909
R73 VPB.t0 VPB.t3 690.909
R74 VPB VPB.t0 302.274
R75 VNB.t3 VNB.t1 3600
R76 VNB.t1 VNB.t2 3200
R77 VNB.t0 VNB.t3 3200
R78 VNB VNB.t0 1400
R79 a_788_36.t0 a_788_36.n0 260.733
R80 a_788_36.n0 a_788_36.n1 177.601
R81 a_788_36.n1 a_788_36.t2 204.048
R82 a_788_36.n1 a_788_36.t3 247.428
R83 a_788_36.n0 a_788_36.t1 710.957
R84 a_464_36.t0 a_464_36.n0 710.957
R85 a_464_36.n0 a_464_36.n1 204.379
R86 a_464_36.n1 a_464_36.t2 82.4225
R87 a_464_36.n1 a_464_36.t3 117.126
R88 a_464_36.n0 a_464_36.t1 260.733
R89 a_141_36.t0 a_141_36.n0 708.768
R90 a_141_36.n0 a_141_36.n1 204.379
R91 a_141_36.n1 a_141_36.t2 82.4225
R92 a_141_36.n1 a_141_36.t3 117.126
R93 a_141_36.n0 a_141_36.t1 259.401
C9 VGND VNB 0.80493f
C10 X VNB 0.2997f
C11 VPWR VNB 0.57956f
C12 A VNB 0.26593f
C13 VPB VNB 1.41988f
C14 a_141_36.t0 VNB 0.05402f
C15 a_141_36.t1 VNB 0.05213f
C16 a_141_36.n0 VNB 0.37452f
C17 a_141_36.n1 VNB 0.21196f
C18 a_141_36.t3 VNB 0.10505f
C19 a_141_36.t2 VNB 0.07607f
C20 a_464_36.t0 VNB 0.05473f
C21 a_464_36.t1 VNB 0.05274f
C22 a_464_36.n0 VNB 0.37603f
C23 a_464_36.n1 VNB 0.21256f
C24 a_464_36.t3 VNB 0.10535f
C25 a_464_36.t2 VNB 0.07629f
C26 a_788_36.t0 VNB 0.05466f
C27 a_788_36.t1 VNB 0.05672f
C28 a_788_36.n0 VNB 0.38408f
C29 a_788_36.t3 VNB 0.03838f
C30 a_788_36.t2 VNB 0.0239f
C31 a_788_36.n1 VNB 0.10253f
C32 VPB.t1 VNB 0.21986f
C33 VPB.t2 VNB 0.24917f
C34 VPB.t3 VNB 0.24917f
C35 VPB.t0 VNB 0.16856f
C36 A.t1 VNB 0.04523f
C37 A.t0 VNB 0.03221f
C38 A.n0 VNB 0.15744f
C39 VPWR.n0 VNB 0.03552f
C40 VPWR.t0 VNB 0.0214f
C41 VPWR.n1 VNB 0.01776f
C42 VPWR.n2 VNB 0.03552f
C43 VPWR.t3 VNB 0.02164f
C44 VPWR.n3 VNB 0.01776f
C45 VPWR.t1 VNB 0.05601f
C46 VPWR.n4 VNB 0.2896f
C47 VPWR.t2 VNB 0.02164f
C48 VPWR.n5 VNB 0.05211f
C49 VPWR.n6 VNB 0.01332f
C50 VPWR.n7 VNB 0.16575f
C51 VPWR.n8 VNB 0.03552f
C52 VPWR.n9 VNB 0.03552f
C53 VPWR.n10 VNB 0.01776f
C54 VPWR.n11 VNB 0.01776f
C55 VPWR.n12 VNB 0.05063f
C56 VPWR.n13 VNB 0.03552f
C57 VPWR.n14 VNB 0.03552f
C58 VPWR.n15 VNB 0.03552f
C59 VPWR.n16 VNB 0.01776f
C60 VPWR.n17 VNB 0.01332f
C61 VPWR.n18 VNB 0.04957f
C62 VPWR.n19 VNB 0.03207f
C63 X.t0 VNB 0.08684f
C64 X.t1 VNB 0.04739f
C65 VGND.n0 VNB 0.02791f
C66 VGND.t0 VNB 0.0164f
C67 VGND.n1 VNB 0.01396f
C68 VGND.n2 VNB 0.02791f
C69 VGND.t3 VNB 0.01656f
C70 VGND.n3 VNB 0.01396f
C71 VGND.t2 VNB 0.02551f
C72 VGND.n4 VNB 0.21044f
C73 VGND.t1 VNB 0.01656f
C74 VGND.n5 VNB 0.0414f
C75 VGND.n6 VNB 0.01047f
C76 VGND.n7 VNB 0.13024f
C77 VGND.n8 VNB 0.02791f
C78 VGND.n9 VNB 0.02791f
C79 VGND.n10 VNB 0.01396f
C80 VGND.n11 VNB 0.01396f
C81 VGND.n12 VNB 0.04023f
C82 VGND.n13 VNB 0.02791f
C83 VGND.n14 VNB 0.02791f
C84 VGND.n15 VNB 0.02791f
C85 VGND.n16 VNB 0.01396f
C86 VGND.n17 VNB 0.01047f
C87 VGND.n18 VNB 0.03937f
C88 VGND.n19 VNB 0.0252f
.ends

.subckt sky130_efx_lvdig__edfxbp_1 CLK D DE Q Q_N VGND VNB VPB VPWR
X0 a_936_288.t0 a_2697_36.t4 VGND.t6 VNB.t7 sky130_fd_pr__nfet_01v8 ad=0.16875 pd=1.65 as=0.16875 ps=1.65 w=0.45 l=0.15
X1 a_249_36.t0 D.t0 a_144_36.t3 VNB.t10 sky130_fd_pr__nfet_01v8 ad=0.08775 pd=0.84 as=0.16875 ps=1.65 w=0.45 l=0.15
X2 VGND.t1 DE.t1 a_249_36.t1 VNB.t16 sky130_fd_pr__nfet_01v8 ad=0.16875 pd=1.65 as=0.08775 ps=0.84 w=0.45 l=0.15
X3 a_2697_36.t1 a_1509_36.t2 a_2553_36.t0 VNB.t2 sky130_fd_pr__special_nfet_01v8 ad=0.1674 pd=1.29 as=0.11542 ps=1.02 w=0.36 l=0.15
X4 a_2913_36.t0 a_1257_36.t2 a_2697_36.t3 VNB.t8 sky130_fd_pr__special_nfet_01v8 ad=0.15593 pd=1.2 as=0.1674 ps=1.29 w=0.36 l=0.15
X5 Q_N.t1 a_936_288.t4 VPWR.t7 VPB.t11 sky130_fd_pr__pfet_01v8_hvt ad=0.405 pd=2.91 as=0.405 ps=2.91 w=1.08 l=0.15
X6 a_861_36.t1 a_324_288.t2 VGND.t10 VNB.t14 sky130_fd_pr__nfet_01v8 ad=0.08775 pd=0.84 as=0.16875 ps=1.65 w=0.45 l=0.15
X7 a_1977_36.t1 a_1509_36.t3 a_1761_36.t0 VNB.t4 sky130_fd_pr__special_nfet_01v8 ad=0.15593 pd=1.2 as=0.1674 ps=1.29 w=0.36 l=0.15
X8 a_1509_36.t1 a_1257_36.t7 VPWR.t6 VPB.t10 sky130_fd_pr__pfet_01v8_hvt ad=0.23625 pd=2.01 as=0.23625 ps=2.01 w=0.63 l=0.15
X9 VPWR.t3 a_2096_165.t5 a_1977_450.t0 VPB.t4 sky130_fd_pr__pfet_01v8_hvt ad=0.12622 pd=1.11 as=0.16875 ps=1.2 w=0.45 l=0.15
X10 Q_N.t0 a_936_288.t2 VGND.t8 VNB.t11 sky130_fd_pr__nfet_01v8 ad=0.23625 pd=2.01 as=0.23625 ps=2.01 w=0.63 l=0.15
X11 a_249_414.t0 D.t1 a_144_36.t2 VPB.t9 sky130_fd_pr__pfet_01v8_hvt ad=0.12285 pd=1.02 as=0.23625 ps=2.01 w=0.63 l=0.15
X12 a_2553_450.t1 a_2096_165.t4 VPWR.t5 VPB.t7 sky130_fd_pr__pfet_01v8_hvt ad=0.12825 pd=1.02 as=0.16875 ps=1.65 w=0.45 l=0.15
X13 VGND.t5 DE.t0 a_324_288.t0 VNB.t17 sky130_fd_pr__nfet_01v8 ad=0.16875 pd=1.65 as=0.16875 ps=1.65 w=0.45 l=0.15
X14 VPWR.t9 a_324_288.t3 a_249_414.t1 VPB.t14 sky130_fd_pr__pfet_01v8_hvt ad=0.23625 pd=2.01 as=0.12285 ps=1.02 w=0.63 l=0.15
X15 a_1761_36.t3 a_1509_36.t5 a_144_36.t1 VPB.t8 sky130_fd_pr__pfet_01v8_hvt ad=0.20925 pd=1.38 as=0.16875 ps=1.65 w=0.45 l=0.15
X16 a_936_288.t1 a_2697_36.t6 VPWR.t4 VPB.t5 sky130_fd_pr__pfet_01v8_hvt ad=0.23625 pd=2.01 as=0.23625 ps=2.01 w=0.63 l=0.15
X17 VGND.t9 a_936_288.t3 a_2913_36.t1 VNB.t12 sky130_fd_pr__nfet_01v8 ad=0.16875 pd=1.65 as=0.15593 ps=1.2 w=0.45 l=0.15
X18 a_2096_165.t1 a_1761_36.t5 VPWR.t2 VPB.t3 sky130_fd_pr__pfet_01v8_hvt ad=0.3996 pd=2.55 as=0.12622 ps=1.11 w=0.72 l=0.15
X19 a_861_414.t1 DE.t2 VPWR.t0 VPB.t17 sky130_fd_pr__pfet_01v8_hvt ad=0.12285 pd=1.02 as=0.23625 ps=2.01 w=0.63 l=0.15
X20 VPWR.t8 a_936_288.t6 a_2913_450.t1 VPB.t12 sky130_fd_pr__pfet_01v8_hvt ad=0.16875 pd=1.65 as=0.16875 ps=1.2 w=0.45 l=0.15
X21 VGND.t0 a_2096_165.t3 a_1977_36.t0 VNB.t0 sky130_fd_pr__nfet_01v8 ad=0.1134 pd=1.02 as=0.15593 ps=1.2 w=0.45 l=0.15
X22 a_2096_165.t0 a_1761_36.t4 VGND.t2 VNB.t1 sky130_fd_pr__nfet_01v8 ad=0.34965 pd=2.37 as=0.1134 ps=1.02 w=0.63 l=0.15
X23 a_1977_450.t1 a_1257_36.t6 a_1761_36.t2 VPB.t6 sky130_fd_pr__pfet_01v8_hvt ad=0.16875 pd=1.2 as=0.20925 ps=1.38 w=0.45 l=0.15
X24 a_144_36.t4 a_936_288.t5 a_861_36.t0 VNB.t13 sky130_fd_pr__nfet_01v8 ad=0.16875 pd=1.65 as=0.08775 ps=0.84 w=0.45 l=0.15
X25 a_1257_36.t0 CLK.t0 VGND.t11 VNB.t15 sky130_fd_pr__nfet_01v8 ad=0.16875 pd=1.65 as=0.16875 ps=1.65 w=0.45 l=0.15
X26 Q.t0 a_2697_36.t5 VGND.t3 VNB.t3 sky130_fd_pr__nfet_01v8 ad=0.23625 pd=2.01 as=0.23625 ps=2.01 w=0.63 l=0.15
X27 a_144_36.t5 a_936_288.t7 a_861_414.t0 VPB.t13 sky130_fd_pr__pfet_01v8_hvt ad=0.23625 pd=2.01 as=0.12285 ps=1.02 w=0.63 l=0.15
X28 a_2553_36.t1 a_2096_165.t2 VGND.t7 VNB.t9 sky130_fd_pr__nfet_01v8 ad=0.11542 pd=1.02 as=0.16875 ps=1.65 w=0.45 l=0.15
X29 a_2697_36.t2 a_1257_36.t5 a_2553_450.t0 VPB.t2 sky130_fd_pr__pfet_01v8_hvt ad=0.20925 pd=1.38 as=0.12825 ps=1.02 w=0.45 l=0.15
X30 a_1761_36.t1 a_1257_36.t3 a_144_36.t0 VNB.t6 sky130_fd_pr__special_nfet_01v8 ad=0.1674 pd=1.29 as=0.135 ps=1.47 w=0.36 l=0.15
X31 a_1257_36.t1 CLK.t1 VPWR.t10 VPB.t15 sky130_fd_pr__pfet_01v8_hvt ad=0.23625 pd=2.01 as=0.23625 ps=2.01 w=0.63 l=0.15
X32 VPWR.t11 DE.t3 a_324_288.t1 VPB.t16 sky130_fd_pr__pfet_01v8_hvt ad=0.23625 pd=2.01 as=0.23625 ps=2.01 w=0.63 l=0.15
X33 Q.t1 a_2697_36.t7 VPWR.t1 VPB.t1 sky130_fd_pr__pfet_01v8_hvt ad=0.405 pd=2.91 as=0.405 ps=2.91 w=1.08 l=0.15
X34 a_2913_450.t0 a_1509_36.t4 a_2697_36.t0 VPB.t0 sky130_fd_pr__pfet_01v8_hvt ad=0.16875 pd=1.2 as=0.20925 ps=1.38 w=0.45 l=0.15
X35 a_1509_36.t0 a_1257_36.t4 VGND.t4 VNB.t5 sky130_fd_pr__nfet_01v8 ad=0.16875 pd=1.65 as=0.16875 ps=1.65 w=0.45 l=0.15
C0 Q_N VPB 0.01018f
C1 D DE 0.02996f
C2 VGND D 0.01622f
C3 D VPWR 0.02183f
C4 D VPB 0.09247f
C5 VGND DE 0.05794f
C6 VGND CLK 0.03978f
C7 VPWR DE 0.10418f
C8 CLK VPWR 0.03739f
C9 VGND VPWR 0.07322f
C10 VPB DE 0.23954f
C11 CLK VPB 0.10634f
C12 VGND VPB 0.04115f
C13 VPWR VPB 0.82238f
C14 Q VGND 0.12234f
C15 Q VPWR 0.15781f
C16 Q_N VGND 0.10221f
C17 Q_N VPWR 0.13857f
C18 Q VPB 0.02034f
R0 Q_N Q_N.t1 344.07
R1 Q_N.n0 Q_N.t0 222.143
R2 Q_N Q_N.n0 19.2005
R3 Q_N.n0 Q_N 9.6005
R4 Q Q.t1 344.07
R5 Q.n0 Q.t0 222.143
R6 Q.n0 Q 28.8005
R7 Q Q.n0 9.6005
R8 VGND.n89 VGND.t9 253
R9 VGND.n76 VGND.t7 253
R10 VGND.n24 VGND.t11 253
R11 VGND.n30 VGND.t1 253
R12 VGND.n4 VGND.t6 253
R13 VGND.n23 VGND.t4 253
R14 VGND.n40 VGND.t10 249.8
R15 VGND.n28 VGND.t5 249.8
R16 VGND VGND.t8 231.744
R17 VGND VGND.t3 231.744
R18 VGND.n70 VGND.n16 197.8
R19 VGND.n16 VGND.t0 52.0005
R20 VGND.n16 VGND.t2 40.9529
R21 VGND.n3 VGND 14.2304
R22 VGND.n6 VGND.n5 12.8005
R23 VGND.n6 VGND.n0 12.8005
R24 VGND.n93 VGND.n0 12.8005
R25 VGND.n93 VGND.n1 12.8005
R26 VGND.n89 VGND.n1 12.8005
R27 VGND.n89 VGND.n88 12.8005
R28 VGND.n88 VGND.n87 12.8005
R29 VGND.n87 VGND.n10 12.8005
R30 VGND.n83 VGND.n10 12.8005
R31 VGND.n83 VGND.n82 12.8005
R32 VGND.n82 VGND.n81 12.8005
R33 VGND.n81 VGND.n12 12.8005
R34 VGND.n77 VGND.n12 12.8005
R35 VGND.n77 VGND.n76 12.8005
R36 VGND.n76 VGND.n75 12.8005
R37 VGND.n75 VGND.n14 12.8005
R38 VGND.n71 VGND.n14 12.8005
R39 VGND.n71 VGND.n70 12.8005
R40 VGND.n70 VGND.n69 12.8005
R41 VGND.n69 VGND.n17 12.8005
R42 VGND.n65 VGND.n17 12.8005
R43 VGND.n65 VGND.n64 12.8005
R44 VGND.n64 VGND.n63 12.8005
R45 VGND.n63 VGND.n19 12.8005
R46 VGND.n59 VGND.n19 12.8005
R47 VGND.n59 VGND.n58 12.8005
R48 VGND.n58 VGND.n57 12.8005
R49 VGND.n57 VGND.n21 12.8005
R50 VGND.n53 VGND.n52 12.8005
R51 VGND.n52 VGND.n51 12.8005
R52 VGND.n51 VGND.n24 12.8005
R53 VGND.n47 VGND.n24 12.8005
R54 VGND.n47 VGND.n46 12.8005
R55 VGND.n46 VGND.n45 12.8005
R56 VGND.n45 VGND.n26 12.8005
R57 VGND.n41 VGND.n26 12.8005
R58 VGND.n39 VGND.n38 12.8005
R59 VGND.n35 VGND.n34 12.8005
R60 VGND.n34 VGND.n33 12.8005
R61 VGND.n33 VGND.n30 12.8005
R62 VGND.n4 VGND.n3 12.4081
R63 VGND VGND.n93 9.6005
R64 VGND.n33 VGND.n32 9.3005
R65 VGND.n34 VGND.n29 9.3005
R66 VGND.n36 VGND.n35 9.3005
R67 VGND.n38 VGND.n37 9.3005
R68 VGND.n39 VGND.n27 9.3005
R69 VGND.n42 VGND.n41 9.3005
R70 VGND.n43 VGND.n26 9.3005
R71 VGND.n45 VGND.n44 9.3005
R72 VGND.n46 VGND.n25 9.3005
R73 VGND.n48 VGND.n47 9.3005
R74 VGND.n49 VGND.n24 9.3005
R75 VGND.n51 VGND.n50 9.3005
R76 VGND.n52 VGND.n22 9.3005
R77 VGND.n54 VGND.n53 9.3005
R78 VGND.n55 VGND.n21 9.3005
R79 VGND.n57 VGND.n56 9.3005
R80 VGND.n58 VGND.n20 9.3005
R81 VGND.n60 VGND.n59 9.3005
R82 VGND.n61 VGND.n19 9.3005
R83 VGND.n63 VGND.n62 9.3005
R84 VGND.n64 VGND.n18 9.3005
R85 VGND.n66 VGND.n65 9.3005
R86 VGND.n67 VGND.n17 9.3005
R87 VGND.n69 VGND.n68 9.3005
R88 VGND.n70 VGND.n15 9.3005
R89 VGND.n72 VGND.n71 9.3005
R90 VGND.n73 VGND.n14 9.3005
R91 VGND.n75 VGND.n74 9.3005
R92 VGND.n76 VGND.n13 9.3005
R93 VGND.n78 VGND.n77 9.3005
R94 VGND.n79 VGND.n12 9.3005
R95 VGND.n81 VGND.n80 9.3005
R96 VGND.n82 VGND.n11 9.3005
R97 VGND.n84 VGND.n83 9.3005
R98 VGND.n85 VGND.n10 9.3005
R99 VGND.n87 VGND.n86 9.3005
R100 VGND.n88 VGND.n9 9.3005
R101 VGND.n90 VGND.n89 9.3005
R102 VGND.n91 VGND.n1 9.3005
R103 VGND.n93 VGND.n92 9.3005
R104 VGND.n8 VGND.n0 9.3005
R105 VGND.n7 VGND.n6 9.3005
R106 VGND.n5 VGND.n2 9.3005
R107 VGND.n5 VGND.n4 6.4005
R108 VGND.n23 VGND.n21 6.4005
R109 VGND.n53 VGND.n23 6.4005
R110 VGND.n41 VGND.n40 6.4005
R111 VGND.n40 VGND.n39 6.4005
R112 VGND.n38 VGND.n28 6.4005
R113 VGND.n35 VGND.n28 6.4005
R114 VGND.n31 VGND.n30 6.2273
R115 VGND.n31 VGND 0.31702
R116 VGND.n3 VGND.n2 0.313143
R117 VGND.n32 VGND.n31 0.0939888
R118 VGND.n7 VGND.n2 0.063
R119 VGND.n8 VGND.n7 0.063
R120 VGND.n92 VGND.n8 0.063
R121 VGND.n92 VGND.n91 0.063
R122 VGND.n91 VGND.n90 0.063
R123 VGND.n90 VGND.n9 0.063
R124 VGND.n86 VGND.n9 0.063
R125 VGND.n86 VGND.n85 0.063
R126 VGND.n85 VGND.n84 0.063
R127 VGND.n84 VGND.n11 0.063
R128 VGND.n80 VGND.n11 0.063
R129 VGND.n80 VGND.n79 0.063
R130 VGND.n79 VGND.n78 0.063
R131 VGND.n78 VGND.n13 0.063
R132 VGND.n74 VGND.n13 0.063
R133 VGND.n74 VGND.n73 0.063
R134 VGND.n73 VGND.n72 0.063
R135 VGND.n72 VGND.n15 0.063
R136 VGND.n68 VGND.n15 0.063
R137 VGND.n68 VGND.n67 0.063
R138 VGND.n67 VGND.n66 0.063
R139 VGND.n66 VGND.n18 0.063
R140 VGND.n62 VGND.n18 0.063
R141 VGND.n62 VGND.n61 0.063
R142 VGND.n61 VGND.n60 0.063
R143 VGND.n60 VGND.n20 0.063
R144 VGND.n56 VGND.n20 0.063
R145 VGND.n56 VGND.n55 0.063
R146 VGND.n55 VGND.n54 0.063
R147 VGND.n54 VGND.n22 0.063
R148 VGND.n50 VGND.n22 0.063
R149 VGND.n50 VGND.n49 0.063
R150 VGND.n49 VGND.n48 0.063
R151 VGND.n48 VGND.n25 0.063
R152 VGND.n44 VGND.n25 0.063
R153 VGND.n44 VGND.n43 0.063
R154 VGND.n43 VGND.n42 0.063
R155 VGND.n42 VGND.n27 0.063
R156 VGND.n37 VGND.n27 0.063
R157 VGND.n37 VGND.n36 0.063
R158 VGND.n36 VGND.n29 0.063
R159 VGND.n32 VGND.n29 0.063
R160 VPWR.n90 VPWR.t8 683.168
R161 VPWR.n77 VPWR.t5 683.168
R162 VPWR.n25 VPWR.t10 661.976
R163 VPWR.n31 VPWR.t9 661.976
R164 VPWR.n29 VPWR.t11 661.976
R165 VPWR.n41 VPWR.t0 661.976
R166 VPWR.n24 VPWR.t6 661.976
R167 VPWR.n5 VPWR.t4 661.976
R168 VPWR.n71 VPWR.n17 597.801
R169 VPWR.n3 VPWR.t7 328.07
R170 VPWR.n95 VPWR.t1 328.07
R171 VPWR.n17 VPWR.t3 85.3672
R172 VPWR.n17 VPWR.t2 61.563
R173 VPWR.n4 VPWR.n3 30.2304
R174 VPWR.n95 VPWR.n94 25.6005
R175 VPWR.n3 VPWR 16.0005
R176 VPWR VPWR.n95 16.0005
R177 VPWR.n7 VPWR.n6 12.8005
R178 VPWR.n7 VPWR.n0 12.8005
R179 VPWR.n94 VPWR.n0 12.8005
R180 VPWR.n94 VPWR.n1 12.8005
R181 VPWR.n90 VPWR.n1 12.8005
R182 VPWR.n90 VPWR.n89 12.8005
R183 VPWR.n89 VPWR.n88 12.8005
R184 VPWR.n88 VPWR.n11 12.8005
R185 VPWR.n84 VPWR.n11 12.8005
R186 VPWR.n84 VPWR.n83 12.8005
R187 VPWR.n83 VPWR.n82 12.8005
R188 VPWR.n82 VPWR.n13 12.8005
R189 VPWR.n78 VPWR.n13 12.8005
R190 VPWR.n78 VPWR.n77 12.8005
R191 VPWR.n77 VPWR.n76 12.8005
R192 VPWR.n76 VPWR.n15 12.8005
R193 VPWR.n72 VPWR.n15 12.8005
R194 VPWR.n72 VPWR.n71 12.8005
R195 VPWR.n71 VPWR.n70 12.8005
R196 VPWR.n70 VPWR.n18 12.8005
R197 VPWR.n66 VPWR.n18 12.8005
R198 VPWR.n66 VPWR.n65 12.8005
R199 VPWR.n65 VPWR.n64 12.8005
R200 VPWR.n64 VPWR.n20 12.8005
R201 VPWR.n60 VPWR.n20 12.8005
R202 VPWR.n60 VPWR.n59 12.8005
R203 VPWR.n59 VPWR.n58 12.8005
R204 VPWR.n58 VPWR.n22 12.8005
R205 VPWR.n54 VPWR.n53 12.8005
R206 VPWR.n53 VPWR.n52 12.8005
R207 VPWR.n52 VPWR.n25 12.8005
R208 VPWR.n48 VPWR.n25 12.8005
R209 VPWR.n48 VPWR.n47 12.8005
R210 VPWR.n47 VPWR.n46 12.8005
R211 VPWR.n46 VPWR.n27 12.8005
R212 VPWR.n42 VPWR.n27 12.8005
R213 VPWR.n40 VPWR.n39 12.8005
R214 VPWR.n36 VPWR.n35 12.8005
R215 VPWR.n35 VPWR.n34 12.8005
R216 VPWR.n34 VPWR.n31 12.8005
R217 VPWR.n5 VPWR.n4 12.4081
R218 VPWR.n34 VPWR.n33 9.3005
R219 VPWR.n35 VPWR.n30 9.3005
R220 VPWR.n37 VPWR.n36 9.3005
R221 VPWR.n39 VPWR.n38 9.3005
R222 VPWR.n40 VPWR.n28 9.3005
R223 VPWR.n43 VPWR.n42 9.3005
R224 VPWR.n44 VPWR.n27 9.3005
R225 VPWR.n46 VPWR.n45 9.3005
R226 VPWR.n47 VPWR.n26 9.3005
R227 VPWR.n49 VPWR.n48 9.3005
R228 VPWR.n50 VPWR.n25 9.3005
R229 VPWR.n52 VPWR.n51 9.3005
R230 VPWR.n53 VPWR.n23 9.3005
R231 VPWR.n55 VPWR.n54 9.3005
R232 VPWR.n56 VPWR.n22 9.3005
R233 VPWR.n58 VPWR.n57 9.3005
R234 VPWR.n59 VPWR.n21 9.3005
R235 VPWR.n61 VPWR.n60 9.3005
R236 VPWR.n62 VPWR.n20 9.3005
R237 VPWR.n64 VPWR.n63 9.3005
R238 VPWR.n65 VPWR.n19 9.3005
R239 VPWR.n67 VPWR.n66 9.3005
R240 VPWR.n68 VPWR.n18 9.3005
R241 VPWR.n70 VPWR.n69 9.3005
R242 VPWR.n71 VPWR.n16 9.3005
R243 VPWR.n73 VPWR.n72 9.3005
R244 VPWR.n74 VPWR.n15 9.3005
R245 VPWR.n76 VPWR.n75 9.3005
R246 VPWR.n77 VPWR.n14 9.3005
R247 VPWR.n79 VPWR.n78 9.3005
R248 VPWR.n80 VPWR.n13 9.3005
R249 VPWR.n82 VPWR.n81 9.3005
R250 VPWR.n83 VPWR.n12 9.3005
R251 VPWR.n85 VPWR.n84 9.3005
R252 VPWR.n86 VPWR.n11 9.3005
R253 VPWR.n88 VPWR.n87 9.3005
R254 VPWR.n89 VPWR.n10 9.3005
R255 VPWR.n91 VPWR.n90 9.3005
R256 VPWR.n92 VPWR.n1 9.3005
R257 VPWR.n94 VPWR.n93 9.3005
R258 VPWR.n9 VPWR.n0 9.3005
R259 VPWR.n8 VPWR.n7 9.3005
R260 VPWR.n6 VPWR.n2 9.3005
R261 VPWR.n6 VPWR.n5 6.4005
R262 VPWR.n24 VPWR.n22 6.4005
R263 VPWR.n54 VPWR.n24 6.4005
R264 VPWR.n42 VPWR.n41 6.4005
R265 VPWR.n41 VPWR.n40 6.4005
R266 VPWR.n39 VPWR.n29 6.4005
R267 VPWR.n36 VPWR.n29 6.4005
R268 VPWR.n32 VPWR.n31 6.2273
R269 VPWR.n32 VPWR 0.31702
R270 VPWR.n4 VPWR.n2 0.313143
R271 VPWR.n33 VPWR.n32 0.0939888
R272 VPWR.n8 VPWR.n2 0.063
R273 VPWR.n9 VPWR.n8 0.063
R274 VPWR.n93 VPWR.n9 0.063
R275 VPWR.n93 VPWR.n92 0.063
R276 VPWR.n92 VPWR.n91 0.063
R277 VPWR.n91 VPWR.n10 0.063
R278 VPWR.n87 VPWR.n10 0.063
R279 VPWR.n87 VPWR.n86 0.063
R280 VPWR.n86 VPWR.n85 0.063
R281 VPWR.n85 VPWR.n12 0.063
R282 VPWR.n81 VPWR.n12 0.063
R283 VPWR.n81 VPWR.n80 0.063
R284 VPWR.n80 VPWR.n79 0.063
R285 VPWR.n79 VPWR.n14 0.063
R286 VPWR.n75 VPWR.n14 0.063
R287 VPWR.n75 VPWR.n74 0.063
R288 VPWR.n74 VPWR.n73 0.063
R289 VPWR.n73 VPWR.n16 0.063
R290 VPWR.n69 VPWR.n16 0.063
R291 VPWR.n69 VPWR.n68 0.063
R292 VPWR.n68 VPWR.n67 0.063
R293 VPWR.n67 VPWR.n19 0.063
R294 VPWR.n63 VPWR.n19 0.063
R295 VPWR.n63 VPWR.n62 0.063
R296 VPWR.n62 VPWR.n61 0.063
R297 VPWR.n61 VPWR.n21 0.063
R298 VPWR.n57 VPWR.n21 0.063
R299 VPWR.n57 VPWR.n56 0.063
R300 VPWR.n56 VPWR.n55 0.063
R301 VPWR.n55 VPWR.n23 0.063
R302 VPWR.n51 VPWR.n23 0.063
R303 VPWR.n51 VPWR.n50 0.063
R304 VPWR.n50 VPWR.n49 0.063
R305 VPWR.n49 VPWR.n26 0.063
R306 VPWR.n45 VPWR.n26 0.063
R307 VPWR.n45 VPWR.n44 0.063
R308 VPWR.n44 VPWR.n43 0.063
R309 VPWR.n43 VPWR.n28 0.063
R310 VPWR.n38 VPWR.n28 0.063
R311 VPWR.n38 VPWR.n37 0.063
R312 VPWR.n37 VPWR.n30 0.063
R313 VPWR.n33 VPWR.n30 0.063
R314 CLK.n0 CLK.t1 319.728
R315 CLK.n0 CLK.t0 232.968
R316 CLK CLK.n0 158.4
R317 DE.n1 DE.t1 269.921
R318 DE.n0 DE.t2 238.59
R319 DE DE.n2 158.4
R320 DE.n0 DE.t3 146.667
R321 DE.n1 DE.t0 101.221
R322 DE.n2 DE.n0 49.5776
R323 DE.n2 DE.n1 17.1957
R324 D.n0 D.t1 319.728
R325 D.n0 D.t0 232.968
R326 D D.n0 158.4
R327 VPB.t3 VPB.t7 690.909
R328 VPB.t13 VPB.t15 690.909
R329 VPB.t5 VPB.t11 604.545
R330 VPB.t1 VPB.t5 604.545
R331 VPB.t12 VPB.t1 604.545
R332 VPB.t10 VPB.t8 604.545
R333 VPB.t15 VPB.t10 604.545
R334 VPB.t16 VPB.t17 604.545
R335 VPB.t14 VPB.t16 604.545
R336 VPB VPB.t9 561.365
R337 VPB.t2 VPB.t0 518.183
R338 VPB.t8 VPB.t6 518.183
R339 VPB.t0 VPB.t12 431.818
R340 VPB.t6 VPB.t4 431.818
R341 VPB.t7 VPB.t2 345.455
R342 VPB.t4 VPB.t3 259.091
R343 VPB.t17 VPB.t13 259.091
R344 VPB.t9 VPB.t14 259.091
R345 VNB.t1 VNB.t9 3200
R346 VNB.t13 VNB.t15 3200
R347 VNB.t7 VNB.t11 2800
R348 VNB.t3 VNB.t7 2800
R349 VNB.t12 VNB.t3 2800
R350 VNB.t5 VNB.t6 2800
R351 VNB.t15 VNB.t5 2800
R352 VNB.t17 VNB.t14 2800
R353 VNB.t16 VNB.t17 2800
R354 VNB VNB.t10 2600
R355 VNB.t2 VNB.t8 2400
R356 VNB.t6 VNB.t4 2400
R357 VNB.t8 VNB.t12 2000
R358 VNB.t4 VNB.t0 2000
R359 VNB.t9 VNB.t2 1600
R360 VNB.t0 VNB.t1 1200
R361 VNB.t14 VNB.t13 1200
R362 VNB.t10 VNB.t16 1200
R363 a_2913_36.t0 a_2913_36.t1 219
R364 a_2553_36.t0 a_2553_36.t1 180.667
R365 a_1977_36.t1 a_1977_36.t0 219
R366 a_861_36.t0 a_861_36.t1 104.001
R367 a_249_36.t0 a_249_36.t1 104.001
R368 a_2913_450.t0 a_2913_450.t1 328.334
R369 a_2553_450.t0 a_2553_450.t1 249.534
R370 a_1977_450.t0 a_1977_450.t1 328.334
R371 a_861_414.t0 a_861_414.t1 121.953
R372 a_249_414.t0 a_249_414.t1 121.953
R373 a_144_36.t0 a_144_36.n0 253.556
R374 a_144_36.n0 a_144_36.t1 906.457
R375 a_144_36.n3 a_144_36.n2 9.3005
R376 a_144_36.n3 a_144_36.n1 11.6309
R377 a_144_36.n0 a_144_36.n3 10.6264
R378 a_144_36.n2 a_144_36.t4 253
R379 a_144_36.n2 a_144_36.t5 789.976
R380 a_144_36.n1 a_144_36.t3 259.401
R381 a_144_36.n1 a_144_36.t2 796.376
R382 a_2697_36.t1 a_2697_36.n0 245
R383 a_2697_36.n0 a_2697_36.t3 65.0005
R384 a_2697_36.n0 a_2697_36.n2 242.601
R385 a_2697_36.n2 a_2697_36.n3 318.401
R386 a_2697_36.n3 a_2697_36.n4 168.701
R387 a_2697_36.n4 a_2697_36.t6 303.661
R388 a_2697_36.n4 a_2697_36.t4 216.9
R389 a_2697_36.n3 a_2697_36.t5 187.981
R390 a_2697_36.n3 a_2697_36.t7 231.361
R391 a_2697_36.n2 a_2697_36.n1 652.201
R392 a_2697_36.n1 a_2697_36.t2 321.767
R393 a_2697_36.n1 a_2697_36.t0 85.3672
R394 a_1761_36.n0 a_1761_36.t1 245
R395 a_1761_36.t0 a_1761_36.n0 65.0005
R396 a_1761_36.n0 a_1761_36.n2 242.601
R397 a_1761_36.n2 a_1761_36.n3 267.2
R398 a_1761_36.n3 a_1761_36.t4 222.256
R399 a_1761_36.n3 a_1761_36.t5 323.476
R400 a_1761_36.n2 a_1761_36.n1 652.201
R401 a_1761_36.n1 a_1761_36.t3 321.767
R402 a_1761_36.n1 a_1761_36.t2 85.3672
R403 a_2096_165.t0 a_2096_165.n1 282.029
R404 a_2096_165.n1 a_2096_165.n2 32.0005
R405 a_2096_165.n2 a_2096_165.n3 228.8
R406 a_2096_165.n3 a_2096_165.t2 251.177
R407 a_2096_165.n3 a_2096_165.t4 366.856
R408 a_2096_165.n2 a_2096_165.t1 738.804
R409 a_2096_165.n1 a_2096_165.n0 209.779
R410 a_2096_165.n0 a_2096_165.t3 161.036
R411 a_2096_165.n0 a_2096_165.t5 450.236
R412 a_1509_36.t0 a_1509_36.n0 253
R413 a_1509_36.n0 a_1509_36.n1 9.98354
R414 a_1509_36.n1 a_1509_36.n2 0.321929
R415 a_1509_36.n2 a_1509_36.n3 10.8273
R416 a_1509_36.n3 a_1509_36.t4 425.334
R417 a_1509_36.n3 a_1509_36.t2 301.957
R418 a_1509_36.n2 a_1509_36.t3 308.091
R419 a_1509_36.n1 a_1509_36.t5 680.521
R420 a_1509_36.n0 a_1509_36.t1 700.376
R421 a_1257_36.t0 a_1257_36.n4 259.401
R422 a_1257_36.n4 a_1257_36.n5 177.601
R423 a_1257_36.n5 a_1257_36.t4 232.968
R424 a_1257_36.n5 a_1257_36.t7 319.728
R425 a_1257_36.n4 a_1257_36.n0 12.8005
R426 a_1257_36.n0 a_1257_36.n2 10.305
R427 a_1257_36.n2 a_1257_36.n1 0.563
R428 a_1257_36.n1 a_1257_36.n3 1.92014
R429 a_1257_36.n3 a_1257_36.t2 308.413
R430 a_1257_36.n3 a_1257_36.t5 680.521
R431 a_1257_36.n2 a_1257_36.t3 375.257
R432 a_1257_36.n1 a_1257_36.t6 351.471
R433 a_1257_36.n0 a_1257_36.t1 668.376
R434 a_936_288.t0 a_936_288.n4 259.401
R435 a_936_288.n4 a_936_288.n5 177.601
R436 a_936_288.n5 a_936_288.t2 204.048
R437 a_936_288.n5 a_936_288.t4 247.428
R438 a_936_288.n4 a_936_288.n0 31.8227
R439 a_936_288.n0 a_936_288.n3 10.7068
R440 a_936_288.n3 a_936_288.n2 199.345
R441 a_936_288.n2 a_936_288.t3 424.697
R442 a_936_288.n2 a_936_288.t6 193.337
R443 a_936_288.n3 a_936_288.n1 223.245
R444 a_936_288.n1 a_936_288.t5 348.647
R445 a_936_288.n1 a_936_288.t7 204.048
R446 a_936_288.n0 a_936_288.t1 649.355
R447 a_324_288.t0 a_324_288.n0 249.8
R448 a_324_288.n0 a_324_288.n1 22.4005
R449 a_324_288.n1 a_324_288.t3 401.731
R450 a_324_288.n1 a_324_288.t1 668.376
R451 a_324_288.n0 a_324_288.t2 420.81
C19 Q_N VNB 0.27435f
C20 Q VNB 0.23531f
C21 VGND VNB 2.64257f
C22 VPWR VNB 1.86623f
C23 CLK VNB 0.22851f
C24 DE VNB 0.41419f
C25 D VNB 0.23625f
C26 VPB VNB 4.8054f
C27 a_324_288.t0 VNB 0.06325f
C28 a_324_288.t2 VNB 0.09322f
C29 a_324_288.n0 VNB 0.32121f
C30 a_324_288.t1 VNB 0.0952f
C31 a_324_288.n1 VNB 0.39546f
C32 a_324_288.t3 VNB 0.08085f
C33 a_936_288.t0 VNB 0.09494f
C34 a_936_288.t1 VNB 0.12926f
C35 a_936_288.n0 VNB 0.21801f
C36 a_936_288.t7 VNB 0.04187f
C37 a_936_288.t5 VNB 0.05289f
C38 a_936_288.n1 VNB 0.25324f
C39 a_936_288.t6 VNB 0.0318f
C40 a_936_288.t3 VNB 0.06271f
C41 a_936_288.n2 VNB 0.14666f
C42 a_936_288.n3 VNB 2.55151f
C43 a_936_288.n4 VNB 0.50005f
C44 a_936_288.t4 VNB 0.06724f
C45 a_936_288.t2 VNB 0.04187f
C46 a_936_288.n5 VNB 0.17965f
C47 a_1257_36.t0 VNB 0.09263f
C48 a_1257_36.t1 VNB 0.13009f
C49 a_1257_36.n0 VNB 0.24746f
C50 a_1257_36.t6 VNB 0.07453f
C51 a_1257_36.n1 VNB 0.57195f
C52 a_1257_36.t3 VNB 0.07291f
C53 a_1257_36.n2 VNB 0.60553f
C54 a_1257_36.t5 VNB 0.12557f
C55 a_1257_36.n3 VNB 0.76885f
C56 a_1257_36.t2 VNB 0.06838f
C57 a_1257_36.n4 VNB 0.4328f
C58 a_1257_36.t7 VNB 0.05557f
C59 a_1257_36.t4 VNB 0.03674f
C60 a_1257_36.n5 VNB 0.18943f
C61 a_1509_36.t0 VNB 0.09597f
C62 a_1509_36.t1 VNB 0.15542f
C63 a_1509_36.n0 VNB 0.57539f
C64 a_1509_36.t5 VNB 0.13646f
C65 a_1509_36.n1 VNB 0.52201f
C66 a_1509_36.t3 VNB 0.07413f
C67 a_1509_36.n2 VNB 0.71968f
C68 a_1509_36.n3 VNB 0.50908f
C69 a_1509_36.t2 VNB 0.05723f
C70 a_1509_36.t4 VNB 0.1544f
C71 a_2096_165.t0 VNB 0.14856f
C72 a_2096_165.t5 VNB 0.05459f
C73 a_2096_165.t3 VNB 0.02292f
C74 a_2096_165.n0 VNB 0.12818f
C75 a_2096_165.n1 VNB 0.25052f
C76 a_2096_165.t1 VNB 0.18474f
C77 a_2096_165.n2 VNB 0.28105f
C78 a_2096_165.t4 VNB 0.04525f
C79 a_2096_165.t2 VNB 0.03247f
C80 a_2096_165.n3 VNB 0.11116f
C81 a_1761_36.t0 VNB 0.01805f
C82 a_1761_36.n0 VNB 0.10852f
C83 a_1761_36.t3 VNB 0.08505f
C84 a_1761_36.t2 VNB 0.02257f
C85 a_1761_36.n1 VNB 0.11915f
C86 a_1761_36.n2 VNB 0.3789f
C87 a_1761_36.t5 VNB 0.05344f
C88 a_1761_36.t4 VNB 0.03814f
C89 a_1761_36.n3 VNB 0.12416f
C90 a_1761_36.t1 VNB 0.06804f
C91 a_2697_36.t1 VNB 0.05955f
C92 a_2697_36.n0 VNB 0.09497f
C93 a_2697_36.t2 VNB 0.07444f
C94 a_2697_36.t0 VNB 0.01975f
C95 a_2697_36.n1 VNB 0.10427f
C96 a_2697_36.n2 VNB 0.36936f
C97 a_2697_36.t7 VNB 0.04861f
C98 a_2697_36.t5 VNB 0.02886f
C99 a_2697_36.n3 VNB 0.21374f
C100 a_2697_36.t4 VNB 0.02582f
C101 a_2697_36.t6 VNB 0.04102f
C102 a_2697_36.n4 VNB 0.16893f
C103 a_2697_36.t3 VNB 0.0158f
C104 a_144_36.t0 VNB 0.0601f
C105 a_144_36.n0 VNB 0.32355f
C106 a_144_36.t2 VNB 0.15636f
C107 a_144_36.n1 VNB 0.52093f
C108 a_144_36.t3 VNB 0.08497f
C109 a_144_36.t5 VNB 0.15016f
C110 a_144_36.n2 VNB 0.37579f
C111 a_144_36.t4 VNB 0.08168f
C112 a_144_36.n3 VNB 1.17701f
C113 a_144_36.t1 VNB 0.13858f
C114 a_249_414.t0 VNB 0.01328f
C115 a_249_414.t1 VNB 0.01328f
C116 a_861_414.t0 VNB 0.01318f
C117 a_861_414.t1 VNB 0.01318f
C118 a_1977_450.t0 VNB 0.02074f
C119 a_1977_450.t1 VNB 0.02074f
C120 a_2553_450.t0 VNB 0.01342f
C121 a_2553_450.t1 VNB 0.01342f
C122 a_2913_450.t0 VNB 0.02052f
C123 a_2913_450.t1 VNB 0.02052f
C124 a_249_36.t0 VNB 0.01026f
C125 a_249_36.t1 VNB 0.01026f
C126 a_861_36.t0 VNB 0.01058f
C127 a_861_36.t1 VNB 0.01058f
C128 a_1977_36.t1 VNB 0.01846f
C129 a_1977_36.t0 VNB 0.02278f
C130 a_2553_36.t0 VNB 0.01092f
C131 a_2553_36.t1 VNB 0.01364f
C132 a_2913_36.t0 VNB 0.01669f
C133 a_2913_36.t1 VNB 0.0206f
C134 VPB.t11 VNB 0.21738f
C135 VPB.t5 VNB 0.21738f
C136 VPB.t1 VNB 0.21738f
C137 VPB.t12 VNB 0.18632f
C138 VPB.t0 VNB 0.1708f
C139 VPB.t2 VNB 0.15527f
C140 VPB.t7 VNB 0.18632f
C141 VPB.t3 VNB 0.1708f
C142 VPB.t4 VNB 0.12421f
C143 VPB.t6 VNB 0.1708f
C144 VPB.t8 VNB 0.20185f
C145 VPB.t10 VNB 0.21738f
C146 VPB.t15 VNB 0.2329f
C147 VPB.t13 VNB 0.1708f
C148 VPB.t17 VNB 0.15527f
C149 VPB.t16 VNB 0.21738f
C150 VPB.t14 VNB 0.15527f
C151 VPB.t9 VNB 0.14751f
C152 D.t1 VNB 0.04576f
C153 D.t0 VNB 0.03026f
C154 D.n0 VNB 0.14463f
C155 DE.t2 VNB 0.06758f
C156 DE.t3 VNB 0.02759f
C157 DE.n0 VNB 0.23796f
C158 DE.t0 VNB 0.01412f
C159 DE.t1 VNB 0.09626f
C160 DE.n1 VNB 0.20126f
C161 DE.n2 VNB 0.09108f
C162 CLK.t1 VNB 0.05979f
C163 CLK.t0 VNB 0.03953f
C164 CLK.n0 VNB 0.18898f
C165 VPWR.n0 VNB 0.02219f
C166 VPWR.n1 VNB 0.02219f
C167 VPWR.n2 VNB 0.26166f
C168 VPWR.t4 VNB 0.03857f
C169 VPWR.t7 VNB 0.06379f
C170 VPWR.n3 VNB 0.05237f
C171 VPWR.n4 VNB 0.176f
C172 VPWR.n5 VNB 0.07503f
C173 VPWR.n6 VNB 0.01664f
C174 VPWR.n7 VNB 0.02219f
C175 VPWR.n8 VNB 0.04439f
C176 VPWR.n9 VNB 0.04439f
C177 VPWR.n10 VNB 0.04439f
C178 VPWR.t8 VNB 0.02675f
C179 VPWR.n11 VNB 0.02219f
C180 VPWR.n12 VNB 0.04439f
C181 VPWR.n13 VNB 0.02219f
C182 VPWR.n14 VNB 0.04439f
C183 VPWR.t5 VNB 0.02675f
C184 VPWR.n15 VNB 0.02219f
C185 VPWR.n16 VNB 0.04439f
C186 VPWR.t2 VNB 0.0151f
C187 VPWR.t3 VNB 0.00751f
C188 VPWR.n17 VNB 0.02121f
C189 VPWR.n18 VNB 0.02219f
C190 VPWR.n19 VNB 0.04439f
C191 VPWR.n20 VNB 0.02219f
C192 VPWR.n21 VNB 0.04439f
C193 VPWR.n22 VNB 0.01664f
C194 VPWR.n23 VNB 0.04439f
C195 VPWR.t6 VNB 0.03857f
C196 VPWR.n24 VNB 0.06292f
C197 VPWR.t10 VNB 0.03857f
C198 VPWR.n25 VNB 0.07401f
C199 VPWR.n26 VNB 0.04439f
C200 VPWR.n27 VNB 0.02219f
C201 VPWR.n28 VNB 0.04439f
C202 VPWR.t0 VNB 0.03857f
C203 VPWR.t11 VNB 0.03857f
C204 VPWR.n29 VNB 0.06292f
C205 VPWR.n30 VNB 0.04439f
C206 VPWR.t9 VNB 0.03857f
C207 VPWR.n31 VNB 0.08481f
C208 VPWR.n32 VNB 0.17694f
C209 VPWR.n33 VNB 0.06608f
C210 VPWR.n34 VNB 0.02219f
C211 VPWR.n35 VNB 0.02219f
C212 VPWR.n36 VNB 0.01664f
C213 VPWR.n37 VNB 0.04439f
C214 VPWR.n38 VNB 0.04439f
C215 VPWR.n39 VNB 0.01664f
C216 VPWR.n40 VNB 0.01664f
C217 VPWR.n41 VNB 0.06292f
C218 VPWR.n42 VNB 0.01664f
C219 VPWR.n43 VNB 0.04439f
C220 VPWR.n44 VNB 0.04439f
C221 VPWR.n45 VNB 0.04439f
C222 VPWR.n46 VNB 0.02219f
C223 VPWR.n47 VNB 0.02219f
C224 VPWR.n48 VNB 0.02219f
C225 VPWR.n49 VNB 0.04439f
C226 VPWR.n50 VNB 0.04439f
C227 VPWR.n51 VNB 0.04439f
C228 VPWR.n52 VNB 0.02219f
C229 VPWR.n53 VNB 0.02219f
C230 VPWR.n54 VNB 0.01664f
C231 VPWR.n55 VNB 0.04439f
C232 VPWR.n56 VNB 0.04439f
C233 VPWR.n57 VNB 0.04439f
C234 VPWR.n58 VNB 0.02219f
C235 VPWR.n59 VNB 0.02219f
C236 VPWR.n60 VNB 0.02219f
C237 VPWR.n61 VNB 0.04439f
C238 VPWR.n62 VNB 0.04439f
C239 VPWR.n63 VNB 0.04439f
C240 VPWR.n64 VNB 0.02219f
C241 VPWR.n65 VNB 0.02219f
C242 VPWR.n66 VNB 0.02219f
C243 VPWR.n67 VNB 0.04439f
C244 VPWR.n68 VNB 0.04439f
C245 VPWR.n69 VNB 0.04439f
C246 VPWR.n70 VNB 0.02219f
C247 VPWR.n71 VNB 0.06044f
C248 VPWR.n72 VNB 0.02219f
C249 VPWR.n73 VNB 0.04439f
C250 VPWR.n74 VNB 0.04439f
C251 VPWR.n75 VNB 0.04439f
C252 VPWR.n76 VNB 0.02219f
C253 VPWR.n77 VNB 0.06318f
C254 VPWR.n78 VNB 0.02219f
C255 VPWR.n79 VNB 0.04439f
C256 VPWR.n80 VNB 0.04439f
C257 VPWR.n81 VNB 0.04439f
C258 VPWR.n82 VNB 0.02219f
C259 VPWR.n83 VNB 0.02219f
C260 VPWR.n84 VNB 0.02219f
C261 VPWR.n85 VNB 0.04439f
C262 VPWR.n86 VNB 0.04439f
C263 VPWR.n87 VNB 0.04439f
C264 VPWR.n88 VNB 0.02219f
C265 VPWR.n89 VNB 0.02219f
C266 VPWR.n90 VNB 0.06318f
C267 VPWR.n91 VNB 0.04439f
C268 VPWR.n92 VNB 0.04439f
C269 VPWR.n93 VNB 0.04439f
C270 VPWR.n94 VNB 0.04439f
C271 VPWR.t1 VNB 0.06379f
C272 VPWR.n95 VNB 0.04163f
C273 VGND.t3 VNB 0.02955f
C274 VGND.n0 VNB 0.01787f
C275 VGND.n1 VNB 0.01787f
C276 VGND.n2 VNB 0.21071f
C277 VGND.t6 VNB 0.021f
C278 VGND.t8 VNB 0.02955f
C279 VGND.n3 VNB 0.12448f
C280 VGND.n4 VNB 0.05224f
C281 VGND.n5 VNB 0.0134f
C282 VGND.n6 VNB 0.01787f
C283 VGND.n7 VNB 0.03574f
C284 VGND.n8 VNB 0.03574f
C285 VGND.n9 VNB 0.03574f
C286 VGND.t9 VNB 0.021f
C287 VGND.n10 VNB 0.01787f
C288 VGND.n11 VNB 0.03574f
C289 VGND.n12 VNB 0.01787f
C290 VGND.n13 VNB 0.03574f
C291 VGND.t7 VNB 0.021f
C292 VGND.n14 VNB 0.01787f
C293 VGND.n15 VNB 0.03574f
C294 VGND.t2 VNB 0.00999f
C295 VGND.t0 VNB 0.00605f
C296 VGND.n16 VNB 0.0164f
C297 VGND.n17 VNB 0.01787f
C298 VGND.n18 VNB 0.03574f
C299 VGND.n19 VNB 0.01787f
C300 VGND.n20 VNB 0.03574f
C301 VGND.n21 VNB 0.0134f
C302 VGND.n22 VNB 0.03574f
C303 VGND.t4 VNB 0.021f
C304 VGND.n23 VNB 0.04248f
C305 VGND.t11 VNB 0.021f
C306 VGND.n24 VNB 0.05142f
C307 VGND.n25 VNB 0.03574f
C308 VGND.n26 VNB 0.01787f
C309 VGND.n27 VNB 0.03574f
C310 VGND.t10 VNB 0.0206f
C311 VGND.t5 VNB 0.0206f
C312 VGND.n28 VNB 0.03841f
C313 VGND.n29 VNB 0.03574f
C314 VGND.t1 VNB 0.021f
C315 VGND.n30 VNB 0.06011f
C316 VGND.n31 VNB 0.14249f
C317 VGND.n32 VNB 0.05322f
C318 VGND.n33 VNB 0.01787f
C319 VGND.n34 VNB 0.01787f
C320 VGND.n35 VNB 0.0134f
C321 VGND.n36 VNB 0.03574f
C322 VGND.n37 VNB 0.03574f
C323 VGND.n38 VNB 0.0134f
C324 VGND.n39 VNB 0.0134f
C325 VGND.n40 VNB 0.03841f
C326 VGND.n41 VNB 0.0134f
C327 VGND.n42 VNB 0.03574f
C328 VGND.n43 VNB 0.03574f
C329 VGND.n44 VNB 0.03574f
C330 VGND.n45 VNB 0.01787f
C331 VGND.n46 VNB 0.01787f
C332 VGND.n47 VNB 0.01787f
C333 VGND.n48 VNB 0.03574f
C334 VGND.n49 VNB 0.03574f
C335 VGND.n50 VNB 0.03574f
C336 VGND.n51 VNB 0.01787f
C337 VGND.n52 VNB 0.01787f
C338 VGND.n53 VNB 0.0134f
C339 VGND.n54 VNB 0.03574f
C340 VGND.n55 VNB 0.03574f
C341 VGND.n56 VNB 0.03574f
C342 VGND.n57 VNB 0.01787f
C343 VGND.n58 VNB 0.01787f
C344 VGND.n59 VNB 0.01787f
C345 VGND.n60 VNB 0.03574f
C346 VGND.n61 VNB 0.03574f
C347 VGND.n62 VNB 0.03574f
C348 VGND.n63 VNB 0.01787f
C349 VGND.n64 VNB 0.01787f
C350 VGND.n65 VNB 0.01787f
C351 VGND.n66 VNB 0.03574f
C352 VGND.n67 VNB 0.03574f
C353 VGND.n68 VNB 0.03574f
C354 VGND.n69 VNB 0.01787f
C355 VGND.n70 VNB 0.04352f
C356 VGND.n71 VNB 0.01787f
C357 VGND.n72 VNB 0.03574f
C358 VGND.n73 VNB 0.03574f
C359 VGND.n74 VNB 0.03574f
C360 VGND.n75 VNB 0.01787f
C361 VGND.n76 VNB 0.05142f
C362 VGND.n77 VNB 0.01787f
C363 VGND.n78 VNB 0.03574f
C364 VGND.n79 VNB 0.03574f
C365 VGND.n80 VNB 0.03574f
C366 VGND.n81 VNB 0.01787f
C367 VGND.n82 VNB 0.01787f
C368 VGND.n83 VNB 0.01787f
C369 VGND.n84 VNB 0.03574f
C370 VGND.n85 VNB 0.03574f
C371 VGND.n86 VNB 0.03574f
C372 VGND.n87 VNB 0.01787f
C373 VGND.n88 VNB 0.01787f
C374 VGND.n89 VNB 0.05142f
C375 VGND.n90 VNB 0.03574f
C376 VGND.n91 VNB 0.03574f
C377 VGND.n92 VNB 0.03574f
C378 VGND.n93 VNB 0.02457f
C379 Q.t1 VNB 0.13164f
C380 Q.t0 VNB 0.07045f
C381 Q.n0 VNB 0.05957f
C382 Q_N.t1 VNB 0.08095f
C383 Q_N.t0 VNB 0.04332f
C384 Q_N.n0 VNB 0.03663f
.ends

.subckt sky130_efx_lvdig__edfxtp_1 CLK D DE Q VGND VNB VPB VPWR
X0 a_936_288.t0 a_2697_36.t4 VGND.t4 VNB.t1 sky130_fd_pr__nfet_01v8 ad=0.16875 pd=1.65 as=0.16875 ps=1.65 w=0.45 l=0.15
X1 a_249_36.t0 D.t0 a_144_36.t5 VNB.t14 sky130_fd_pr__nfet_01v8 ad=0.08775 pd=0.84 as=0.16875 ps=1.65 w=0.45 l=0.15
X2 VGND.t0 DE.t1 a_249_36.t1 VNB.t15 sky130_fd_pr__nfet_01v8 ad=0.16875 pd=1.65 as=0.08775 ps=0.84 w=0.45 l=0.15
X3 a_2697_36.t2 a_1509_36.t2 a_2553_36.t1 VNB.t11 sky130_fd_pr__special_nfet_01v8 ad=0.1674 pd=1.29 as=0.11542 ps=1.02 w=0.36 l=0.15
X4 a_2913_36.t0 a_1257_36.t2 a_2697_36.t0 VNB.t2 sky130_fd_pr__special_nfet_01v8 ad=0.15593 pd=1.2 as=0.1674 ps=1.29 w=0.36 l=0.15
X5 a_861_36.t0 a_324_288.t2 VGND.t10 VNB.t10 sky130_fd_pr__nfet_01v8 ad=0.08775 pd=0.84 as=0.16875 ps=1.65 w=0.45 l=0.15
X6 a_1977_36.t0 a_1509_36.t3 a_1761_36.t0 VNB.t3 sky130_fd_pr__special_nfet_01v8 ad=0.15593 pd=1.2 as=0.1674 ps=1.29 w=0.36 l=0.15
X7 a_1509_36.t0 a_1257_36.t7 VPWR.t1 VPB.t0 sky130_fd_pr__pfet_01v8_hvt ad=0.23625 pd=2.01 as=0.23625 ps=2.01 w=0.63 l=0.15
X8 VPWR.t6 a_2096_165.t5 a_1977_450.t1 VPB.t7 sky130_fd_pr__pfet_01v8_hvt ad=0.12622 pd=1.11 as=0.16875 ps=1.2 w=0.45 l=0.15
X9 a_249_414.t1 D.t1 a_144_36.t4 VPB.t14 sky130_fd_pr__pfet_01v8_hvt ad=0.12285 pd=1.02 as=0.23625 ps=2.01 w=0.63 l=0.15
X10 a_2553_450.t0 a_2096_165.t4 VPWR.t8 VPB.t9 sky130_fd_pr__pfet_01v8_hvt ad=0.12825 pd=1.02 as=0.16875 ps=1.65 w=0.45 l=0.15
X11 VGND.t1 DE.t0 a_324_288.t0 VNB.t16 sky130_fd_pr__nfet_01v8 ad=0.16875 pd=1.65 as=0.16875 ps=1.65 w=0.45 l=0.15
X12 VPWR.t10 a_324_288.t3 a_249_414.t0 VPB.t12 sky130_fd_pr__pfet_01v8_hvt ad=0.23625 pd=2.01 as=0.12285 ps=1.02 w=0.63 l=0.15
X13 a_1761_36.t2 a_1509_36.t5 a_144_36.t0 VPB.t5 sky130_fd_pr__pfet_01v8_hvt ad=0.20925 pd=1.38 as=0.16875 ps=1.65 w=0.45 l=0.15
X14 a_936_288.t1 a_2697_36.t6 VPWR.t3 VPB.t2 sky130_fd_pr__pfet_01v8_hvt ad=0.23625 pd=2.01 as=0.23625 ps=2.01 w=0.63 l=0.15
X15 VGND.t8 a_936_288.t2 a_2913_36.t1 VNB.t7 sky130_fd_pr__nfet_01v8 ad=0.16875 pd=1.65 as=0.15593 ps=1.2 w=0.45 l=0.15
X16 a_2096_165.t1 a_1761_36.t5 VPWR.t9 VPB.t11 sky130_fd_pr__pfet_01v8_hvt ad=0.3996 pd=2.55 as=0.12622 ps=1.11 w=0.72 l=0.15
X17 a_861_414.t1 DE.t2 VPWR.t4 VPB.t16 sky130_fd_pr__pfet_01v8_hvt ad=0.12285 pd=1.02 as=0.23625 ps=2.01 w=0.63 l=0.15
X18 VPWR.t7 a_936_288.t4 a_2913_450.t1 VPB.t8 sky130_fd_pr__pfet_01v8_hvt ad=0.16875 pd=1.65 as=0.16875 ps=1.2 w=0.45 l=0.15
X19 VGND.t7 a_2096_165.t3 a_1977_36.t1 VNB.t6 sky130_fd_pr__nfet_01v8 ad=0.1134 pd=1.02 as=0.15593 ps=1.2 w=0.45 l=0.15
X20 a_2096_165.t0 a_1761_36.t4 VGND.t5 VNB.t4 sky130_fd_pr__nfet_01v8 ad=0.34965 pd=2.37 as=0.1134 ps=1.02 w=0.63 l=0.15
X21 a_1977_450.t0 a_1257_36.t6 a_1761_36.t1 VPB.t3 sky130_fd_pr__pfet_01v8_hvt ad=0.16875 pd=1.2 as=0.20925 ps=1.38 w=0.45 l=0.15
X22 a_144_36.t3 a_936_288.t3 a_861_36.t1 VNB.t12 sky130_fd_pr__nfet_01v8 ad=0.16875 pd=1.65 as=0.08775 ps=0.84 w=0.45 l=0.15
X23 a_1257_36.t0 CLK.t0 VGND.t3 VNB.t13 sky130_fd_pr__nfet_01v8 ad=0.16875 pd=1.65 as=0.16875 ps=1.65 w=0.45 l=0.15
X24 Q.t1 a_2697_36.t5 VGND.t2 VNB.t0 sky130_fd_pr__nfet_01v8 ad=0.23625 pd=2.01 as=0.23625 ps=2.01 w=0.63 l=0.15
X25 a_144_36.t1 a_936_288.t5 a_861_414.t0 VPB.t6 sky130_fd_pr__pfet_01v8_hvt ad=0.23625 pd=2.01 as=0.12285 ps=1.02 w=0.63 l=0.15
X26 a_2553_36.t0 a_2096_165.t2 VGND.t6 VNB.t5 sky130_fd_pr__nfet_01v8 ad=0.11542 pd=1.02 as=0.16875 ps=1.65 w=0.45 l=0.15
X27 a_2697_36.t3 a_1257_36.t5 a_2553_450.t1 VPB.t10 sky130_fd_pr__pfet_01v8_hvt ad=0.20925 pd=1.38 as=0.12825 ps=1.02 w=0.45 l=0.15
X28 a_1761_36.t3 a_1257_36.t3 a_144_36.t2 VNB.t8 sky130_fd_pr__special_nfet_01v8 ad=0.1674 pd=1.29 as=0.135 ps=1.47 w=0.36 l=0.15
X29 a_1257_36.t1 CLK.t1 VPWR.t5 VPB.t13 sky130_fd_pr__pfet_01v8_hvt ad=0.23625 pd=2.01 as=0.23625 ps=2.01 w=0.63 l=0.15
X30 VPWR.t0 DE.t3 a_324_288.t1 VPB.t15 sky130_fd_pr__pfet_01v8_hvt ad=0.23625 pd=2.01 as=0.23625 ps=2.01 w=0.63 l=0.15
X31 Q.t0 a_2697_36.t7 VPWR.t2 VPB.t1 sky130_fd_pr__pfet_01v8_hvt ad=0.405 pd=2.91 as=0.405 ps=2.91 w=1.08 l=0.15
X32 a_2913_450.t0 a_1509_36.t4 a_2697_36.t1 VPB.t4 sky130_fd_pr__pfet_01v8_hvt ad=0.16875 pd=1.2 as=0.20925 ps=1.38 w=0.45 l=0.15
X33 a_1509_36.t1 a_1257_36.t4 VGND.t9 VNB.t9 sky130_fd_pr__nfet_01v8 ad=0.16875 pd=1.65 as=0.16875 ps=1.65 w=0.45 l=0.15
C0 VGND CLK 0.03978f
C1 VPWR VPB 0.77303f
C2 VPB D 0.09247f
C3 VGND Q 0.12234f
C4 VPB DE 0.23954f
C5 VGND VPB 0.04035f
C6 VPB CLK 0.10634f
C7 VPWR D 0.02183f
C8 Q VPB 0.02034f
C9 VPWR DE 0.10418f
C10 D DE 0.02996f
C11 VPWR VGND 0.05335f
C12 VGND D 0.01622f
C13 VPWR CLK 0.03739f
C14 VGND DE 0.05794f
C15 VPWR Q 0.15781f
R0 Q Q.t0 344.07
R1 Q.n0 Q.t1 222.143
R2 Q.n0 Q 28.8005
R3 Q Q.n0 9.6005
R4 VGND.n0 VGND.t4 259.339
R5 VGND.n1 VGND.t8 253
R6 VGND.n68 VGND.t6 253
R7 VGND.n16 VGND.t3 253
R8 VGND.n22 VGND.t0 253
R9 VGND.n14 VGND.t9 253
R10 VGND.n32 VGND.t10 249.8
R11 VGND.n20 VGND.t1 249.8
R12 VGND VGND.t2 231.744
R13 VGND.n62 VGND.n9 197.8
R14 VGND.n9 VGND.t7 52.0005
R15 VGND.n9 VGND.t5 40.9529
R16 VGND.n85 VGND.n84 12.8005
R17 VGND.n84 VGND.n1 12.8005
R18 VGND.n80 VGND.n1 12.8005
R19 VGND.n80 VGND.n79 12.8005
R20 VGND.n79 VGND.n78 12.8005
R21 VGND.n78 VGND.n3 12.8005
R22 VGND.n74 VGND.n3 12.8005
R23 VGND.n74 VGND.n73 12.8005
R24 VGND.n73 VGND.n72 12.8005
R25 VGND.n72 VGND.n5 12.8005
R26 VGND.n68 VGND.n5 12.8005
R27 VGND.n68 VGND.n67 12.8005
R28 VGND.n67 VGND.n66 12.8005
R29 VGND.n66 VGND.n7 12.8005
R30 VGND.n62 VGND.n7 12.8005
R31 VGND.n62 VGND.n61 12.8005
R32 VGND.n61 VGND.n60 12.8005
R33 VGND.n60 VGND.n10 12.8005
R34 VGND.n56 VGND.n10 12.8005
R35 VGND.n56 VGND.n55 12.8005
R36 VGND.n55 VGND.n54 12.8005
R37 VGND.n54 VGND.n12 12.8005
R38 VGND.n50 VGND.n12 12.8005
R39 VGND.n50 VGND.n49 12.8005
R40 VGND.n49 VGND.n48 12.8005
R41 VGND.n45 VGND.n44 12.8005
R42 VGND.n44 VGND.n43 12.8005
R43 VGND.n43 VGND.n16 12.8005
R44 VGND.n39 VGND.n16 12.8005
R45 VGND.n39 VGND.n38 12.8005
R46 VGND.n38 VGND.n37 12.8005
R47 VGND.n37 VGND.n18 12.8005
R48 VGND.n33 VGND.n18 12.8005
R49 VGND.n31 VGND.n30 12.8005
R50 VGND.n27 VGND.n26 12.8005
R51 VGND.n26 VGND.n25 12.8005
R52 VGND.n25 VGND.n22 12.8005
R53 VGND VGND.n85 9.6005
R54 VGND.n25 VGND.n24 9.3005
R55 VGND.n26 VGND.n21 9.3005
R56 VGND.n28 VGND.n27 9.3005
R57 VGND.n30 VGND.n29 9.3005
R58 VGND.n31 VGND.n19 9.3005
R59 VGND.n34 VGND.n33 9.3005
R60 VGND.n35 VGND.n18 9.3005
R61 VGND.n37 VGND.n36 9.3005
R62 VGND.n38 VGND.n17 9.3005
R63 VGND.n40 VGND.n39 9.3005
R64 VGND.n41 VGND.n16 9.3005
R65 VGND.n43 VGND.n42 9.3005
R66 VGND.n44 VGND.n15 9.3005
R67 VGND.n46 VGND.n45 9.3005
R68 VGND.n48 VGND.n47 9.3005
R69 VGND.n49 VGND.n13 9.3005
R70 VGND.n51 VGND.n50 9.3005
R71 VGND.n52 VGND.n12 9.3005
R72 VGND.n54 VGND.n53 9.3005
R73 VGND.n55 VGND.n11 9.3005
R74 VGND.n57 VGND.n56 9.3005
R75 VGND.n58 VGND.n10 9.3005
R76 VGND.n60 VGND.n59 9.3005
R77 VGND.n61 VGND.n8 9.3005
R78 VGND.n63 VGND.n62 9.3005
R79 VGND.n64 VGND.n7 9.3005
R80 VGND.n66 VGND.n65 9.3005
R81 VGND.n67 VGND.n6 9.3005
R82 VGND.n69 VGND.n68 9.3005
R83 VGND.n70 VGND.n5 9.3005
R84 VGND.n72 VGND.n71 9.3005
R85 VGND.n73 VGND.n4 9.3005
R86 VGND.n75 VGND.n74 9.3005
R87 VGND.n76 VGND.n3 9.3005
R88 VGND.n78 VGND.n77 9.3005
R89 VGND.n79 VGND.n2 9.3005
R90 VGND.n81 VGND.n80 9.3005
R91 VGND.n82 VGND.n1 9.3005
R92 VGND.n84 VGND.n83 9.3005
R93 VGND.n48 VGND.n14 6.4005
R94 VGND.n45 VGND.n14 6.4005
R95 VGND.n33 VGND.n32 6.4005
R96 VGND.n32 VGND.n31 6.4005
R97 VGND.n30 VGND.n20 6.4005
R98 VGND.n27 VGND.n20 6.4005
R99 VGND.n23 VGND.n22 6.2273
R100 VGND.n85 VGND.n0 6.08215
R101 VGND.n23 VGND 0.31702
R102 VGND.n83 VGND.n0 0.2391
R103 VGND.n24 VGND.n23 0.0939888
R104 VGND.n83 VGND.n82 0.063
R105 VGND.n82 VGND.n81 0.063
R106 VGND.n81 VGND.n2 0.063
R107 VGND.n77 VGND.n2 0.063
R108 VGND.n77 VGND.n76 0.063
R109 VGND.n76 VGND.n75 0.063
R110 VGND.n75 VGND.n4 0.063
R111 VGND.n71 VGND.n4 0.063
R112 VGND.n71 VGND.n70 0.063
R113 VGND.n70 VGND.n69 0.063
R114 VGND.n69 VGND.n6 0.063
R115 VGND.n65 VGND.n6 0.063
R116 VGND.n65 VGND.n64 0.063
R117 VGND.n64 VGND.n63 0.063
R118 VGND.n63 VGND.n8 0.063
R119 VGND.n59 VGND.n8 0.063
R120 VGND.n59 VGND.n58 0.063
R121 VGND.n58 VGND.n57 0.063
R122 VGND.n57 VGND.n11 0.063
R123 VGND.n53 VGND.n11 0.063
R124 VGND.n53 VGND.n52 0.063
R125 VGND.n52 VGND.n51 0.063
R126 VGND.n51 VGND.n13 0.063
R127 VGND.n47 VGND.n13 0.063
R128 VGND.n47 VGND.n46 0.063
R129 VGND.n46 VGND.n15 0.063
R130 VGND.n42 VGND.n15 0.063
R131 VGND.n42 VGND.n41 0.063
R132 VGND.n41 VGND.n40 0.063
R133 VGND.n40 VGND.n17 0.063
R134 VGND.n36 VGND.n17 0.063
R135 VGND.n36 VGND.n35 0.063
R136 VGND.n35 VGND.n34 0.063
R137 VGND.n34 VGND.n19 0.063
R138 VGND.n29 VGND.n19 0.063
R139 VGND.n29 VGND.n28 0.063
R140 VGND.n28 VGND.n21 0.063
R141 VGND.n24 VGND.n21 0.063
R142 VPWR.n1 VPWR.t7 683.168
R143 VPWR.n68 VPWR.t8 683.168
R144 VPWR.n0 VPWR.t3 668.314
R145 VPWR.n16 VPWR.t5 661.976
R146 VPWR.n22 VPWR.t10 661.976
R147 VPWR.n20 VPWR.t0 661.976
R148 VPWR.n32 VPWR.t4 661.976
R149 VPWR.n14 VPWR.t1 661.976
R150 VPWR.n62 VPWR.n9 597.801
R151 VPWR.n86 VPWR.t2 328.07
R152 VPWR.n9 VPWR.t6 85.3672
R153 VPWR.n9 VPWR.t9 61.563
R154 VPWR.n86 VPWR.n85 25.6005
R155 VPWR VPWR.n86 16.0005
R156 VPWR.n85 VPWR.n84 12.8005
R157 VPWR.n84 VPWR.n1 12.8005
R158 VPWR.n80 VPWR.n1 12.8005
R159 VPWR.n80 VPWR.n79 12.8005
R160 VPWR.n79 VPWR.n78 12.8005
R161 VPWR.n78 VPWR.n3 12.8005
R162 VPWR.n74 VPWR.n3 12.8005
R163 VPWR.n74 VPWR.n73 12.8005
R164 VPWR.n73 VPWR.n72 12.8005
R165 VPWR.n72 VPWR.n5 12.8005
R166 VPWR.n68 VPWR.n5 12.8005
R167 VPWR.n68 VPWR.n67 12.8005
R168 VPWR.n67 VPWR.n66 12.8005
R169 VPWR.n66 VPWR.n7 12.8005
R170 VPWR.n62 VPWR.n7 12.8005
R171 VPWR.n62 VPWR.n61 12.8005
R172 VPWR.n61 VPWR.n60 12.8005
R173 VPWR.n60 VPWR.n10 12.8005
R174 VPWR.n56 VPWR.n10 12.8005
R175 VPWR.n56 VPWR.n55 12.8005
R176 VPWR.n55 VPWR.n54 12.8005
R177 VPWR.n54 VPWR.n12 12.8005
R178 VPWR.n50 VPWR.n12 12.8005
R179 VPWR.n50 VPWR.n49 12.8005
R180 VPWR.n49 VPWR.n48 12.8005
R181 VPWR.n45 VPWR.n44 12.8005
R182 VPWR.n44 VPWR.n43 12.8005
R183 VPWR.n43 VPWR.n16 12.8005
R184 VPWR.n39 VPWR.n16 12.8005
R185 VPWR.n39 VPWR.n38 12.8005
R186 VPWR.n38 VPWR.n37 12.8005
R187 VPWR.n37 VPWR.n18 12.8005
R188 VPWR.n33 VPWR.n18 12.8005
R189 VPWR.n31 VPWR.n30 12.8005
R190 VPWR.n27 VPWR.n26 12.8005
R191 VPWR.n26 VPWR.n25 12.8005
R192 VPWR.n25 VPWR.n22 12.8005
R193 VPWR.n25 VPWR.n24 9.3005
R194 VPWR.n26 VPWR.n21 9.3005
R195 VPWR.n28 VPWR.n27 9.3005
R196 VPWR.n30 VPWR.n29 9.3005
R197 VPWR.n31 VPWR.n19 9.3005
R198 VPWR.n34 VPWR.n33 9.3005
R199 VPWR.n35 VPWR.n18 9.3005
R200 VPWR.n37 VPWR.n36 9.3005
R201 VPWR.n38 VPWR.n17 9.3005
R202 VPWR.n40 VPWR.n39 9.3005
R203 VPWR.n41 VPWR.n16 9.3005
R204 VPWR.n43 VPWR.n42 9.3005
R205 VPWR.n44 VPWR.n15 9.3005
R206 VPWR.n46 VPWR.n45 9.3005
R207 VPWR.n48 VPWR.n47 9.3005
R208 VPWR.n49 VPWR.n13 9.3005
R209 VPWR.n51 VPWR.n50 9.3005
R210 VPWR.n52 VPWR.n12 9.3005
R211 VPWR.n54 VPWR.n53 9.3005
R212 VPWR.n55 VPWR.n11 9.3005
R213 VPWR.n57 VPWR.n56 9.3005
R214 VPWR.n58 VPWR.n10 9.3005
R215 VPWR.n60 VPWR.n59 9.3005
R216 VPWR.n61 VPWR.n8 9.3005
R217 VPWR.n63 VPWR.n62 9.3005
R218 VPWR.n64 VPWR.n7 9.3005
R219 VPWR.n66 VPWR.n65 9.3005
R220 VPWR.n67 VPWR.n6 9.3005
R221 VPWR.n69 VPWR.n68 9.3005
R222 VPWR.n70 VPWR.n5 9.3005
R223 VPWR.n72 VPWR.n71 9.3005
R224 VPWR.n73 VPWR.n4 9.3005
R225 VPWR.n75 VPWR.n74 9.3005
R226 VPWR.n76 VPWR.n3 9.3005
R227 VPWR.n78 VPWR.n77 9.3005
R228 VPWR.n79 VPWR.n2 9.3005
R229 VPWR.n81 VPWR.n80 9.3005
R230 VPWR.n82 VPWR.n1 9.3005
R231 VPWR.n84 VPWR.n83 9.3005
R232 VPWR.n48 VPWR.n14 6.4005
R233 VPWR.n45 VPWR.n14 6.4005
R234 VPWR.n33 VPWR.n32 6.4005
R235 VPWR.n32 VPWR.n31 6.4005
R236 VPWR.n30 VPWR.n20 6.4005
R237 VPWR.n27 VPWR.n20 6.4005
R238 VPWR.n23 VPWR.n22 6.2273
R239 VPWR.n85 VPWR.n0 6.08215
R240 VPWR.n23 VPWR 0.31702
R241 VPWR.n83 VPWR.n0 0.2391
R242 VPWR.n24 VPWR.n23 0.0939888
R243 VPWR.n83 VPWR.n82 0.063
R244 VPWR.n82 VPWR.n81 0.063
R245 VPWR.n81 VPWR.n2 0.063
R246 VPWR.n77 VPWR.n2 0.063
R247 VPWR.n77 VPWR.n76 0.063
R248 VPWR.n76 VPWR.n75 0.063
R249 VPWR.n75 VPWR.n4 0.063
R250 VPWR.n71 VPWR.n4 0.063
R251 VPWR.n71 VPWR.n70 0.063
R252 VPWR.n70 VPWR.n69 0.063
R253 VPWR.n69 VPWR.n6 0.063
R254 VPWR.n65 VPWR.n6 0.063
R255 VPWR.n65 VPWR.n64 0.063
R256 VPWR.n64 VPWR.n63 0.063
R257 VPWR.n63 VPWR.n8 0.063
R258 VPWR.n59 VPWR.n8 0.063
R259 VPWR.n59 VPWR.n58 0.063
R260 VPWR.n58 VPWR.n57 0.063
R261 VPWR.n57 VPWR.n11 0.063
R262 VPWR.n53 VPWR.n11 0.063
R263 VPWR.n53 VPWR.n52 0.063
R264 VPWR.n52 VPWR.n51 0.063
R265 VPWR.n51 VPWR.n13 0.063
R266 VPWR.n47 VPWR.n13 0.063
R267 VPWR.n47 VPWR.n46 0.063
R268 VPWR.n46 VPWR.n15 0.063
R269 VPWR.n42 VPWR.n15 0.063
R270 VPWR.n42 VPWR.n41 0.063
R271 VPWR.n41 VPWR.n40 0.063
R272 VPWR.n40 VPWR.n17 0.063
R273 VPWR.n36 VPWR.n17 0.063
R274 VPWR.n36 VPWR.n35 0.063
R275 VPWR.n35 VPWR.n34 0.063
R276 VPWR.n34 VPWR.n19 0.063
R277 VPWR.n29 VPWR.n19 0.063
R278 VPWR.n29 VPWR.n28 0.063
R279 VPWR.n28 VPWR.n21 0.063
R280 VPWR.n24 VPWR.n21 0.063
R281 CLK.n0 CLK.t1 319.728
R282 CLK.n0 CLK.t0 232.968
R283 CLK CLK.n0 158.4
R284 DE.n1 DE.t1 269.921
R285 DE.n0 DE.t2 238.59
R286 DE DE.n2 158.4
R287 DE.n0 DE.t3 146.667
R288 DE.n1 DE.t0 101.221
R289 DE.n2 DE.n0 49.5776
R290 DE.n2 DE.n1 17.1957
R291 D.n0 D.t1 319.728
R292 D.n0 D.t0 232.968
R293 D D.n0 158.4
R294 VPB.t11 VPB.t9 690.909
R295 VPB.t6 VPB.t13 690.909
R296 VPB.t1 VPB.t2 604.545
R297 VPB.t8 VPB.t1 604.545
R298 VPB.t0 VPB.t5 604.545
R299 VPB.t13 VPB.t0 604.545
R300 VPB.t15 VPB.t16 604.545
R301 VPB.t12 VPB.t15 604.545
R302 VPB VPB.t14 561.365
R303 VPB.t10 VPB.t4 518.183
R304 VPB.t5 VPB.t3 518.183
R305 VPB.t4 VPB.t8 431.818
R306 VPB.t3 VPB.t7 431.818
R307 VPB.t9 VPB.t10 345.455
R308 VPB.t7 VPB.t11 259.091
R309 VPB.t16 VPB.t6 259.091
R310 VPB.t14 VPB.t12 259.091
R311 VNB.t4 VNB.t5 3200
R312 VNB.t12 VNB.t13 3200
R313 VNB.t0 VNB.t1 2800
R314 VNB.t7 VNB.t0 2800
R315 VNB.t9 VNB.t8 2800
R316 VNB.t13 VNB.t9 2800
R317 VNB.t16 VNB.t10 2800
R318 VNB.t15 VNB.t16 2800
R319 VNB VNB.t14 2600
R320 VNB.t11 VNB.t2 2400
R321 VNB.t8 VNB.t3 2400
R322 VNB.t2 VNB.t7 2000
R323 VNB.t3 VNB.t6 2000
R324 VNB.t5 VNB.t11 1600
R325 VNB.t6 VNB.t4 1200
R326 VNB.t10 VNB.t12 1200
R327 VNB.t14 VNB.t15 1200
R328 a_2913_36.t0 a_2913_36.t1 219
R329 a_2553_36.t1 a_2553_36.t0 180.667
R330 a_1977_36.t0 a_1977_36.t1 219
R331 a_861_36.t0 a_861_36.t1 104.001
R332 a_249_36.t0 a_249_36.t1 104.001
R333 a_2913_450.t0 a_2913_450.t1 328.334
R334 a_2553_450.t0 a_2553_450.t1 249.534
R335 a_1977_450.t0 a_1977_450.t1 328.334
R336 a_861_414.t0 a_861_414.t1 121.953
R337 a_249_414.t0 a_249_414.t1 121.953
R338 a_144_36.t2 a_144_36.n0 253.556
R339 a_144_36.n0 a_144_36.t0 906.457
R340 a_144_36.n3 a_144_36.n2 9.3005
R341 a_144_36.n3 a_144_36.n1 11.6309
R342 a_144_36.n0 a_144_36.n3 10.6264
R343 a_144_36.n2 a_144_36.t3 253
R344 a_144_36.n2 a_144_36.t1 789.976
R345 a_144_36.n1 a_144_36.t5 259.401
R346 a_144_36.n1 a_144_36.t4 796.376
R347 a_2697_36.n0 a_2697_36.t2 245
R348 a_2697_36.t0 a_2697_36.n0 65.0005
R349 a_2697_36.n0 a_2697_36.n2 242.601
R350 a_2697_36.n2 a_2697_36.n3 318.401
R351 a_2697_36.n3 a_2697_36.n4 168.701
R352 a_2697_36.n4 a_2697_36.t6 303.661
R353 a_2697_36.n4 a_2697_36.t4 216.9
R354 a_2697_36.n3 a_2697_36.t5 187.981
R355 a_2697_36.n3 a_2697_36.t7 231.361
R356 a_2697_36.n2 a_2697_36.n1 652.201
R357 a_2697_36.n1 a_2697_36.t3 321.767
R358 a_2697_36.n1 a_2697_36.t1 85.3672
R359 a_1761_36.n0 a_1761_36.t3 245
R360 a_1761_36.t0 a_1761_36.n0 65.0005
R361 a_1761_36.n0 a_1761_36.n2 242.601
R362 a_1761_36.n2 a_1761_36.n3 267.2
R363 a_1761_36.n3 a_1761_36.t4 222.256
R364 a_1761_36.n3 a_1761_36.t5 323.476
R365 a_1761_36.n2 a_1761_36.n1 652.201
R366 a_1761_36.n1 a_1761_36.t2 321.767
R367 a_1761_36.n1 a_1761_36.t1 85.3672
R368 a_2096_165.t0 a_2096_165.n1 282.029
R369 a_2096_165.n1 a_2096_165.n2 32.0005
R370 a_2096_165.n2 a_2096_165.n3 228.8
R371 a_2096_165.n3 a_2096_165.t2 251.177
R372 a_2096_165.n3 a_2096_165.t4 366.856
R373 a_2096_165.n2 a_2096_165.t1 738.804
R374 a_2096_165.n1 a_2096_165.n0 209.779
R375 a_2096_165.n0 a_2096_165.t3 161.036
R376 a_2096_165.n0 a_2096_165.t5 450.236
R377 a_1509_36.t1 a_1509_36.n0 253
R378 a_1509_36.n0 a_1509_36.n1 9.98354
R379 a_1509_36.n1 a_1509_36.n2 0.321929
R380 a_1509_36.n2 a_1509_36.n3 10.8273
R381 a_1509_36.n3 a_1509_36.t4 425.334
R382 a_1509_36.n3 a_1509_36.t2 301.957
R383 a_1509_36.n2 a_1509_36.t3 308.091
R384 a_1509_36.n1 a_1509_36.t5 680.521
R385 a_1509_36.n0 a_1509_36.t0 700.376
R386 a_1257_36.t0 a_1257_36.n4 259.401
R387 a_1257_36.n4 a_1257_36.n5 177.601
R388 a_1257_36.n5 a_1257_36.t4 232.968
R389 a_1257_36.n5 a_1257_36.t7 319.728
R390 a_1257_36.n4 a_1257_36.n0 12.8005
R391 a_1257_36.n0 a_1257_36.n2 10.305
R392 a_1257_36.n2 a_1257_36.n1 0.563
R393 a_1257_36.n1 a_1257_36.n3 1.92014
R394 a_1257_36.n3 a_1257_36.t2 308.413
R395 a_1257_36.n3 a_1257_36.t5 680.521
R396 a_1257_36.n2 a_1257_36.t3 375.257
R397 a_1257_36.n1 a_1257_36.t6 351.471
R398 a_1257_36.n0 a_1257_36.t1 668.376
R399 a_936_288.t0 a_936_288.n0 304.022
R400 a_936_288.n0 a_936_288.n3 10.7068
R401 a_936_288.n3 a_936_288.n2 199.345
R402 a_936_288.n2 a_936_288.t2 424.697
R403 a_936_288.n2 a_936_288.t4 193.337
R404 a_936_288.n3 a_936_288.n1 223.245
R405 a_936_288.n1 a_936_288.t3 348.647
R406 a_936_288.n1 a_936_288.t5 204.048
R407 a_936_288.n0 a_936_288.t1 649.355
R408 a_324_288.t0 a_324_288.n0 249.8
R409 a_324_288.n0 a_324_288.n1 22.4005
R410 a_324_288.n1 a_324_288.t3 401.731
R411 a_324_288.n1 a_324_288.t1 668.376
R412 a_324_288.n0 a_324_288.t2 420.81
C16 Q VNB 0.23531f
C17 VGND VNB 2.46551f
C18 VPWR VNB 1.76743f
C19 CLK VNB 0.22851f
C20 DE VNB 0.41419f
C21 D VNB 0.23625f
C22 VPB VNB 4.55047f
C23 a_324_288.t0 VNB 0.06325f
C24 a_324_288.t2 VNB 0.09322f
C25 a_324_288.n0 VNB 0.32121f
C26 a_324_288.t1 VNB 0.0952f
C27 a_324_288.n1 VNB 0.39546f
C28 a_324_288.t3 VNB 0.08085f
C29 a_936_288.t0 VNB 0.14424f
C30 a_936_288.t1 VNB 0.13051f
C31 a_936_288.n0 VNB 0.53975f
C32 a_936_288.t5 VNB 0.04228f
C33 a_936_288.t3 VNB 0.0534f
C34 a_936_288.n1 VNB 0.25569f
C35 a_936_288.t4 VNB 0.0321f
C36 a_936_288.t2 VNB 0.06332f
C37 a_936_288.n2 VNB 0.14809f
C38 a_936_288.n3 VNB 2.57621f
C39 a_1257_36.t0 VNB 0.09262f
C40 a_1257_36.t1 VNB 0.13006f
C41 a_1257_36.n0 VNB 0.24741f
C42 a_1257_36.t6 VNB 0.07452f
C43 a_1257_36.n1 VNB 0.57185f
C44 a_1257_36.t3 VNB 0.07289f
C45 a_1257_36.n2 VNB 0.60543f
C46 a_1257_36.t5 VNB 0.12555f
C47 a_1257_36.n3 VNB 0.76871f
C48 a_1257_36.t2 VNB 0.06837f
C49 a_1257_36.n4 VNB 0.43272f
C50 a_1257_36.t7 VNB 0.05556f
C51 a_1257_36.t4 VNB 0.03674f
C52 a_1257_36.n5 VNB 0.1894f
C53 a_1509_36.t1 VNB 0.09596f
C54 a_1509_36.t0 VNB 0.1554f
C55 a_1509_36.n0 VNB 0.57532f
C56 a_1509_36.t5 VNB 0.13644f
C57 a_1509_36.n1 VNB 0.52194f
C58 a_1509_36.t3 VNB 0.07413f
C59 a_1509_36.n2 VNB 0.71959f
C60 a_1509_36.n3 VNB 0.50902f
C61 a_1509_36.t2 VNB 0.05723f
C62 a_1509_36.t4 VNB 0.15439f
C63 a_2096_165.t0 VNB 0.14856f
C64 a_2096_165.t5 VNB 0.05459f
C65 a_2096_165.t3 VNB 0.02292f
C66 a_2096_165.n0 VNB 0.12818f
C67 a_2096_165.n1 VNB 0.25052f
C68 a_2096_165.t1 VNB 0.18474f
C69 a_2096_165.n2 VNB 0.28105f
C70 a_2096_165.t4 VNB 0.04525f
C71 a_2096_165.t2 VNB 0.03247f
C72 a_2096_165.n3 VNB 0.11116f
C73 a_1761_36.t0 VNB 0.01805f
C74 a_1761_36.n0 VNB 0.10852f
C75 a_1761_36.t2 VNB 0.08505f
C76 a_1761_36.t1 VNB 0.02257f
C77 a_1761_36.n1 VNB 0.11915f
C78 a_1761_36.n2 VNB 0.3789f
C79 a_1761_36.t5 VNB 0.05344f
C80 a_1761_36.t4 VNB 0.03814f
C81 a_1761_36.n3 VNB 0.12416f
C82 a_1761_36.t3 VNB 0.06804f
C83 a_2697_36.t0 VNB 0.01538f
C84 a_2697_36.n0 VNB 0.09248f
C85 a_2697_36.t3 VNB 0.07249f
C86 a_2697_36.t1 VNB 0.01923f
C87 a_2697_36.n1 VNB 0.10154f
C88 a_2697_36.n2 VNB 0.35967f
C89 a_2697_36.t7 VNB 0.04734f
C90 a_2697_36.t5 VNB 0.02811f
C91 a_2697_36.n3 VNB 0.20814f
C92 a_2697_36.t4 VNB 0.02515f
C93 a_2697_36.t6 VNB 0.03994f
C94 a_2697_36.n4 VNB 0.1645f
C95 a_2697_36.t2 VNB 0.05799f
C96 a_144_36.t2 VNB 0.0601f
C97 a_144_36.n0 VNB 0.32355f
C98 a_144_36.t4 VNB 0.15636f
C99 a_144_36.n1 VNB 0.52093f
C100 a_144_36.t5 VNB 0.08497f
C101 a_144_36.t1 VNB 0.15016f
C102 a_144_36.n2 VNB 0.37579f
C103 a_144_36.t3 VNB 0.08168f
C104 a_144_36.n3 VNB 1.17701f
C105 a_144_36.t0 VNB 0.13858f
C106 a_249_414.t0 VNB 0.01328f
C107 a_249_414.t1 VNB 0.01328f
C108 a_861_414.t0 VNB 0.01318f
C109 a_861_414.t1 VNB 0.01318f
C110 a_1977_450.t0 VNB 0.02074f
C111 a_1977_450.t1 VNB 0.02074f
C112 a_2553_450.t0 VNB 0.01342f
C113 a_2553_450.t1 VNB 0.01342f
C114 a_2913_450.t0 VNB 0.02052f
C115 a_2913_450.t1 VNB 0.02052f
C116 a_249_36.t0 VNB 0.01026f
C117 a_249_36.t1 VNB 0.01026f
C118 a_861_36.t0 VNB 0.01058f
C119 a_861_36.t1 VNB 0.01058f
C120 a_1977_36.t0 VNB 0.01846f
C121 a_1977_36.t1 VNB 0.02278f
C122 a_2553_36.t1 VNB 0.01092f
C123 a_2553_36.t0 VNB 0.01364f
C124 a_2913_36.t0 VNB 0.01669f
C125 a_2913_36.t1 VNB 0.0206f
C126 VPB.t2 VNB 0.25256f
C127 VPB.t1 VNB 0.22099f
C128 VPB.t8 VNB 0.18942f
C129 VPB.t4 VNB 0.17363f
C130 VPB.t10 VNB 0.15785f
C131 VPB.t9 VNB 0.18942f
C132 VPB.t11 VNB 0.17363f
C133 VPB.t7 VNB 0.12628f
C134 VPB.t3 VNB 0.17363f
C135 VPB.t5 VNB 0.2052f
C136 VPB.t0 VNB 0.22099f
C137 VPB.t13 VNB 0.23677f
C138 VPB.t6 VNB 0.17363f
C139 VPB.t16 VNB 0.15785f
C140 VPB.t15 VNB 0.22099f
C141 VPB.t12 VNB 0.15785f
C142 VPB.t14 VNB 0.14996f
C143 D.t1 VNB 0.04576f
C144 D.t0 VNB 0.03026f
C145 D.n0 VNB 0.14463f
C146 DE.t2 VNB 0.06758f
C147 DE.t3 VNB 0.02759f
C148 DE.n0 VNB 0.23796f
C149 DE.t0 VNB 0.01412f
C150 DE.t1 VNB 0.09626f
C151 DE.n1 VNB 0.20126f
C152 DE.n2 VNB 0.09108f
C153 CLK.t1 VNB 0.05979f
C154 CLK.t0 VNB 0.03953f
C155 CLK.n0 VNB 0.18898f
C156 VPWR.t3 VNB 0.03953f
C157 VPWR.n0 VNB 0.25905f
C158 VPWR.t7 VNB 0.02678f
C159 VPWR.n1 VNB 0.06327f
C160 VPWR.n2 VNB 0.04444f
C161 VPWR.n3 VNB 0.02222f
C162 VPWR.n4 VNB 0.04444f
C163 VPWR.n5 VNB 0.02222f
C164 VPWR.n6 VNB 0.04444f
C165 VPWR.t8 VNB 0.02678f
C166 VPWR.n7 VNB 0.02222f
C167 VPWR.n8 VNB 0.04444f
C168 VPWR.t9 VNB 0.01512f
C169 VPWR.t6 VNB 0.00752f
C170 VPWR.n9 VNB 0.02124f
C171 VPWR.n10 VNB 0.02222f
C172 VPWR.n11 VNB 0.04444f
C173 VPWR.n12 VNB 0.02222f
C174 VPWR.n13 VNB 0.04444f
C175 VPWR.t1 VNB 0.03862f
C176 VPWR.n14 VNB 0.063f
C177 VPWR.n15 VNB 0.04444f
C178 VPWR.t5 VNB 0.03862f
C179 VPWR.n16 VNB 0.07411f
C180 VPWR.n17 VNB 0.04444f
C181 VPWR.n18 VNB 0.02222f
C182 VPWR.n19 VNB 0.04444f
C183 VPWR.t4 VNB 0.03862f
C184 VPWR.t0 VNB 0.03862f
C185 VPWR.n20 VNB 0.063f
C186 VPWR.n21 VNB 0.04444f
C187 VPWR.t10 VNB 0.03862f
C188 VPWR.n22 VNB 0.08492f
C189 VPWR.n23 VNB 0.17718f
C190 VPWR.n24 VNB 0.06617f
C191 VPWR.n25 VNB 0.02222f
C192 VPWR.n26 VNB 0.02222f
C193 VPWR.n27 VNB 0.01667f
C194 VPWR.n28 VNB 0.04444f
C195 VPWR.n29 VNB 0.04444f
C196 VPWR.n30 VNB 0.01667f
C197 VPWR.n31 VNB 0.01667f
C198 VPWR.n32 VNB 0.063f
C199 VPWR.n33 VNB 0.01667f
C200 VPWR.n34 VNB 0.04444f
C201 VPWR.n35 VNB 0.04444f
C202 VPWR.n36 VNB 0.04444f
C203 VPWR.n37 VNB 0.02222f
C204 VPWR.n38 VNB 0.02222f
C205 VPWR.n39 VNB 0.02222f
C206 VPWR.n40 VNB 0.04444f
C207 VPWR.n41 VNB 0.04444f
C208 VPWR.n42 VNB 0.04444f
C209 VPWR.n43 VNB 0.02222f
C210 VPWR.n44 VNB 0.02222f
C211 VPWR.n45 VNB 0.01667f
C212 VPWR.n46 VNB 0.04444f
C213 VPWR.n47 VNB 0.04444f
C214 VPWR.n48 VNB 0.01667f
C215 VPWR.n49 VNB 0.02222f
C216 VPWR.n50 VNB 0.02222f
C217 VPWR.n51 VNB 0.04444f
C218 VPWR.n52 VNB 0.04444f
C219 VPWR.n53 VNB 0.04444f
C220 VPWR.n54 VNB 0.02222f
C221 VPWR.n55 VNB 0.02222f
C222 VPWR.n56 VNB 0.02222f
C223 VPWR.n57 VNB 0.04444f
C224 VPWR.n58 VNB 0.04444f
C225 VPWR.n59 VNB 0.04444f
C226 VPWR.n60 VNB 0.02222f
C227 VPWR.n61 VNB 0.02222f
C228 VPWR.n62 VNB 0.06052f
C229 VPWR.n63 VNB 0.04444f
C230 VPWR.n64 VNB 0.04444f
C231 VPWR.n65 VNB 0.04444f
C232 VPWR.n66 VNB 0.02222f
C233 VPWR.n67 VNB 0.02222f
C234 VPWR.n68 VNB 0.06327f
C235 VPWR.n69 VNB 0.04444f
C236 VPWR.n70 VNB 0.04444f
C237 VPWR.n71 VNB 0.04444f
C238 VPWR.n72 VNB 0.02222f
C239 VPWR.n73 VNB 0.02222f
C240 VPWR.n74 VNB 0.02222f
C241 VPWR.n75 VNB 0.04444f
C242 VPWR.n76 VNB 0.04444f
C243 VPWR.n77 VNB 0.04444f
C244 VPWR.n78 VNB 0.02222f
C245 VPWR.n79 VNB 0.02222f
C246 VPWR.n80 VNB 0.02222f
C247 VPWR.n81 VNB 0.04444f
C248 VPWR.n82 VNB 0.04444f
C249 VPWR.n83 VNB 0.27179f
C250 VPWR.n84 VNB 0.02222f
C251 VPWR.n85 VNB 0.05347f
C252 VPWR.t2 VNB 0.06387f
C253 VPWR.n86 VNB 0.04168f
C254 VGND.t2 VNB 0.02966f
C255 VGND.t4 VNB 0.02278f
C256 VGND.n0 VNB 0.19996f
C257 VGND.t8 VNB 0.02108f
C258 VGND.n1 VNB 0.05161f
C259 VGND.n2 VNB 0.03588f
C260 VGND.n3 VNB 0.01794f
C261 VGND.n4 VNB 0.03588f
C262 VGND.n5 VNB 0.01794f
C263 VGND.n6 VNB 0.03588f
C264 VGND.t6 VNB 0.02108f
C265 VGND.n7 VNB 0.01794f
C266 VGND.n8 VNB 0.03588f
C267 VGND.t5 VNB 0.01002f
C268 VGND.t7 VNB 0.00607f
C269 VGND.n9 VNB 0.01646f
C270 VGND.n10 VNB 0.01794f
C271 VGND.n11 VNB 0.03588f
C272 VGND.n12 VNB 0.01794f
C273 VGND.n13 VNB 0.03588f
C274 VGND.t9 VNB 0.02108f
C275 VGND.n14 VNB 0.04264f
C276 VGND.n15 VNB 0.03588f
C277 VGND.t3 VNB 0.02108f
C278 VGND.n16 VNB 0.05161f
C279 VGND.n17 VNB 0.03588f
C280 VGND.n18 VNB 0.01794f
C281 VGND.n19 VNB 0.03588f
C282 VGND.t10 VNB 0.02068f
C283 VGND.t1 VNB 0.02068f
C284 VGND.n20 VNB 0.03856f
C285 VGND.n21 VNB 0.03588f
C286 VGND.t0 VNB 0.02108f
C287 VGND.n22 VNB 0.06034f
C288 VGND.n23 VNB 0.14304f
C289 VGND.n24 VNB 0.05342f
C290 VGND.n25 VNB 0.01794f
C291 VGND.n26 VNB 0.01794f
C292 VGND.n27 VNB 0.01346f
C293 VGND.n28 VNB 0.03588f
C294 VGND.n29 VNB 0.03588f
C295 VGND.n30 VNB 0.01346f
C296 VGND.n31 VNB 0.01346f
C297 VGND.n32 VNB 0.03856f
C298 VGND.n33 VNB 0.01346f
C299 VGND.n34 VNB 0.03588f
C300 VGND.n35 VNB 0.03588f
C301 VGND.n36 VNB 0.03588f
C302 VGND.n37 VNB 0.01794f
C303 VGND.n38 VNB 0.01794f
C304 VGND.n39 VNB 0.01794f
C305 VGND.n40 VNB 0.03588f
C306 VGND.n41 VNB 0.03588f
C307 VGND.n42 VNB 0.03588f
C308 VGND.n43 VNB 0.01794f
C309 VGND.n44 VNB 0.01794f
C310 VGND.n45 VNB 0.01346f
C311 VGND.n46 VNB 0.03588f
C312 VGND.n47 VNB 0.03588f
C313 VGND.n48 VNB 0.01346f
C314 VGND.n49 VNB 0.01794f
C315 VGND.n50 VNB 0.01794f
C316 VGND.n51 VNB 0.03588f
C317 VGND.n52 VNB 0.03588f
C318 VGND.n53 VNB 0.03588f
C319 VGND.n54 VNB 0.01794f
C320 VGND.n55 VNB 0.01794f
C321 VGND.n56 VNB 0.01794f
C322 VGND.n57 VNB 0.03588f
C323 VGND.n58 VNB 0.03588f
C324 VGND.n59 VNB 0.03588f
C325 VGND.n60 VNB 0.01794f
C326 VGND.n61 VNB 0.01794f
C327 VGND.n62 VNB 0.04369f
C328 VGND.n63 VNB 0.03588f
C329 VGND.n64 VNB 0.03588f
C330 VGND.n65 VNB 0.03588f
C331 VGND.n66 VNB 0.01794f
C332 VGND.n67 VNB 0.01794f
C333 VGND.n68 VNB 0.05161f
C334 VGND.n69 VNB 0.03588f
C335 VGND.n70 VNB 0.03588f
C336 VGND.n71 VNB 0.03588f
C337 VGND.n72 VNB 0.01794f
C338 VGND.n73 VNB 0.01794f
C339 VGND.n74 VNB 0.01794f
C340 VGND.n75 VNB 0.03588f
C341 VGND.n76 VNB 0.03588f
C342 VGND.n77 VNB 0.03588f
C343 VGND.n78 VNB 0.01794f
C344 VGND.n79 VNB 0.01794f
C345 VGND.n80 VNB 0.01794f
C346 VGND.n81 VNB 0.03588f
C347 VGND.n82 VNB 0.03588f
C348 VGND.n83 VNB 0.21943f
C349 VGND.n84 VNB 0.01794f
C350 VGND.n85 VNB 0.03195f
C351 Q.t0 VNB 0.13164f
C352 Q.t1 VNB 0.07045f
C353 Q.n0 VNB 0.05957f
.ends

.subckt sky130_efx_lvdig__ha_1 A B COUT SUM VGND VNB VPB VPWR
X0 a_108_216.t1 B.t3 VPWR.t3 VPB.t2 sky130_fd_pr__pfet_01v8_hvt ad=0.08775 pd=0.84 as=0.16875 ps=1.65 w=0.45 l=0.15
X1 a_717_450.t0 a_108_216.t5 VPWR.t4 VPB.t1 sky130_fd_pr__pfet_01v8_hvt ad=0.16875 pd=1.65 as=0.16875 ps=1.65 w=0.45 l=0.15
X2 VPWR.t1 a_108_216.t6 COUT.t0 VPB.t0 sky130_fd_pr__pfet_01v8_hvt ad=0.405 pd=2.91 as=0.405 ps=2.91 w=1.08 l=0.15
X3 VPWR.t0 A.t3 a_108_216.t2 VPB.t4 sky130_fd_pr__pfet_01v8_hvt ad=0.08775 pd=0.84 as=0.08775 ps=0.84 w=0.45 l=0.15
X4 SUM.t1 a_717_450.t4 VPWR.t5 VPB.t6 sky130_fd_pr__pfet_01v8_hvt ad=0.405 pd=2.91 as=0.405 ps=2.91 w=1.08 l=0.15
X5 a_609_450.t1 A.t2 VPWR.t2 VPB.t5 sky130_fd_pr__pfet_01v8_hvt ad=0.08775 pd=0.84 as=0.08775 ps=0.84 w=0.45 l=0.15
X6 VGND.t0 B.t0 a_609_36.t0 VNB.t2 sky130_fd_pr__nfet_01v8 ad=0.16875 pd=1.65 as=0.08775 ps=0.84 w=0.45 l=0.15
X7 a_717_450.t1 B.t2 a_609_450.t0 VPB.t3 sky130_fd_pr__pfet_01v8_hvt ad=0.16875 pd=1.65 as=0.08775 ps=0.84 w=0.45 l=0.15
X8 a_609_36.t1 A.t0 VGND.t3 VNB.t4 sky130_fd_pr__nfet_01v8 ad=0.08775 pd=0.84 as=0.08775 ps=0.84 w=0.45 l=0.15
X9 SUM.t0 a_717_450.t3 VGND.t4 VNB.t5 sky130_fd_pr__nfet_01v8 ad=0.23625 pd=2.01 as=0.23625 ps=2.01 w=0.63 l=0.15
X10 VGND.t1 a_108_216.t4 COUT.t1 VNB.t0 sky130_fd_pr__nfet_01v8 ad=0.23625 pd=2.01 as=0.23625 ps=2.01 w=0.63 l=0.15
X11 a_717_450.t2 a_108_216.t3 a_609_36.t2 VNB.t6 sky130_fd_pr__nfet_01v8 ad=0.16875 pd=1.65 as=0.16875 ps=1.65 w=0.45 l=0.15
X12 a_393_36.t0 B.t1 a_108_216.t0 VNB.t1 sky130_fd_pr__nfet_01v8 ad=0.08775 pd=0.84 as=0.16875 ps=1.65 w=0.45 l=0.15
X13 VGND.t2 A.t1 a_393_36.t1 VNB.t3 sky130_fd_pr__nfet_01v8 ad=0.08775 pd=0.84 as=0.08775 ps=0.84 w=0.45 l=0.15
C0 VGND COUT 0.10221f
C1 A VPB 0.16404f
C2 SUM VPB 0.01417f
C3 COUT VPB 0.01121f
C4 VGND VPWR 0.07429f
C5 VGND B 0.05631f
C6 A VPWR 0.07432f
C7 VPWR VPB 0.28343f
C8 SUM VPWR 0.08434f
C9 A B 0.19992f
C10 VPB B 0.2208f
C11 VPWR COUT 0.08657f
C12 COUT B 0.00292f
C13 VPWR B 0.11728f
C14 VGND A 0.04842f
C15 VGND VPB 0.01609f
C16 VGND SUM 0.10221f
R0 VGND.n17 VGND.t0 249.8
R1 VGND VGND.t1 231.744
R2 VGND VGND.t4 231.744
R3 VGND.n2 VGND.n1 201
R4 VGND.n1 VGND.t3 52.0005
R5 VGND.n1 VGND.t2 52.0005
R6 VGND VGND.n18 16.1924
R7 VGND.n17 VGND.n16 12.8005
R8 VGND.n16 VGND.n15 12.8005
R9 VGND.n15 VGND.n2 12.8005
R10 VGND.n11 VGND.n2 12.8005
R11 VGND.n11 VGND.n10 12.8005
R12 VGND.n10 VGND.n9 12.8005
R13 VGND.n9 VGND.n4 12.8005
R14 VGND.n5 VGND.n4 12.8005
R15 VGND.n5 VGND 9.6005
R16 VGND.n7 VGND.n4 9.3005
R17 VGND.n9 VGND.n8 9.3005
R18 VGND.n10 VGND.n3 9.3005
R19 VGND.n12 VGND.n11 9.3005
R20 VGND.n13 VGND.n2 9.3005
R21 VGND.n15 VGND.n14 9.3005
R22 VGND.n16 VGND.n0 9.3005
R23 VGND.n6 VGND.n5 6.26255
R24 VGND.n18 VGND.n17 6.21158
R25 VGND.n6 VGND 0.131507
R26 VGND.n18 VGND.n0 0.109665
R27 VGND.n7 VGND.n6 0.0898878
R28 VGND.n14 VGND.n0 0.063
R29 VGND.n14 VGND.n13 0.063
R30 VGND.n13 VGND.n12 0.063
R31 VGND.n12 VGND.n3 0.063
R32 VGND.n8 VGND.n3 0.063
R33 VGND.n8 VGND.n7 0.063
R34 SUM SUM.t1 366.469
R35 SUM.n0 SUM.t0 222.143
R36 SUM.n0 SUM 19.2005
R37 SUM SUM.n0 9.6005
R38 VPWR.n6 VPWR.t5 793.259
R39 VPWR.n0 VPWR.t1 786.92
R40 VPWR.n7 VPWR.t4 683.168
R41 VPWR.n19 VPWR.t3 683.168
R42 VPWR.n14 VPWR.n4 597.801
R43 VPWR.n4 VPWR.t2 85.3672
R44 VPWR.n4 VPWR.t0 85.3672
R45 VPWR.n8 VPWR.n7 12.8005
R46 VPWR.n8 VPWR.n5 12.8005
R47 VPWR.n12 VPWR.n5 12.8005
R48 VPWR.n13 VPWR.n12 12.8005
R49 VPWR.n14 VPWR.n13 12.8005
R50 VPWR.n14 VPWR.n2 12.8005
R51 VPWR.n18 VPWR.n2 12.8005
R52 VPWR.n19 VPWR.n18 12.8005
R53 VPWR.n20 VPWR.n19 12.8005
R54 VPWR.n20 VPWR.n0 12.8005
R55 VPWR.n21 VPWR.n20 9.3005
R56 VPWR.n19 VPWR.n1 9.3005
R57 VPWR.n18 VPWR.n17 9.3005
R58 VPWR.n16 VPWR.n2 9.3005
R59 VPWR.n15 VPWR.n14 9.3005
R60 VPWR.n13 VPWR.n3 9.3005
R61 VPWR.n12 VPWR.n11 9.3005
R62 VPWR.n10 VPWR.n5 9.3005
R63 VPWR.n9 VPWR.n8 9.3005
R64 VPWR.n22 VPWR.n0 6.26255
R65 VPWR.n7 VPWR.n6 6.08215
R66 VPWR.n9 VPWR.n6 0.2391
R67 VPWR VPWR.n22 0.131507
R68 VPWR.n22 VPWR.n21 0.0898878
R69 VPWR.n10 VPWR.n9 0.063
R70 VPWR.n11 VPWR.n10 0.063
R71 VPWR.n11 VPWR.n3 0.063
R72 VPWR.n15 VPWR.n3 0.063
R73 VPWR.n16 VPWR.n15 0.063
R74 VPWR.n17 VPWR.n16 0.063
R75 VPWR.n17 VPWR.n1 0.063
R76 VPWR.n21 VPWR.n1 0.063
R77 COUT COUT.t0 366.469
R78 COUT.n0 COUT.t1 222.143
R79 COUT.n0 COUT 19.2005
R80 COUT COUT.n0 9.6005
R81 A.n0 A.t0 361.5
R82 A.n1 A.t1 361.5
R83 A.n0 A.t2 159.06
R84 A.n1 A.t3 159.06
R85 A A.n2 158.4
R86 A.n2 A.n0 36.1505
R87 A.n2 A.n1 36.1505
R88 B.n1 B.t3 348.647
R89 B.n0 B.t2 348.647
R90 B.n1 B.t1 232.968
R91 B.n0 B.t0 232.968
R92 B.n2 B.n0 171.565
R93 B.n2 B.n1 152
R94 B B.n2 6.4005
R95 VPB.t1 VPB.t6 604.545
R96 VPB.t3 VPB.t1 604.545
R97 VPB.t0 VPB.t2 604.545
R98 VPB VPB.t0 302.274
R99 VPB.t5 VPB.t3 259.091
R100 VPB.t4 VPB.t5 259.091
R101 VPB.t2 VPB.t4 259.091
R102 VNB.t6 VNB.t5 2800
R103 VNB.t2 VNB.t6 2800
R104 VNB.t0 VNB.t1 2800
R105 VNB VNB.t0 1400
R106 VNB.t4 VNB.t2 1200
R107 VNB.t3 VNB.t4 1200
R108 VNB.t1 VNB.t3 1200
R109 a_609_36.n0 a_609_36.t1 52.0005
R110 a_609_36.t0 a_609_36.n0 52.0005
R111 a_609_36.n0 a_609_36.t2 511.601
R112 a_393_36.t0 a_393_36.t1 104.001
R113 a_609_450.t0 a_609_450.t1 170.733
R114 a_717_450.t0 a_717_450.n0 689.567
R115 a_717_450.n0 a_717_450.n1 190.4
R116 a_717_450.n1 a_717_450.t3 204.048
R117 a_717_450.n1 a_717_450.t4 247.428
R118 a_717_450.n0 a_717_450.t1 734.367
R119 a_717_450.n0 a_717_450.t2 278.601
R120 a_108_216.t0 a_108_216.n3 256.2
R121 a_108_216.n3 a_108_216.n4 171.905
R122 a_108_216.n4 a_108_216.t3 232.968
R123 a_108_216.n4 a_108_216.t5 348.647
R124 a_108_216.n3 a_108_216.n1 32.0005
R125 a_108_216.n1 a_108_216.n2 209.601
R126 a_108_216.n2 a_108_216.t4 204.048
R127 a_108_216.n2 a_108_216.t6 247.428
R128 a_108_216.n1 a_108_216.n0 604.201
R129 a_108_216.n0 a_108_216.t1 85.3672
R130 a_108_216.n0 a_108_216.t2 85.3672
C17 VGND VNB 1.05461f
C18 SUM VNB 0.26309f
C19 VPWR VNB 0.69274f
C20 COUT VNB 0.2651f
C21 A VNB 0.25826f
C22 B VNB 0.31118f
C23 VPB VNB 1.67532f
C24 a_108_216.t0 VNB 0.07752f
C25 a_108_216.t1 VNB 0.02257f
C26 a_108_216.t2 VNB 0.02257f
C27 a_108_216.n0 VNB 0.04779f
C28 a_108_216.n1 VNB 0.55654f
C29 a_108_216.t6 VNB 0.05899f
C30 a_108_216.t4 VNB 0.03673f
C31 a_108_216.n2 VNB 0.20069f
C32 a_108_216.n3 VNB 0.74083f
C33 a_108_216.t5 VNB 0.0464f
C34 a_108_216.t3 VNB 0.03304f
C35 a_108_216.n4 VNB 0.19525f
C36 a_717_450.t0 VNB 0.05426f
C37 a_717_450.t2 VNB 0.06582f
C38 a_717_450.n0 VNB 0.68004f
C39 a_717_450.t1 VNB 0.06605f
C40 a_717_450.t4 VNB 0.03943f
C41 a_717_450.t3 VNB 0.02455f
C42 a_717_450.n1 VNB 0.11668f
C43 a_609_450.t0 VNB 0.01026f
C44 a_609_450.t1 VNB 0.01026f
C45 a_393_36.t0 VNB 0.00824f
C46 a_393_36.t1 VNB 0.00824f
C47 a_609_36.t0 VNB 0.02232f
C48 a_609_36.n0 VNB 0.24173f
C49 a_609_36.t2 VNB 0.23484f
C50 a_609_36.t1 VNB 0.02232f
C51 VPB.t6 VNB 0.22923f
C52 VPB.t1 VNB 0.20057f
C53 VPB.t3 VNB 0.14327f
C54 VPB.t5 VNB 0.08596f
C55 VPB.t4 VNB 0.08596f
C56 VPB.t2 VNB 0.14327f
C57 VPB.t0 VNB 0.15043f
C58 B.t2 VNB 0.05847f
C59 B.t0 VNB 0.04163f
C60 B.n0 VNB 0.23602f
C61 B.t3 VNB 0.05847f
C62 B.t1 VNB 0.04163f
C63 B.n1 VNB 0.20098f
C64 B.n2 VNB 0.55857f
C65 A.t2 VNB 0.02723f
C66 A.t0 VNB 0.06024f
C67 A.n0 VNB 0.14043f
C68 A.t3 VNB 0.02723f
C69 A.t1 VNB 0.06024f
C70 A.n1 VNB 0.14043f
C71 A.n2 VNB 0.06277f
C72 COUT.t0 VNB 0.08485f
C73 COUT.t1 VNB 0.04216f
C74 COUT.n0 VNB 0.03564f
C75 VPWR.t1 VNB 0.05035f
C76 VPWR.n0 VNB 0.05598f
C77 VPWR.n1 VNB 0.03483f
C78 VPWR.t3 VNB 0.02099f
C79 VPWR.n2 VNB 0.01741f
C80 VPWR.n3 VNB 0.03483f
C81 VPWR.t2 VNB 0.0059f
C82 VPWR.t0 VNB 0.0059f
C83 VPWR.n4 VNB 0.01226f
C84 VPWR.n5 VNB 0.01741f
C85 VPWR.t5 VNB 0.05086f
C86 VPWR.n6 VNB 0.19274f
C87 VPWR.t4 VNB 0.02099f
C88 VPWR.n7 VNB 0.05665f
C89 VPWR.n8 VNB 0.01741f
C90 VPWR.n9 VNB 0.213f
C91 VPWR.n10 VNB 0.03483f
C92 VPWR.n11 VNB 0.03483f
C93 VPWR.n12 VNB 0.01741f
C94 VPWR.n13 VNB 0.01741f
C95 VPWR.n14 VNB 0.04743f
C96 VPWR.n15 VNB 0.03483f
C97 VPWR.n16 VNB 0.03483f
C98 VPWR.n17 VNB 0.03483f
C99 VPWR.n18 VNB 0.01741f
C100 VPWR.n19 VNB 0.04958f
C101 VPWR.n20 VNB 0.01741f
C102 VPWR.n21 VNB 0.04775f
C103 VPWR.n22 VNB 0.06355f
C104 SUM.t1 VNB 0.08673f
C105 SUM.t0 VNB 0.04309f
C106 SUM.n0 VNB 0.03643f
C107 VGND.t4 VNB 0.02975f
C108 VGND.n0 VNB 0.10378f
C109 VGND.t0 VNB 0.02074f
C110 VGND.t3 VNB 0.00609f
C111 VGND.t2 VNB 0.00609f
C112 VGND.n1 VNB 0.0138f
C113 VGND.n2 VNB 0.04788f
C114 VGND.n3 VNB 0.03599f
C115 VGND.n4 VNB 0.018f
C116 VGND.t1 VNB 0.02975f
C117 VGND.n5 VNB 0.03338f
C118 VGND.n6 VNB 0.06567f
C119 VGND.n7 VNB 0.04934f
C120 VGND.n8 VNB 0.03599f
C121 VGND.n9 VNB 0.018f
C122 VGND.n10 VNB 0.018f
C123 VGND.n11 VNB 0.018f
C124 VGND.n12 VNB 0.03599f
C125 VGND.n13 VNB 0.03599f
C126 VGND.n14 VNB 0.03599f
C127 VGND.n15 VNB 0.018f
C128 VGND.n16 VNB 0.018f
C129 VGND.n17 VNB 0.05619f
C130 VGND.n18 VNB 0.37799f
.ends

.subckt sky130_efx_lvdig__inv_1 A Y VGND VNB VPB VPWR
X0 Y.t1 A.t1 VPWR.t0 VPB.t0 sky130_fd_pr__pfet_01v8_hvt ad=0.405 pd=2.91 as=0.405 ps=2.91 w=1.08 l=0.15
X1 Y.t0 A.t0 VGND.t0 VNB.t0 sky130_fd_pr__nfet_01v8 ad=0.23625 pd=2.01 as=0.23625 ps=2.01 w=0.63 l=0.15
C0 VPB VPWR 0.06715f
C1 VGND VPWR 0.03199f
C2 VPWR A 0.06489f
C3 VPB Y 0.01427f
C4 VGND Y 0.10009f
C5 A Y 0.04374f
C6 VPB VGND 0.01012f
C7 VPB A 0.05348f
C8 VGND A 0.05415f
C9 VPWR Y 0.13749f
R0 VGND VGND.t0 231.744
R1 Y Y.t1 344.07
R2 Y.n0 Y.t0 222.143
R3 Y.n0 Y 28.8005
R4 Y Y.n0 9.6005
R5 VPWR.n0 VPWR.t0 328.07
R6 VPWR.n0 VPWR 32.6692
R7 VPWR VPWR.n0 16.0005
R8 A.n0 A.t1 247.428
R9 A.n0 A.t0 204.048
R10 A A.n0 158.4
R11 VPB VPB.t0 302.274
R12 VNB VNB.t0 1400
C10 VGND VNB 0.4755f
C11 Y VNB 0.25306f
C12 VPWR VNB 0.47287f
C13 A VNB 0.23375f
C14 VPB VNB 0.37387f
C15 VPB.t0 VNB 0.11329f
C16 A.t1 VNB 0.04175f
C17 A.t0 VNB 0.026f
C18 A.n0 VNB 0.10276f
C19 VPWR.t0 VNB 0.04653f
C20 VPWR.n0 VNB 0.03964f
C21 Y.t1 VNB 0.08152f
C22 Y.t0 VNB 0.04363f
C23 Y.n0 VNB 0.03689f
C24 VGND.t0 VNB 0.0202f
.ends

.subckt sky130_efx_lvdig__inv_2 A Y VGND VNB VPB VPWR
X0 VGND.t1 A.t0 Y.t3 VNB.t1 sky130_fd_pr__nfet_01v8 ad=0.23625 pd=2.01 as=0.12285 ps=1.02 w=0.63 l=0.15
X1 Y.t2 A.t3 VPWR.t1 VPB.t0 sky130_fd_pr__pfet_01v8_hvt ad=0.2106 pd=1.47 as=0.405 ps=2.91 w=1.08 l=0.15
X2 VPWR.t0 A.t2 Y.t1 VPB.t1 sky130_fd_pr__pfet_01v8_hvt ad=0.405 pd=2.91 as=0.2106 ps=1.47 w=1.08 l=0.15
X3 Y.t0 A.t1 VGND.t0 VNB.t0 sky130_fd_pr__nfet_01v8 ad=0.12285 pd=1.02 as=0.23625 ps=2.01 w=0.63 l=0.15
C0 A VPB 0.09788f
C1 VPWR VGND 0.05009f
C2 Y VGND 0.15357f
C3 A VPWR 0.09572f
C4 Y A 0.10877f
C5 A VGND 0.08139f
C6 VPWR VPB 0.0766f
C7 Y VPB 0.00717f
C8 VPB VGND 0.00844f
C9 Y VPWR 0.22627f
R0 VGND VGND.t1 231.744
R1 VGND VGND.t0 231.744
R2 VGND.n0 VGND 16.4571
R3 VGND VGND.n0 16.3067
R4 VGND.n0 VGND 0.354563
R5 Y Y.n0 308.5
R6 Y.n2 Y.n1 185
R7 Y.n1 Y.t3 37.1434
R8 Y.n1 Y.t0 37.1434
R9 Y.n0 Y.t1 35.5699
R10 Y.n0 Y.t2 35.5699
R11 Y Y.n2 19.2005
R12 Y.n2 Y 9.6005
R13 VPWR.n0 VPWR.t1 328.07
R14 VPWR.n2 VPWR.t0 328.07
R15 VPWR.n2 VPWR.n1 32.4571
R16 VPWR.n1 VPWR.n0 32.3067
R17 VPWR.n0 VPWR 16.0005
R18 VPWR VPWR.n2 16.0005
R19 VPWR.n1 VPWR 0.354563
R20 A.n0 A.t2 231.361
R21 A.n1 A.t3 231.361
R22 A A.n1 194.55
R23 A.n0 A.t0 187.981
R24 A.n1 A.t1 187.981
R25 A.n1 A.n0 72.3005
R26 VPB VPB.t0 302.274
R27 VPB.t0 VPB.t1 259.091
R28 VNB VNB.t0 1400
R29 VNB.t0 VNB.t1 1200
C10 VGND VNB 0.54313f
C11 Y VNB 0.28408f
C12 VPWR VNB 0.49025f
C13 A VNB 0.3285f
C14 VPB VNB 0.46095f
C15 VPB.t1 VNB 0.09505f
C16 VPB.t0 VNB 0.06178f
C17 A.t3 VNB 0.03916f
C18 A.t1 VNB 0.02325f
C19 A.t2 VNB 0.03916f
C20 A.t0 VNB 0.02325f
C21 A.n0 VNB 0.08248f
C22 A.n1 VNB 0.12299f
C23 VPWR.t1 VNB 0.04565f
C24 VPWR.n0 VNB 0.03783f
C25 VPWR.n1 VNB 0.11587f
C26 VPWR.t0 VNB 0.04565f
C27 VPWR.n2 VNB 0.03842f
C28 Y.t1 VNB 0.03317f
C29 Y.t2 VNB 0.03317f
C30 Y.n0 VNB 0.07083f
C31 Y.t3 VNB 0.01935f
C32 Y.t0 VNB 0.01935f
C33 Y.n1 VNB 0.03869f
C34 Y.n2 VNB 0.04592f
C35 VGND.t0 VNB 0.02096f
C36 VGND.t1 VNB 0.02096f
C37 VGND.n0 VNB 0.07022f
.ends

.subckt sky130_efx_lvdig__inv_4 A Y VGND VNB VPB VPWR
X0 VGND.t0 A.t2 Y.t3 VNB.t1 sky130_fd_pr__nfet_01v8 ad=0.12285 pd=1.02 as=0.12285 ps=1.02 w=0.63 l=0.15
X1 Y.t5 A.t1 VGND.t2 VNB.t2 sky130_fd_pr__nfet_01v8 ad=0.12285 pd=1.02 as=0.12285 ps=1.02 w=0.63 l=0.15
X2 VGND.t1 A.t0 Y.t4 VNB.t3 sky130_fd_pr__nfet_01v8 ad=0.23625 pd=2.01 as=0.12285 ps=1.02 w=0.63 l=0.15
X3 Y.t7 A.t7 VPWR.t3 VPB.t0 sky130_fd_pr__pfet_01v8_hvt ad=0.2106 pd=1.47 as=0.405 ps=2.91 w=1.08 l=0.15
X4 VPWR.t0 A.t6 Y.t0 VPB.t1 sky130_fd_pr__pfet_01v8_hvt ad=0.2106 pd=1.47 as=0.2106 ps=1.47 w=1.08 l=0.15
X5 Y.t1 A.t5 VPWR.t1 VPB.t2 sky130_fd_pr__pfet_01v8_hvt ad=0.2106 pd=1.47 as=0.2106 ps=1.47 w=1.08 l=0.15
X6 VPWR.t2 A.t4 Y.t2 VPB.t3 sky130_fd_pr__pfet_01v8_hvt ad=0.405 pd=2.91 as=0.2106 ps=1.47 w=1.08 l=0.15
X7 Y.t6 A.t3 VGND.t3 VNB.t0 sky130_fd_pr__nfet_01v8 ad=0.12285 pd=1.02 as=0.23625 ps=2.01 w=0.63 l=0.15
C0 VGND VPB 0.00912f
C1 A Y 0.23208f
C2 VPWR Y 0.48984f
C3 A VPWR 0.15818f
C4 VPB Y 0.01503f
C5 A VPB 0.19009f
C6 VGND Y 0.34107f
C7 VPWR VPB 0.11025f
C8 A VGND 0.13357f
C9 VGND VPWR 0.07001f
R0 VGND VGND.t1 231.744
R1 VGND VGND.t3 231.744
R2 VGND VGND.n2 194.601
R3 VGND.n2 VGND.t2 37.1434
R4 VGND.n2 VGND.t0 37.1434
R5 VGND.n3 VGND 16.2074
R6 VGND.n10 VGND.n9 15.7005
R7 VGND.n6 VGND.n5 12.8005
R8 VGND.n6 VGND.n0 12.8005
R9 VGND.n4 VGND.n3 12.1406
R10 VGND.n4 VGND 9.6005
R11 VGND VGND.n10 9.6005
R12 VGND.n8 VGND.n0 9.3005
R13 VGND.n7 VGND.n6 9.3005
R14 VGND.n5 VGND.n1 9.3005
R15 VGND.n5 VGND.n4 6.4005
R16 VGND.n10 VGND.n0 6.4005
R17 VGND.n3 VGND.n1 0.584022
R18 VGND.n7 VGND.n1 0.063
R19 VGND.n8 VGND.n7 0.063
R20 VGND.n9 VGND.n8 0.063
R21 VGND.n9 VGND 0.03175
R22 Y Y.n3 308.5
R23 Y Y.n0 308.5
R24 Y.n5 Y.n4 185
R25 Y.n2 Y.n1 185
R26 Y.n7 Y.n6 38.4005
R27 Y.n4 Y.t4 37.1434
R28 Y.n4 Y.t5 37.1434
R29 Y.n1 Y.t3 37.1434
R30 Y.n1 Y.t6 37.1434
R31 Y.n3 Y.t2 35.5699
R32 Y.n3 Y.t1 35.5699
R33 Y.n0 Y.t0 35.5699
R34 Y.n0 Y.t7 35.5699
R35 Y.n6 Y.n5 19.2005
R36 Y.n7 Y.n2 19.2005
R37 Y.n6 Y 9.6005
R38 Y.n5 Y 9.6005
R39 Y Y.n7 9.6005
R40 Y.n2 Y 9.6005
R41 Y.n7 Y 6.4005
R42 VPWR.n4 VPWR.t3 328.07
R43 VPWR.n13 VPWR.t2 328.07
R44 VPWR.n2 VPWR.n1 292.5
R45 VPWR.n1 VPWR.t1 35.5699
R46 VPWR.n1 VPWR.t0 35.5699
R47 VPWR.n13 VPWR.n12 32.2074
R48 VPWR.n5 VPWR.n4 25.6005
R49 VPWR.n11 VPWR.n2 25.6005
R50 VPWR.n4 VPWR 16.0005
R51 VPWR.n2 VPWR 16.0005
R52 VPWR VPWR.n13 16.0005
R53 VPWR.n6 VPWR.n5 15.7005
R54 VPWR.n10 VPWR.n9 12.8005
R55 VPWR.n9 VPWR.n3 12.8005
R56 VPWR.n12 VPWR.n11 12.1406
R57 VPWR.n7 VPWR.n3 9.3005
R58 VPWR.n9 VPWR.n8 9.3005
R59 VPWR.n10 VPWR.n0 9.3005
R60 VPWR.n11 VPWR.n10 6.4005
R61 VPWR.n5 VPWR.n3 6.4005
R62 VPWR.n12 VPWR.n0 0.584022
R63 VPWR.n8 VPWR.n0 0.063
R64 VPWR.n8 VPWR.n7 0.063
R65 VPWR.n7 VPWR.n6 0.063
R66 VPWR.n6 VPWR 0.03175
R67 A.n0 A.t4 231.361
R68 A.n1 A.t5 231.361
R69 A.n2 A.t6 231.361
R70 A.n3 A.t7 231.361
R71 A A.n3 194.55
R72 A.n0 A.t0 187.981
R73 A.n1 A.t1 187.981
R74 A.n2 A.t2 187.981
R75 A.n3 A.t3 187.981
R76 A.n1 A.n0 72.3005
R77 A.n2 A.n1 72.3005
R78 A.n3 A.n2 72.3005
R79 VPB VPB.t0 302.274
R80 VPB.t2 VPB.t3 259.091
R81 VPB.t1 VPB.t2 259.091
R82 VPB.t0 VPB.t1 259.091
R83 VNB VNB.t0 1400
R84 VNB.t2 VNB.t3 1200
R85 VNB.t1 VNB.t2 1200
R86 VNB.t0 VNB.t1 1200
C10 VGND VNB 0.58717f
C11 Y VNB 0.36864f
C12 VPWR VNB 0.46399f
C13 A VNB 0.50106f
C14 VPB VNB 0.71978f
C15 VPB.t3 VNB 0.1014f
C16 VPB.t2 VNB 0.06084f
C17 VPB.t1 VNB 0.06084f
C18 VPB.t0 VNB 0.06591f
C19 A.t7 VNB 0.0388f
C20 A.t3 VNB 0.02304f
C21 A.t6 VNB 0.0388f
C22 A.t2 VNB 0.02304f
C23 A.t5 VNB 0.0388f
C24 A.t1 VNB 0.02304f
C25 A.t4 VNB 0.0388f
C26 A.t0 VNB 0.02304f
C27 A.n0 VNB 0.08172f
C28 A.n1 VNB 0.105f
C29 A.n2 VNB 0.105f
C30 A.n3 VNB 0.12186f
C31 VPWR.n0 VNB 0.17203f
C32 VPWR.t1 VNB 0.01529f
C33 VPWR.t0 VNB 0.01529f
C34 VPWR.n1 VNB 0.03059f
C35 VPWR.n2 VNB 0.03059f
C36 VPWR.n3 VNB 0.01412f
C37 VPWR.t3 VNB 0.05411f
C38 VPWR.n4 VNB 0.03531f
C39 VPWR.n5 VNB 0.0366f
C40 VPWR.n6 VNB 0.03399f
C41 VPWR.n7 VNB 0.03765f
C42 VPWR.n8 VNB 0.03765f
C43 VPWR.n9 VNB 0.01882f
C44 VPWR.n10 VNB 0.01412f
C45 VPWR.n11 VNB 0.03756f
C46 VPWR.n12 VNB 0.08676f
C47 VPWR.t2 VNB 0.05411f
C48 VPWR.n13 VNB 0.04486f
C49 Y.t0 VNB 0.03331f
C50 Y.t7 VNB 0.03331f
C51 Y.n0 VNB 0.07115f
C52 Y.t3 VNB 0.01943f
C53 Y.t6 VNB 0.01943f
C54 Y.n1 VNB 0.03887f
C55 Y.n2 VNB 0.04613f
C56 Y.t2 VNB 0.03331f
C57 Y.t1 VNB 0.03331f
C58 Y.n3 VNB 0.07115f
C59 Y.t4 VNB 0.01943f
C60 Y.t5 VNB 0.01943f
C61 Y.n4 VNB 0.03887f
C62 Y.n5 VNB 0.04613f
C63 Y.n6 VNB 0.12813f
C64 Y.n7 VNB 0.11788f
C65 VGND.t3 VNB 0.02523f
C66 VGND.n0 VNB 0.01144f
C67 VGND.n1 VNB 0.13945f
C68 VGND.t2 VNB 0.00723f
C69 VGND.t0 VNB 0.00723f
C70 VGND.n2 VNB 0.01531f
C71 VGND.t1 VNB 0.02523f
C72 VGND.n3 VNB 0.05703f
C73 VGND.n4 VNB 0.02091f
C74 VGND.n5 VNB 0.01144f
C75 VGND.n6 VNB 0.01526f
C76 VGND.n7 VNB 0.03052f
C77 VGND.n8 VNB 0.03052f
C78 VGND.n9 VNB 0.02755f
C79 VGND.n10 VNB 0.02013f
.ends

.subckt sky130_efx_lvdig__mux2_1 A0 A1 S X VGND VNB VPB VPWR
X0 a_861_450.t1 a_324_180.t3 VPWR.t2 VPB.t2 sky130_fd_pr__pfet_01v8_hvt ad=0.08775 pd=0.84 as=0.16875 ps=1.65 w=0.45 l=0.15
X1 a_249_36.t1 A0.t0 a_144_36.t2 VNB.t3 sky130_fd_pr__nfet_01v8 ad=0.08775 pd=0.84 as=0.16875 ps=1.65 w=0.45 l=0.15
X2 VGND.t1 a_324_180.t2 a_249_36.t0 VNB.t2 sky130_fd_pr__nfet_01v8 ad=0.16875 pd=1.65 as=0.08775 ps=0.84 w=0.45 l=0.15
X3 a_144_36.t1 A1.t1 a_861_450.t0 VPB.t0 sky130_fd_pr__pfet_01v8_hvt ad=0.16875 pd=1.65 as=0.08775 ps=0.84 w=0.45 l=0.15
X4 a_861_36.t1 S.t0 VGND.t2 VNB.t5 sky130_fd_pr__nfet_01v8 ad=0.08775 pd=0.84 as=0.16875 ps=1.65 w=0.45 l=0.15
X5 VPWR.t3 S.t2 a_324_180.t1 VPB.t5 sky130_fd_pr__pfet_01v8_hvt ad=0.16875 pd=1.65 as=0.16875 ps=1.65 w=0.45 l=0.15
X6 VGND.t3 S.t1 a_324_180.t0 VNB.t4 sky130_fd_pr__nfet_01v8 ad=0.16875 pd=1.65 as=0.16875 ps=1.65 w=0.45 l=0.15
X7 a_144_36.t0 A1.t0 a_861_36.t0 VNB.t0 sky130_fd_pr__nfet_01v8 ad=0.16875 pd=1.65 as=0.08775 ps=0.84 w=0.45 l=0.15
X8 X.t1 a_144_36.t4 VGND.t0 VNB.t1 sky130_fd_pr__nfet_01v8 ad=0.23625 pd=2.01 as=0.23625 ps=2.01 w=0.63 l=0.15
X9 a_249_450.t0 A0.t1 a_144_36.t3 VPB.t3 sky130_fd_pr__pfet_01v8_hvt ad=0.08775 pd=0.84 as=0.16875 ps=1.65 w=0.45 l=0.15
X10 VPWR.t0 S.t3 a_249_450.t1 VPB.t4 sky130_fd_pr__pfet_01v8_hvt ad=0.16875 pd=1.65 as=0.08775 ps=0.84 w=0.45 l=0.15
X11 X.t0 a_144_36.t5 VPWR.t1 VPB.t1 sky130_fd_pr__pfet_01v8_hvt ad=0.405 pd=2.91 as=0.405 ps=2.91 w=1.08 l=0.15
C0 VPWR A1 0.02569f
C1 X VGND 0.10221f
C2 S A1 0.03776f
C3 VPWR A0 0.02312f
C4 S VPWR 0.0684f
C5 X A1 0.00107f
C6 X VPWR 0.13857f
C7 S A0 0.04299f
C8 VGND VPB 0.0141f
C9 A1 VPB 0.1359f
C10 VPWR VPB 0.29762f
C11 VGND A1 0.01693f
C12 A0 VPB 0.13097f
C13 S VPB 0.28386f
C14 VGND VPWR 0.04137f
C15 X VPB 0.00972f
C16 VGND A0 0.01596f
C17 S VGND 0.08055f
R0 VGND.n4 VGND.t1 253
R1 VGND.n0 VGND.t2 253
R2 VGND.n10 VGND.t3 253
R3 VGND VGND.t0 231.744
R4 VGND VGND.n14 14.5486
R5 VGND.n12 VGND.n11 12.8005
R6 VGND.n9 VGND.n2 12.8005
R7 VGND.n5 VGND.n2 12.8005
R8 VGND.n5 VGND.n4 12.8005
R9 VGND.n14 VGND.n0 12.6037
R10 VGND.n6 VGND.n5 9.3005
R11 VGND.n7 VGND.n2 9.3005
R12 VGND.n9 VGND.n8 9.3005
R13 VGND.n11 VGND.n1 9.3005
R14 VGND.n13 VGND.n12 9.3005
R15 VGND.n12 VGND.n0 6.4005
R16 VGND.n11 VGND.n10 6.4005
R17 VGND.n10 VGND.n9 6.4005
R18 VGND.n4 VGND.n3 6.2273
R19 VGND.n3 VGND 0.31702
R20 VGND.n14 VGND.n13 0.117593
R21 VGND.n6 VGND.n3 0.0939888
R22 VGND.n13 VGND.n1 0.063
R23 VGND.n8 VGND.n1 0.063
R24 VGND.n8 VGND.n7 0.063
R25 VGND.n7 VGND.n6 0.063
R26 X X.t0 344.07
R27 X.n0 X.t1 222.143
R28 X X.n0 19.2005
R29 X.n0 X 9.6005
R30 VPWR.n4 VPWR.t0 683.168
R31 VPWR.n10 VPWR.t3 683.168
R32 VPWR.n0 VPWR.t2 683.168
R33 VPWR.n15 VPWR.t1 328.07
R34 VPWR.n15 VPWR.n14 30.5486
R35 VPWR VPWR.n15 16.0005
R36 VPWR.n12 VPWR.n11 12.8005
R37 VPWR.n9 VPWR.n2 12.8005
R38 VPWR.n5 VPWR.n2 12.8005
R39 VPWR.n5 VPWR.n4 12.8005
R40 VPWR.n14 VPWR.n0 12.6037
R41 VPWR.n6 VPWR.n5 9.3005
R42 VPWR.n7 VPWR.n2 9.3005
R43 VPWR.n9 VPWR.n8 9.3005
R44 VPWR.n11 VPWR.n1 9.3005
R45 VPWR.n13 VPWR.n12 9.3005
R46 VPWR.n12 VPWR.n0 6.4005
R47 VPWR.n11 VPWR.n10 6.4005
R48 VPWR.n10 VPWR.n9 6.4005
R49 VPWR.n4 VPWR.n3 6.2273
R50 VPWR.n3 VPWR 0.31702
R51 VPWR.n14 VPWR.n13 0.117593
R52 VPWR.n6 VPWR.n3 0.0939888
R53 VPWR.n13 VPWR.n1 0.063
R54 VPWR.n8 VPWR.n1 0.063
R55 VPWR.n8 VPWR.n7 0.063
R56 VPWR.n7 VPWR.n6 0.063
R57 A1.n0 A1.t0 406.488
R58 A1.n0 A1.t1 175.127
R59 A1 A1.n0 158.4
R60 S.n0 S.t3 327.76
R61 S.n2 S.t0 291.611
R62 S.n1 S.t1 159.06
R63 S.n0 S.t2 159.06
R64 S S.n2 158.4
R65 S.n1 S.n0 115.68
R66 S.n2 S.n1 36.1505
R67 A0.n0 A0.t0 406.488
R68 A0.n0 A0.t1 175.127
R69 A0 A0.n0 158.4
R70 VPB.t0 VPB.t1 690.909
R71 VPB.t5 VPB.t2 604.545
R72 VPB.t4 VPB.t5 604.545
R73 VPB VPB.t3 561.365
R74 VPB.t2 VPB.t0 259.091
R75 VPB.t3 VPB.t4 259.091
R76 VNB.t0 VNB.t1 3200
R77 VNB.t4 VNB.t5 2800
R78 VNB.t2 VNB.t4 2800
R79 VNB VNB.t3 2600
R80 VNB.t5 VNB.t0 1200
R81 VNB.t3 VNB.t2 1200
R82 a_861_36.t0 a_861_36.t1 104.001
R83 a_249_36.t0 a_249_36.t1 104.001
R84 a_861_450.t0 a_861_450.t1 170.733
R85 a_249_450.t0 a_249_450.t1 170.733
R86 a_144_36.t0 a_144_36.n0 253
R87 a_144_36.n0 a_144_36.n2 38.4005
R88 a_144_36.n2 a_144_36.n3 168
R89 a_144_36.n3 a_144_36.t4 204.048
R90 a_144_36.n3 a_144_36.t5 247.428
R91 a_144_36.n2 a_144_36.t1 750.367
R92 a_144_36.n0 a_144_36.n1 20.9309
R93 a_144_36.n1 a_144_36.t3 820.768
R94 a_144_36.n1 a_144_36.t2 259.401
R95 a_324_180.t0 a_324_180.n1 253
R96 a_324_180.n1 a_324_180.t2 372.81
R97 a_324_180.n1 a_324_180.n0 12.8005
R98 a_324_180.n0 a_324_180.t3 392.01
R99 a_324_180.n0 a_324_180.t1 689.567
C18 VGND VNB 1.09855f
C19 X VNB 0.27494f
C20 VPWR VNB 0.80435f
C21 A1 VNB 0.20895f
C22 S VNB 0.40559f
C23 A0 VNB 0.22262f
C24 VPB VNB 1.72955f
C25 a_324_180.t0 VNB 0.06188f
C26 a_324_180.t1 VNB 0.06326f
C27 a_324_180.n0 VNB 0.39658f
C28 a_324_180.t3 VNB 0.08191f
C29 a_324_180.n1 VNB 0.33019f
C30 a_324_180.t2 VNB 0.07175f
C31 a_144_36.t0 VNB 0.06652f
C32 a_144_36.n0 VNB 0.47221f
C33 a_144_36.t2 VNB 0.0692f
C34 a_144_36.n1 VNB 0.7219f
C35 a_144_36.t3 VNB 0.10203f
C36 a_144_36.t1 VNB 0.08111f
C37 a_144_36.n2 VNB 0.29583f
C38 a_144_36.t5 VNB 0.05076f
C39 a_144_36.t4 VNB 0.03161f
C40 a_144_36.n3 VNB 0.12936f
C41 a_249_450.t0 VNB 0.00951f
C42 a_249_450.t1 VNB 0.00951f
C43 a_861_450.t0 VNB 0.00951f
C44 a_861_450.t1 VNB 0.00951f
C45 a_249_36.t0 VNB 0.01036f
C46 a_249_36.t1 VNB 0.01036f
C47 a_861_36.t0 VNB 0.01036f
C48 a_861_36.t1 VNB 0.01036f
C49 VPB.t1 VNB 0.24086f
C50 VPB.t0 VNB 0.17663f
C51 VPB.t2 VNB 0.16058f
C52 VPB.t5 VNB 0.22481f
C53 VPB.t4 VNB 0.16058f
C54 VPB.t3 VNB 0.15255f
C55 A0.t1 VNB 0.02903f
C56 A0.t0 VNB 0.05802f
C57 A0.n0 VNB 0.17575f
C58 S.t0 VNB 0.08109f
C59 S.t2 VNB 0.02274f
C60 S.t3 VNB 0.10178f
C61 S.n0 VNB 0.24208f
C62 S.t1 VNB 0.02274f
C63 S.n1 VNB 0.07521f
C64 S.n2 VNB 0.18959f
C65 A1.t1 VNB 0.03252f
C66 A1.t0 VNB 0.06498f
C67 A1.n0 VNB 0.19682f
C68 VPWR.t2 VNB 0.02204f
C69 VPWR.n0 VNB 0.05387f
C70 VPWR.n1 VNB 0.03657f
C71 VPWR.t3 VNB 0.02204f
C72 VPWR.n2 VNB 0.01829f
C73 VPWR.n3 VNB 0.14579f
C74 VPWR.t0 VNB 0.02204f
C75 VPWR.n4 VNB 0.06095f
C76 VPWR.n5 VNB 0.01829f
C77 VPWR.n6 VNB 0.05445f
C78 VPWR.n7 VNB 0.03657f
C79 VPWR.n8 VNB 0.03657f
C80 VPWR.n9 VNB 0.01371f
C81 VPWR.n10 VNB 0.04292f
C82 VPWR.n11 VNB 0.01371f
C83 VPWR.n12 VNB 0.01371f
C84 VPWR.n13 VNB 0.11613f
C85 VPWR.n14 VNB 0.35126f
C86 VPWR.t1 VNB 0.05256f
C87 VPWR.n15 VNB 0.04508f
C88 X.t0 VNB 0.08159f
C89 X.t1 VNB 0.04366f
C90 X.n0 VNB 0.03692f
C91 VGND.t0 VNB 0.03257f
C92 VGND.t2 VNB 0.02315f
C93 VGND.n0 VNB 0.05863f
C94 VGND.n1 VNB 0.0394f
C95 VGND.t3 VNB 0.02315f
C96 VGND.n2 VNB 0.0197f
C97 VGND.n3 VNB 0.15708f
C98 VGND.t1 VNB 0.02315f
C99 VGND.n4 VNB 0.06626f
C100 VGND.n5 VNB 0.0197f
C101 VGND.n6 VNB 0.05866f
C102 VGND.n7 VNB 0.0394f
C103 VGND.n8 VNB 0.0394f
C104 VGND.n9 VNB 0.01478f
C105 VGND.n10 VNB 0.04683f
C106 VGND.n11 VNB 0.01478f
C107 VGND.n12 VNB 0.01478f
C108 VGND.n13 VNB 0.12512f
C109 VGND.n14 VNB 0.35755f
.ends

.subckt sky130_efx_lvdig__mux2_2 A0 A1 S X VGND VNB VPB VPWR
X0 a_249_36.t1 A0.t0 a_144_36.t3 VNB.t6 sky130_fd_pr__nfet_01v8 ad=0.08775 pd=0.84 as=0.16875 ps=1.65 w=0.45 l=0.15
X1 VGND.t3 a_324_180.t2 a_249_36.t0 VNB.t1 sky130_fd_pr__nfet_01v8 ad=0.16875 pd=1.65 as=0.08775 ps=0.84 w=0.45 l=0.15
X2 a_861_36.t0 S.t0 VGND.t1 VNB.t4 sky130_fd_pr__nfet_01v8 ad=0.08775 pd=0.84 as=0.16875 ps=1.65 w=0.45 l=0.15
X3 a_249_414.t1 A0.t1 a_144_36.t2 VPB.t6 sky130_fd_pr__pfet_01v8_hvt ad=0.12285 pd=1.02 as=0.23625 ps=2.01 w=0.63 l=0.15
X4 VGND.t0 S.t1 a_324_180.t1 VNB.t3 sky130_fd_pr__nfet_01v8 ad=0.16875 pd=1.65 as=0.16875 ps=1.65 w=0.45 l=0.15
X5 VPWR.t3 S.t3 a_249_414.t0 VPB.t2 sky130_fd_pr__pfet_01v8_hvt ad=0.23625 pd=2.01 as=0.12285 ps=1.02 w=0.63 l=0.15
X6 a_861_414.t0 a_324_180.t3 VPWR.t2 VPB.t1 sky130_fd_pr__pfet_01v8_hvt ad=0.12285 pd=1.02 as=0.23625 ps=2.01 w=0.63 l=0.15
X7 a_144_36.t0 A1.t0 a_861_36.t1 VNB.t5 sky130_fd_pr__nfet_01v8 ad=0.16875 pd=1.65 as=0.08775 ps=0.84 w=0.45 l=0.15
X8 X.t2 a_144_36.t5 VGND.t4 VNB.t2 sky130_fd_pr__nfet_01v8 ad=0.12285 pd=1.02 as=0.23625 ps=2.01 w=0.63 l=0.15
X9 VGND.t2 a_144_36.t4 X.t0 VNB.t0 sky130_fd_pr__nfet_01v8 ad=0.23625 pd=2.01 as=0.12285 ps=1.02 w=0.63 l=0.15
X10 a_144_36.t1 A1.t1 a_861_414.t1 VPB.t4 sky130_fd_pr__pfet_01v8_hvt ad=0.23625 pd=2.01 as=0.12285 ps=1.02 w=0.63 l=0.15
X11 X.t1 a_144_36.t7 VPWR.t1 VPB.t0 sky130_fd_pr__pfet_01v8_hvt ad=0.2106 pd=1.47 as=0.405 ps=2.91 w=1.08 l=0.15
X12 VPWR.t0 S.t2 a_324_180.t0 VPB.t3 sky130_fd_pr__pfet_01v8_hvt ad=0.23625 pd=2.01 as=0.23625 ps=2.01 w=0.63 l=0.15
X13 VPWR.t4 a_144_36.t6 X.t3 VPB.t5 sky130_fd_pr__pfet_01v8_hvt ad=0.405 pd=2.91 as=0.2106 ps=1.47 w=1.08 l=0.15
C0 A1 VPB 0.11122f
C1 X VPB 0.00762f
C3 VGND A0 0.0161f
C4 VPWR A0 0.02289f
C5 S A0 0.03278f
C6 S VGND 0.08444f
C7 VGND VPWR 0.06841f
C8 S VPWR 0.0757f
C9 VPB A0 0.11271f
C10 VGND VPB 0.01628f
C11 S VPB 0.24252f
C12 VPWR VPB 0.32944f
C13 A1 VGND 0.01719f
C14 A1 VPWR 0.02507f
C15 S A1 0.03126f
C16 VGND X 0.15357f
C17 X VPWR 0.22627f
R0 VGND.n7 VGND.t3 253
R1 VGND.n4 VGND.t1 253
R2 VGND.n13 VGND.t0 253
R3 VGND VGND.t2 231.744
R4 VGND VGND.t4 231.744
R5 VGND.n24 VGND 14.3698
R6 VGND.n25 VGND.n0 12.8005
R7 VGND.n21 VGND.n0 12.8005
R8 VGND.n21 VGND.n20 12.8005
R9 VGND.n20 VGND.n19 12.8005
R10 VGND.n19 VGND.n2 12.8005
R11 VGND.n15 VGND.n14 12.8005
R12 VGND.n12 VGND.n5 12.8005
R13 VGND.n8 VGND.n5 12.8005
R14 VGND.n8 VGND.n7 12.8005
R15 VGND VGND.n25 9.6005
R16 VGND.n9 VGND.n8 9.3005
R17 VGND.n10 VGND.n5 9.3005
R18 VGND.n12 VGND.n11 9.3005
R19 VGND.n14 VGND.n3 9.3005
R20 VGND.n16 VGND.n15 9.3005
R21 VGND.n17 VGND.n2 9.3005
R22 VGND.n19 VGND.n18 9.3005
R23 VGND.n20 VGND.n1 9.3005
R24 VGND.n22 VGND.n21 9.3005
R25 VGND.n23 VGND.n0 9.3005
R26 VGND.n4 VGND.n2 6.4005
R27 VGND.n15 VGND.n4 6.4005
R28 VGND.n14 VGND.n13 6.4005
R29 VGND.n13 VGND.n12 6.4005
R30 VGND.n7 VGND.n6 6.2273
R31 VGND.n25 VGND.n24 6.00163
R32 VGND.n24 VGND.n23 0.319971
R33 VGND.n6 VGND 0.31702
R34 VGND.n9 VGND.n6 0.0939888
R35 VGND.n23 VGND.n22 0.063
R36 VGND.n22 VGND.n1 0.063
R37 VGND.n18 VGND.n1 0.063
R38 VGND.n18 VGND.n17 0.063
R39 VGND.n17 VGND.n16 0.063
R40 VGND.n16 VGND.n3 0.063
R41 VGND.n11 VGND.n3 0.063
R42 VGND.n11 VGND.n10 0.063
R43 VGND.n10 VGND.n9 0.063
R44 X X.n0 308.5
R45 X.n2 X.n1 185
R46 X.n1 X.t0 37.1434
R47 X.n1 X.t2 37.1434
R48 X.n0 X.t3 35.5699
R49 X.n0 X.t1 35.5699
R50 X X.n2 19.2005
R51 X.n2 X 9.6005
R52 VPWR.n7 VPWR.t3 661.976
R53 VPWR.n13 VPWR.t0 661.976
R54 VPWR.n4 VPWR.t2 661.976
R55 VPWR.n24 VPWR.t4 328.07
R56 VPWR.n27 VPWR.t1 328.07
R57 VPWR.n25 VPWR.n24 30.3698
R58 VPWR.n27 VPWR.n26 25.6005
R59 VPWR.n24 VPWR 16.0005
R60 VPWR VPWR.n27 16.0005
R61 VPWR.n26 VPWR.n0 12.8005
R62 VPWR.n21 VPWR.n0 12.8005
R63 VPWR.n21 VPWR.n20 12.8005
R64 VPWR.n20 VPWR.n19 12.8005
R65 VPWR.n19 VPWR.n2 12.8005
R66 VPWR.n15 VPWR.n14 12.8005
R67 VPWR.n12 VPWR.n5 12.8005
R68 VPWR.n8 VPWR.n5 12.8005
R69 VPWR.n8 VPWR.n7 12.8005
R70 VPWR.n9 VPWR.n8 9.3005
R71 VPWR.n10 VPWR.n5 9.3005
R72 VPWR.n12 VPWR.n11 9.3005
R73 VPWR.n14 VPWR.n3 9.3005
R74 VPWR.n16 VPWR.n15 9.3005
R75 VPWR.n17 VPWR.n2 9.3005
R76 VPWR.n19 VPWR.n18 9.3005
R77 VPWR.n20 VPWR.n1 9.3005
R78 VPWR.n22 VPWR.n21 9.3005
R79 VPWR.n23 VPWR.n0 9.3005
R80 VPWR.n4 VPWR.n2 6.4005
R81 VPWR.n15 VPWR.n4 6.4005
R82 VPWR.n14 VPWR.n13 6.4005
R83 VPWR.n13 VPWR.n12 6.4005
R84 VPWR.n7 VPWR.n6 6.2273
R85 VPWR.n26 VPWR.n25 6.00163
R86 VPWR.n25 VPWR.n23 0.319971
R87 VPWR.n6 VPWR 0.31702
R88 VPWR.n9 VPWR.n6 0.0939888
R89 VPWR.n23 VPWR.n22 0.063
R90 VPWR.n22 VPWR.n1 0.063
R91 VPWR.n18 VPWR.n1 0.063
R92 VPWR.n18 VPWR.n17 0.063
R93 VPWR.n17 VPWR.n16 0.063
R94 VPWR.n16 VPWR.n3 0.063
R95 VPWR.n11 VPWR.n3 0.063
R96 VPWR.n11 VPWR.n10 0.063
R97 VPWR.n10 VPWR.n9 0.063
R98 A1.n0 A1.t0 348.647
R99 A1.n0 A1.t1 204.048
R100 A1 A1.n0 158.4
R101 S.n0 S.t3 298.841
R102 S.n2 S.t0 225.738
R103 S.n1 S.t1 159.06
R104 S S.n2 158.4
R105 S.n0 S.t2 130.141
R106 S.n1 S.n0 115.68
R107 S.n2 S.n1 36.1505
R108 A0.n0 A0.t0 348.647
R109 A0.n0 A0.t1 204.048
R110 A0 A0.n0 158.4
R111 VPB.t4 VPB.t0 690.909
R112 VPB.t3 VPB.t1 604.545
R113 VPB.t2 VPB.t3 604.545
R114 VPB VPB.t6 561.365
R115 VPB.t0 VPB.t5 259.091
R116 VPB.t1 VPB.t4 259.091
R117 VPB.t6 VPB.t2 259.091
R118 VNB.t5 VNB.t2 3200
R119 VNB.t3 VNB.t4 2800
R120 VNB.t1 VNB.t3 2800
R121 VNB VNB.t6 2600
R122 VNB.t2 VNB.t0 1200
R123 VNB.t4 VNB.t5 1200
R124 VNB.t6 VNB.t1 1200
R125 a_861_36.t0 a_861_36.t1 104.001
R126 a_249_36.t0 a_249_36.t1 104.001
R127 a_861_414.t0 a_861_414.t1 121.953
R128 a_249_414.t0 a_249_414.t1 121.953
R129 a_144_36.t0 a_144_36.n0 253
R130 a_144_36.n0 a_144_36.n2 38.4005
R131 a_144_36.n2 a_144_36.n4 204.15
R132 a_144_36.n4 a_144_36.n3 72.3005
R133 a_144_36.n4 a_144_36.t7 231.361
R134 a_144_36.n4 a_144_36.t5 187.981
R135 a_144_36.n3 a_144_36.t6 231.361
R136 a_144_36.n3 a_144_36.t4 187.981
R137 a_144_36.n2 a_144_36.t1 725.976
R138 a_144_36.n0 a_144_36.n1 20.9309
R139 a_144_36.n1 a_144_36.t2 796.376
R140 a_144_36.n1 a_144_36.t3 259.401
R141 a_324_180.t1 a_324_180.n1 253
R142 a_324_180.n1 a_324_180.t2 372.81
R143 a_324_180.n1 a_324_180.n0 6.4005
R144 a_324_180.n0 a_324_180.t3 420.93
R145 a_324_180.n0 a_324_180.t0 668.376
C18 VGND VNB 1.23507f
C19 X VNB 0.27889f
C20 VPWR VNB 0.91064f
C21 A1 VNB 0.20816f
C22 S VNB 0.40938f
C23 A0 VNB 0.2197f
C24 VPB VNB 1.88774f
C25 a_324_180.t1 VNB 0.06077f
C26 a_324_180.t0 VNB 0.08951f
C27 a_324_180.n0 VNB 0.40691f
C28 a_324_180.t3 VNB 0.08554f
C29 a_324_180.n1 VNB 0.31149f
C30 a_324_180.t2 VNB 0.07046f
C31 a_144_36.t0 VNB 0.06554f
C32 a_144_36.n0 VNB 0.46527f
C33 a_144_36.t3 VNB 0.06818f
C34 a_144_36.n1 VNB 0.68753f
C35 a_144_36.t2 VNB 0.12546f
C36 a_144_36.t1 VNB 0.10645f
C37 a_144_36.n2 VNB 0.27595f
C38 a_144_36.t4 VNB 0.02797f
C39 a_144_36.t6 VNB 0.04711f
C40 a_144_36.n3 VNB 0.09922f
C41 a_144_36.t5 VNB 0.02797f
C42 a_144_36.t7 VNB 0.04711f
C43 a_144_36.n4 VNB 0.15197f
C44 a_249_414.t0 VNB 0.01312f
C45 a_249_414.t1 VNB 0.01312f
C46 a_861_414.t0 VNB 0.01312f
C47 a_861_414.t1 VNB 0.01312f
C48 a_249_36.t0 VNB 0.01036f
C49 a_249_36.t1 VNB 0.01036f
C50 a_861_36.t0 VNB 0.01036f
C51 a_861_36.t1 VNB 0.01036f
C52 VPB.t5 VNB 0.16889f
C53 VPB.t0 VNB 0.15482f
C54 VPB.t4 VNB 0.15482f
C55 VPB.t1 VNB 0.14074f
C56 VPB.t3 VNB 0.19704f
C57 VPB.t2 VNB 0.14074f
C58 VPB.t6 VNB 0.13371f
C59 A0.t1 VNB 0.03707f
C60 A0.t0 VNB 0.04683f
C61 A0.n0 VNB 0.15925f
C62 S.t0 VNB 0.08002f
C63 S.t2 VNB 0.02511f
C64 S.t3 VNB 0.1062f
C65 S.n0 VNB 0.2196f
C66 S.t1 VNB 0.02176f
C67 S.n1 VNB 0.07199f
C68 S.n2 VNB 0.18177f
C69 A1.t1 VNB 0.04157f
C70 A1.t0 VNB 0.0525f
C71 A1.n0 VNB 0.17856f
C72 VPWR.n0 VNB 0.01768f
C73 VPWR.n1 VNB 0.03536f
C74 VPWR.n2 VNB 0.01326f
C75 VPWR.n3 VNB 0.03536f
C76 VPWR.t2 VNB 0.03073f
C77 VPWR.n4 VNB 0.05013f
C78 VPWR.t0 VNB 0.03073f
C79 VPWR.n5 VNB 0.01768f
C80 VPWR.n6 VNB 0.14097f
C81 VPWR.t3 VNB 0.03073f
C82 VPWR.n7 VNB 0.06757f
C83 VPWR.n8 VNB 0.01768f
C84 VPWR.n9 VNB 0.05265f
C85 VPWR.n10 VNB 0.03536f
C86 VPWR.n11 VNB 0.03536f
C87 VPWR.n12 VNB 0.01326f
C88 VPWR.n13 VNB 0.05013f
C89 VPWR.n14 VNB 0.01326f
C90 VPWR.n15 VNB 0.01326f
C91 VPWR.n16 VNB 0.03536f
C92 VPWR.n17 VNB 0.03536f
C93 VPWR.n18 VNB 0.03536f
C94 VPWR.n19 VNB 0.01768f
C95 VPWR.n20 VNB 0.01768f
C96 VPWR.n21 VNB 0.01768f
C97 VPWR.n22 VNB 0.03536f
C98 VPWR.n23 VNB 0.17301f
C99 VPWR.t4 VNB 0.05082f
C100 VPWR.n24 VNB 0.04148f
C101 VPWR.n25 VNB 0.11261f
C102 VPWR.n26 VNB 0.04201f
C103 VPWR.t1 VNB 0.05082f
C104 VPWR.n27 VNB 0.03317f
C105 X.t3 VNB 0.03428f
C106 X.t1 VNB 0.03428f
C107 X.n0 VNB 0.0732f
C108 X.t0 VNB 0.01999f
C109 X.t2 VNB 0.01999f
C110 X.n1 VNB 0.03999f
C111 X.n2 VNB 0.04746f
C112 VGND.t4 VNB 0.03089f
C113 VGND.n0 VNB 0.01869f
C114 VGND.n1 VNB 0.03737f
C115 VGND.n2 VNB 0.01401f
C116 VGND.n3 VNB 0.03737f
C117 VGND.t1 VNB 0.02196f
C118 VGND.n4 VNB 0.04441f
C119 VGND.t0 VNB 0.02196f
C120 VGND.n5 VNB 0.01869f
C121 VGND.n6 VNB 0.14897f
C122 VGND.t3 VNB 0.02196f
C123 VGND.n7 VNB 0.06285f
C124 VGND.n8 VNB 0.01869f
C125 VGND.n9 VNB 0.05564f
C126 VGND.n10 VNB 0.03737f
C127 VGND.n11 VNB 0.03737f
C128 VGND.n12 VNB 0.01401f
C129 VGND.n13 VNB 0.04441f
C130 VGND.n14 VNB 0.01401f
C131 VGND.n15 VNB 0.01401f
C132 VGND.n16 VNB 0.03737f
C133 VGND.n17 VNB 0.03737f
C134 VGND.n18 VNB 0.03737f
C135 VGND.n19 VNB 0.01869f
C136 VGND.n20 VNB 0.01869f
C137 VGND.n21 VNB 0.01869f
C138 VGND.n22 VNB 0.03737f
C139 VGND.n23 VNB 0.18283f
C140 VGND.t2 VNB 0.03089f
C141 VGND.n24 VNB 0.10142f
C142 VGND.n25 VNB 0.03272f
.ends

.subckt sky130_efx_lvdig__nand2_1 A B Y VGND VNB VPB VPWR
X0 Y.t1 A.t0 a_141_36.t0 VNB.t0 sky130_fd_pr__nfet_01v8 ad=0.23625 pd=2.01 as=0.12285 ps=1.02 w=0.63 l=0.15
X1 Y.t2 B.t1 VPWR.t1 VPB.t1 sky130_fd_pr__pfet_01v8_hvt ad=0.2106 pd=1.47 as=0.405 ps=2.91 w=1.08 l=0.15
X2 VPWR.t0 A.t1 Y.t0 VPB.t0 sky130_fd_pr__pfet_01v8_hvt ad=0.405 pd=2.91 as=0.2106 ps=1.47 w=1.08 l=0.15
X3 a_141_36.t1 B.t0 VGND.t0 VNB.t1 sky130_fd_pr__nfet_01v8 ad=0.12285 pd=1.02 as=0.23625 ps=2.01 w=0.63 l=0.15
C0 VGND B 0.05368f
C1 VPB B 0.04956f
C2 VPWR Y 0.2293f
C3 VGND Y 0.13562f
C4 VPWR A 0.06439f
C5 VPB Y 0.00728f
C6 A VGND 0.01532f
C7 Y B 0.05877f
C8 A VPB 0.04956f
C9 A B 0.04923f
C10 A Y 0.09776f
C11 VPWR VGND 0.0379f
C12 VPWR VPB 0.0766f
C13 VPB VGND 0.00741f
C14 VPWR B 0.06512f
R0 VGND VGND.t0 231.744
R1 Y Y.n0 308.5
R2 Y.n1 Y.t1 222.143
R3 Y.n0 Y.t0 35.5699
R4 Y.n0 Y.t2 35.5699
R5 Y Y.n1 5.1205
R6 Y.n1 Y 3.2005
R7 VPWR.n0 VPWR.t1 328.07
R8 VPWR.n2 VPWR.t0 328.07
R9 VPWR.n2 VPWR.n1 32.4571
R10 VPWR.n1 VPWR.n0 32.3067
R11 VPWR.n0 VPWR 16.0005
R12 VPWR VPWR.n2 16.0005
R13 VPWR.n1 VPWR 0.354563
R14 A.n0 A.t1 247.428
R15 A.n0 A.t0 204.048
R16 A A.n0 158.4
R17 B.n0 B.t1 247.428
R18 B.n0 B.t0 204.048
R19 B B.n0 158.4
R20 VPB VPB.t1 302.274
R21 VPB.t1 VPB.t0 259.091
R22 VNB VNB.t1 1400
R23 VNB.t1 VNB.t0 1200
R24 a_141_36.t0 a_141_36.t1 74.2862
C15 VGND VNB 0.56388f
C16 Y VNB 0.36849f
C17 VPWR VNB 0.49454f
C18 A VNB 0.21247f
C19 B VNB 0.21249f
C20 VPB VNB 0.461f
C21 a_141_36.t0 VNB 0.00978f
C22 a_141_36.t1 VNB 0.00978f
C23 VPB.t0 VNB 0.09521f
C24 VPB.t1 VNB 0.06188f
C25 B.t1 VNB 0.05335f
C26 B.t0 VNB 0.03322f
C27 B.n0 VNB 0.13132f
C28 A.t1 VNB 0.05333f
C29 A.t0 VNB 0.03321f
C30 A.n0 VNB 0.13127f
C31 VPWR.t1 VNB 0.0482f
C32 VPWR.n0 VNB 0.03995f
C33 VPWR.n1 VNB 0.12235f
C34 VPWR.t0 VNB 0.0482f
C35 VPWR.n2 VNB 0.04056f
C36 Y.t0 VNB 0.03159f
C37 Y.t2 VNB 0.03159f
C38 Y.n0 VNB 0.06746f
C39 Y.t1 VNB 0.0621f
C40 Y.n1 VNB 0.05007f
C41 VGND.t0 VNB 0.02215f
.ends

.subckt sky130_efx_lvdig__nand2_2 A B Y VGND VNB VPB VPWR
X0 nmos_n3f5_f2_l150_ftf_0.S0.t3 A.t0 Y.t2 VNB.t3 sky130_fd_pr__nfet_01v8 ad=0.12285 pd=1.02 as=0.12285 ps=1.02 w=0.63 l=0.15
X1 VGND.t0 B.t1 nmos_n3f5_f2_l150_ftf_0.S0.t0 VNB.t0 sky130_fd_pr__nfet_01v8 ad=0.12285 pd=1.02 as=0.12285 ps=1.02 w=0.63 l=0.15
X2 nmos_n3f5_f2_l150_ftf_0.S0.t1 B.t0 VGND.t1 VNB.t1 sky130_fd_pr__nfet_01v8 ad=0.23625 pd=2.01 as=0.12285 ps=1.02 w=0.63 l=0.15
X3 Y.t4 A.t3 VPWR.t3 VPB.t2 sky130_fd_pr__pfet_01v8_hvt ad=0.2106 pd=1.47 as=0.405 ps=2.91 w=1.08 l=0.15
X4 VPWR.t2 A.t2 Y.t3 VPB.t3 sky130_fd_pr__pfet_01v8_hvt ad=0.2106 pd=1.47 as=0.2106 ps=1.47 w=1.08 l=0.15
X5 Y.t1 B.t3 VPWR.t1 VPB.t0 sky130_fd_pr__pfet_01v8_hvt ad=0.2106 pd=1.47 as=0.2106 ps=1.47 w=1.08 l=0.15
X6 VPWR.t0 B.t2 Y.t0 VPB.t1 sky130_fd_pr__pfet_01v8_hvt ad=0.405 pd=2.91 as=0.2106 ps=1.47 w=1.08 l=0.15
X7 Y.t5 A.t1 nmos_n3f5_f2_l150_ftf_0.S0.t2 VNB.t2 sky130_fd_pr__nfet_01v8 ad=0.12285 pd=1.02 as=0.23625 ps=2.01 w=0.63 l=0.15
C0 VPWR A 0.08545f
C1 nmos_n3f5_f2_l150_ftf_0.S0 Y 0.11846f
C2 VGND Y 0.0163f
C3 B VPB 0.07872f
C4 VPWR Y 0.39958f
C5 Y A 0.11743f
C6 nmos_n3f5_f2_l150_ftf_0.S0 VPB 0.00238f
C7 VGND VPB 0.00852f
C8 nmos_n3f5_f2_l150_ftf_0.S0 B 0.0738f
C9 VGND B 0.04214f
C10 VPWR VPB 0.10954f
C11 VPB A 0.09566f
C12 VPWR B 0.05053f
C13 B A 0.05091f
C14 VGND nmos_n3f5_f2_l150_ftf_0.S0 0.34001f
C15 VPWR nmos_n3f5_f2_l150_ftf_0.S0 0.01965f
C16 VGND VPWR 0.05488f
C17 nmos_n3f5_f2_l150_ftf_0.S0 A 0.06286f
C18 VGND A 0.02073f
C19 VPB Y 0.01252f
C20 B Y 0.08086f
R0 VGND VGND.n0 202.984
R1 VGND.n0 VGND.t1 37.1434
R2 VGND.n0 VGND.t0 37.1434
R3 Y.n3 Y.n0 292.5
R4 Y.n2 Y.n1 292.5
R5 Y Y.n4 201
R6 Y.n3 Y.n2 38.4005
R7 Y.n4 Y.t2 37.1434
R8 Y.n4 Y.t5 37.1434
R9 Y.n0 Y.t3 35.5699
R10 Y.n0 Y.t4 35.5699
R11 Y.n1 Y.t0 35.5699
R12 Y.n1 Y.t1 35.5699
R13 Y.n2 Y 3.2005
R14 Y Y.n3 3.2005
R15 VPWR.n10 VPWR.n1 597.801
R16 VPWR.n3 VPWR.t3 328.07
R17 VPWR.n12 VPWR.t0 328.07
R18 VPWR.n1 VPWR.t1 35.5699
R19 VPWR.n1 VPWR.t2 35.5699
R20 VPWR.n12 VPWR.n11 32.2074
R21 VPWR.n4 VPWR.n3 25.6005
R22 VPWR.n3 VPWR 16.0005
R23 VPWR VPWR.n12 16.0005
R24 VPWR.n5 VPWR.n4 15.7005
R25 VPWR.n9 VPWR.n8 12.8005
R26 VPWR.n8 VPWR.n2 12.8005
R27 VPWR.n11 VPWR.n10 12.1406
R28 VPWR.n6 VPWR.n2 9.3005
R29 VPWR.n8 VPWR.n7 9.3005
R30 VPWR.n9 VPWR.n0 9.3005
R31 VPWR.n10 VPWR.n9 6.4005
R32 VPWR.n4 VPWR.n2 6.4005
R33 VPWR.n11 VPWR.n0 0.584022
R34 VPWR.n7 VPWR.n0 0.063
R35 VPWR.n7 VPWR.n6 0.063
R36 VPWR.n6 VPWR.n5 0.063
R37 VPWR.n5 VPWR 0.03175
R38 B.n0 B.t2 231.361
R39 B.n1 B.t3 231.361
R40 B.n0 B.t0 187.981
R41 B.n1 B.t1 187.981
R42 B B.n2 158.4
R43 B.n2 B.n0 36.1505
R44 B.n2 B.n1 36.1505
R45 A.n0 A.t2 231.361
R46 A.n1 A.t3 231.361
R47 A A.n1 194.55
R48 A.n0 A.t0 187.981
R49 A.n1 A.t1 187.981
R50 A.n1 A.n0 72.3005
R51 VPB VPB.t2 302.274
R52 VPB.t0 VPB.t1 259.091
R53 VPB.t3 VPB.t0 259.091
R54 VPB.t2 VPB.t3 259.091
R55 VNB VNB.t2 1400
R56 VNB.t0 VNB.t1 1200
R57 VNB.t3 VNB.t0 1200
R58 VNB.t2 VNB.t3 1200
R59 nmos_n3f5_f2_l150_ftf_0.S0.t1 nmos_n3f5_f2_l150_ftf_0.S0.n2 222.143
R60 nmos_n3f5_f2_l150_ftf_0.S0 nmos_n3f5_f2_l150_ftf_0.S0.n2 9.6005
R61 nmos_n3f5_f2_l150_ftf_0.S0.n1 nmos_n3f5_f2_l150_ftf_0.S0.n0 185
R62 nmos_n3f5_f2_l150_ftf_0.S0 nmos_n3f5_f2_l150_ftf_0.S0.n1 9.6005
R63 nmos_n3f5_f2_l150_ftf_0.S0.n2 nmos_n3f5_f2_l150_ftf_0.S0.n1 70.4005
R64 nmos_n3f5_f2_l150_ftf_0.S0 nmos_n3f5_f2_l150_ftf_0.S0.t2 231.744
R65 nmos_n3f5_f2_l150_ftf_0.S0.n0 nmos_n3f5_f2_l150_ftf_0.S0.t3 37.1434
R66 nmos_n3f5_f2_l150_ftf_0.S0.n0 nmos_n3f5_f2_l150_ftf_0.S0.t0 37.1434
C21 VGND VNB 0.85813f
C22 Y VNB 0.18187f
C23 VPWR VNB 0.44573f
C24 B VNB 0.25542f
C25 A VNB 0.30089f
C26 VPB VNB 0.7179f
C27 nmos_n3f5_f2_l150_ftf_0.S0 VNB 0.29194f
C28 nmos_n3f5_f2_l150_ftf_0.S0.t1 VNB 0.07148f
C29 nmos_n3f5_f2_l150_ftf_0.S0.t3 VNB 0.02121f
C30 nmos_n3f5_f2_l150_ftf_0.S0.t0 VNB 0.02121f
C31 nmos_n3f5_f2_l150_ftf_0.S0.n0 VNB 0.04242f
C32 nmos_n3f5_f2_l150_ftf_0.S0.n1 VNB 0.0839f
C33 nmos_n3f5_f2_l150_ftf_0.S0.t2 VNB 0.07398f
C34 nmos_n3f5_f2_l150_ftf_0.S0.n2 VNB 0.094f
C35 VPB.t1 VNB 0.09604f
C36 VPB.t0 VNB 0.05763f
C37 VPB.t3 VNB 0.05763f
C38 VPB.t2 VNB 0.06243f
C39 A.t3 VNB 0.04419f
C40 A.t1 VNB 0.02624f
C41 A.t2 VNB 0.04419f
C42 A.t0 VNB 0.02624f
C43 A.n0 VNB 0.09307f
C44 A.n1 VNB 0.13878f
C45 B.t2 VNB 0.04383f
C46 B.t0 VNB 0.02603f
C47 B.n0 VNB 0.0726f
C48 B.t3 VNB 0.04383f
C49 B.t1 VNB 0.02603f
C50 B.n1 VNB 0.0726f
C51 B.n2 VNB 0.04104f
C52 VPWR.n0 VNB 0.15658f
C53 VPWR.t1 VNB 0.01392f
C54 VPWR.t2 VNB 0.01392f
C55 VPWR.n1 VNB 0.02821f
C56 VPWR.n2 VNB 0.01285f
C57 VPWR.t3 VNB 0.04925f
C58 VPWR.n3 VNB 0.03214f
C59 VPWR.n4 VNB 0.03331f
C60 VPWR.n5 VNB 0.03094f
C61 VPWR.n6 VNB 0.03427f
C62 VPWR.n7 VNB 0.03427f
C63 VPWR.n8 VNB 0.01713f
C64 VPWR.n9 VNB 0.01285f
C65 VPWR.n10 VNB 0.04239f
C66 VPWR.n11 VNB 0.07897f
C67 VPWR.t0 VNB 0.04925f
C68 VPWR.n12 VNB 0.04084f
C69 Y.t3 VNB 0.03082f
C70 Y.t4 VNB 0.03082f
C71 Y.n0 VNB 0.06163f
C72 Y.t0 VNB 0.03082f
C73 Y.t1 VNB 0.03082f
C74 Y.n1 VNB 0.06163f
C75 Y.n2 VNB 0.13749f
C76 Y.n3 VNB 0.13749f
C77 Y.t2 VNB 0.01798f
C78 Y.t5 VNB 0.01798f
C79 Y.n4 VNB 0.03935f
C80 VGND.t1 VNB 0.00875f
C81 VGND.t0 VNB 0.00875f
C82 VGND.n0 VNB 0.02064f
.ends

.subckt sky130_efx_lvdig__nor2_1 A B Y VGND VNB VPB VPWR
X0 VGND.t0 B.t0 Y.t1 VNB.t1 sky130_fd_pr__nfet_01v8 ad=0.23625 pd=2.01 as=0.12285 ps=1.02 w=0.63 l=0.15
X1 a_141_324.t0 A.t1 VPWR.t0 VPB.t0 sky130_fd_pr__pfet_01v8_hvt ad=0.2106 pd=1.47 as=0.405 ps=2.91 w=1.08 l=0.15
X2 Y.t0 B.t1 a_141_324.t1 VPB.t1 sky130_fd_pr__pfet_01v8_hvt ad=0.405 pd=2.91 as=0.2106 ps=1.47 w=1.08 l=0.15
X3 Y.t2 A.t0 VGND.t1 VNB.t0 sky130_fd_pr__nfet_01v8 ad=0.12285 pd=1.02 as=0.23625 ps=2.01 w=0.63 l=0.15
C0 A VPWR 0.06442f
C1 VGND VPB 0.00746f
C2 B VPWR 0.01923f
C3 VPB A 0.04956f
C4 B VPB 0.04956f
C5 VGND Y 0.15726f
C6 VPB VPWR 0.07137f
C7 Y A 0.056f
C8 Y B 0.10712f
C9 Y VPWR 0.11971f
C10 Y VPB 0.0132f
C11 VGND A 0.05438f
C12 VGND B 0.05324f
C13 B A 0.04923f
C14 VGND VPWR 0.03692f
R0 VGND VGND.t0 231.744
R1 VGND VGND.t1 231.744
R2 VGND.n0 VGND 16.4571
R3 VGND VGND.n0 16.3067
R4 VGND.n0 VGND 0.354563
R5 Y Y.t0 334.469
R6 Y.n1 Y.n0 185
R7 Y Y.n1 51.2005
R8 Y.n0 Y.t1 37.1434
R9 Y.n0 Y.t2 37.1434
R10 Y.n1 Y 9.6005
R11 VPWR.n0 VPWR.t0 328.07
R12 VPWR.n0 VPWR 32.6607
R13 VPWR VPWR.n0 16.0005
R14 B.n0 B.t1 247.428
R15 B.n0 B.t0 204.048
R16 B B.n0 158.4
R17 A.n0 A.t1 247.428
R18 A.n0 A.t0 204.048
R19 A A.n0 158.4
R20 VPB VPB.t0 302.274
R21 VPB.t0 VPB.t1 259.091
R22 VNB VNB.t0 1400
R23 VNB.t0 VNB.t1 1200
R24 a_141_324.t0 a_141_324.t1 71.1394
C15 VGND VNB 0.55045f
C16 Y VNB 0.29907f
C17 VPWR VNB 0.53081f
C18 B VNB 0.21292f
C19 A VNB 0.21191f
C20 VPB VNB 0.46113f
C21 a_141_324.t0 VNB 0.02157f
C22 a_141_324.t1 VNB 0.02157f
C23 VPB.t1 VNB 0.09557f
C24 VPB.t0 VNB 0.06212f
C25 A.t1 VNB 0.05281f
C26 A.t0 VNB 0.03289f
C27 A.n0 VNB 0.13001f
C28 B.t1 VNB 0.05374f
C29 B.t0 VNB 0.03347f
C30 B.n0 VNB 0.13228f
C31 VPWR.t0 VNB 0.04396f
C32 VPWR.n0 VNB 0.03757f
C33 Y.t0 VNB 0.10244f
C34 Y.t1 VNB 0.01667f
C35 Y.t2 VNB 0.01667f
C36 Y.n0 VNB 0.03334f
C37 Y.n1 VNB 0.08793f
C38 VGND.t1 VNB 0.02222f
C39 VGND.t0 VNB 0.02222f
C40 VGND.n0 VNB 0.07443f
.ends

.subckt sky130_efx_lvdig__nor2_2 A B Y VGND VNB VPB VPWR
X0 VGND.t1 A.t0 Y.t3 VNB.t3 sky130_fd_pr__nfet_01v8 ad=0.12285 pd=1.02 as=0.12285 ps=1.02 w=0.63 l=0.15
X1 Y.t4 B.t1 VGND.t2 VNB.t0 sky130_fd_pr__nfet_01v8 ad=0.12285 pd=1.02 as=0.12285 ps=1.02 w=0.63 l=0.15
X2 VGND.t0 B.t0 Y.t0 VNB.t1 sky130_fd_pr__nfet_01v8 ad=0.23625 pd=2.01 as=0.12285 ps=1.02 w=0.63 l=0.15
X3 VPWR.t1 A.t3 pmos_n6_f2_l150_hvt_ftf_1.S0.t2 VPB.t2 sky130_fd_pr__pfet_01v8_hvt ad=0.2106 pd=1.47 as=0.405 ps=2.91 w=1.08 l=0.15
X4 pmos_n6_f2_l150_hvt_ftf_1.S0.t3 A.t2 VPWR.t0 VPB.t3 sky130_fd_pr__pfet_01v8_hvt ad=0.2106 pd=1.47 as=0.2106 ps=1.47 w=1.08 l=0.15
X5 Y.t2 B.t3 pmos_n6_f2_l150_hvt_ftf_1.S0.t0 VPB.t0 sky130_fd_pr__pfet_01v8_hvt ad=0.2106 pd=1.47 as=0.2106 ps=1.47 w=1.08 l=0.15
X6 pmos_n6_f2_l150_hvt_ftf_1.S0.t1 B.t2 Y.t1 VPB.t1 sky130_fd_pr__pfet_01v8_hvt ad=0.405 pd=2.91 as=0.2106 ps=1.47 w=1.08 l=0.15
X7 Y.t5 A.t1 VGND.t3 VNB.t2 sky130_fd_pr__nfet_01v8 ad=0.12285 pd=1.02 as=0.23625 ps=2.01 w=0.63 l=0.15
C0 VGND B 0.07508f
C1 VGND VPB 0.0087f
C2 VPWR pmos_n6_f2_l150_hvt_ftf_1.S0 0.33744f
C3 A pmos_n6_f2_l150_hvt_ftf_1.S0 0.09023f
C4 VPWR A 0.04408f
C5 Y pmos_n6_f2_l150_hvt_ftf_1.S0 0.15971f
C6 Y VPWR 0.01004f
C7 Y A 0.04979f
C8 B pmos_n6_f2_l150_hvt_ftf_1.S0 0.07521f
C9 VPWR B 0.02298f
C10 VPB pmos_n6_f2_l150_hvt_ftf_1.S0 0.018f
C11 VPB VPWR 0.09882f
C12 B A 0.04992f
C13 VPB A 0.09566f
C14 VGND pmos_n6_f2_l150_hvt_ftf_1.S0 0.01251f
C15 VGND VPWR 0.05283f
C16 VGND A 0.07602f
C17 Y B 0.11153f
C18 Y VPB 0.00946f
C19 VPB B 0.09566f
C20 VGND Y 0.30993f
R0 VGND VGND.t0 231.744
R1 VGND VGND.t3 231.744
R2 VGND.n4 VGND.n2 197.8
R3 VGND.n2 VGND.t2 37.1434
R4 VGND.n2 VGND.t1 37.1434
R5 VGND.n3 VGND 16.2074
R6 VGND.n10 VGND.n9 15.7005
R7 VGND.n6 VGND.n5 12.8005
R8 VGND.n6 VGND.n0 12.8005
R9 VGND.n4 VGND.n3 12.1406
R10 VGND VGND.n10 9.6005
R11 VGND.n8 VGND.n0 9.3005
R12 VGND.n7 VGND.n6 9.3005
R13 VGND.n5 VGND.n1 9.3005
R14 VGND.n5 VGND.n4 6.4005
R15 VGND.n10 VGND.n0 6.4005
R16 VGND.n3 VGND.n1 0.584022
R17 VGND.n7 VGND.n1 0.063
R18 VGND.n8 VGND.n7 0.063
R19 VGND.n9 VGND.n8 0.063
R20 VGND.n9 VGND 0.03175
R21 Y Y.n2 610.601
R22 Y.n1 Y.n0 185
R23 Y.n5 Y.n4 185
R24 Y.n3 Y.n1 60.8005
R25 Y.n4 Y.t0 37.1434
R26 Y.n4 Y.t4 37.1434
R27 Y.n0 Y.t3 37.1434
R28 Y.n0 Y.t5 37.1434
R29 Y.n2 Y.t1 35.5699
R30 Y.n2 Y.t2 35.5699
R31 Y.n1 Y 9.6005
R32 Y.n3 Y 9.6005
R33 Y.n5 Y.n3 9.6005
R34 Y Y.n5 9.6005
R35 VPWR VPWR.n0 602.652
R36 VPWR.n0 VPWR.t0 35.5699
R37 VPWR.n0 VPWR.t1 35.5699
R38 B.n1 B.t2 231.361
R39 B.n0 B.t3 231.361
R40 B B.n1 194.55
R41 B.n1 B.t0 187.981
R42 B.n0 B.t1 187.981
R43 B.n1 B.n0 72.3005
R44 A.n0 A.t2 231.361
R45 A.n1 A.t3 231.361
R46 A A.n1 194.55
R47 A.n0 A.t0 187.981
R48 A.n1 A.t1 187.981
R49 A.n1 A.n0 72.3005
R50 VPB VPB.t2 302.274
R51 VPB.t0 VPB.t1 259.091
R52 VPB.t3 VPB.t0 259.091
R53 VPB.t2 VPB.t3 259.091
R54 VNB VNB.t2 1400
R55 VNB.t0 VNB.t1 1200
R56 VNB.t3 VNB.t0 1200
R57 VNB.t2 VNB.t3 1200
R58 pmos_n6_f2_l150_hvt_ftf_1.S0.t1 pmos_n6_f2_l150_hvt_ftf_1.S0 334.469
R59 pmos_n6_f2_l150_hvt_ftf_1.S0.n0 pmos_n6_f2_l150_hvt_ftf_1.S0.n1 292.5
R60 pmos_n6_f2_l150_hvt_ftf_1.S0 pmos_n6_f2_l150_hvt_ftf_1.S0.n1 6.4005
R61 pmos_n6_f2_l150_hvt_ftf_1.S0.n1 pmos_n6_f2_l150_hvt_ftf_1.S0 6.4005
R62 pmos_n6_f2_l150_hvt_ftf_1.S0 pmos_n6_f2_l150_hvt_ftf_1.S0.t2 334.469
R63 pmos_n6_f2_l150_hvt_ftf_1.S0.t3 pmos_n6_f2_l150_hvt_ftf_1.S0.n0 35.5699
R64 pmos_n6_f2_l150_hvt_ftf_1.S0.n0 pmos_n6_f2_l150_hvt_ftf_1.S0.t0 35.5699
C21 VGND VNB 0.5551f
C22 Y VNB 0.23395f
C23 VPWR VNB 0.82763f
C24 B VNB 0.30052f
C25 A VNB 0.2988f
C26 VPB VNB 0.71998f
C27 pmos_n6_f2_l150_hvt_ftf_1.S0 VNB 0.48341f
C28 pmos_n6_f2_l150_hvt_ftf_1.S0.t1 VNB 0.08972f
C29 pmos_n6_f2_l150_hvt_ftf_1.S0.t3 VNB 0.02503f
C30 pmos_n6_f2_l150_hvt_ftf_1.S0.t0 VNB 0.02503f
C31 pmos_n6_f2_l150_hvt_ftf_1.S0.n0 VNB 0.05006f
C32 pmos_n6_f2_l150_hvt_ftf_1.S0.n1 VNB 0.0154f
C33 pmos_n6_f2_l150_hvt_ftf_1.S0.t2 VNB 0.08972f
C34 VPB.t1 VNB 0.10197f
C35 VPB.t0 VNB 0.06118f
C36 VPB.t3 VNB 0.06118f
C37 VPB.t2 VNB 0.06628f
C38 A.t3 VNB 0.0414f
C39 A.t1 VNB 0.02458f
C40 A.t2 VNB 0.0414f
C41 A.t0 VNB 0.02458f
C42 A.n0 VNB 0.08719f
C43 A.n1 VNB 0.13002f
C44 B.t2 VNB 0.04392f
C45 B.t0 VNB 0.02608f
C46 B.t3 VNB 0.04392f
C47 B.t1 VNB 0.02608f
C48 B.n0 VNB 0.0925f
C49 B.n1 VNB 0.13793f
C50 VPWR.t0 VNB 0.016f
C51 VPWR.t1 VNB 0.016f
C52 VPWR.n0 VNB 0.03306f
C53 Y.t3 VNB 0.01984f
C54 Y.t5 VNB 0.01984f
C55 Y.n0 VNB 0.03967f
C56 Y.n1 VNB 0.07104f
C57 Y.t1 VNB 0.03401f
C58 Y.t2 VNB 0.03401f
C59 Y.n2 VNB 0.07152f
C60 Y.n3 VNB 0.05975f
C61 Y.t0 VNB 0.01984f
C62 Y.t4 VNB 0.01984f
C63 Y.n4 VNB 0.03967f
C64 Y.n5 VNB 0.03139f
C65 VGND.t3 VNB 0.02489f
C66 VGND.n0 VNB 0.01129f
C67 VGND.n1 VNB 0.13758f
C68 VGND.t2 VNB 0.00714f
C69 VGND.t1 VNB 0.00714f
C70 VGND.n2 VNB 0.01524f
C71 VGND.t0 VNB 0.02489f
C72 VGND.n3 VNB 0.05627f
C73 VGND.n4 VNB 0.03659f
C74 VGND.n5 VNB 0.01129f
C75 VGND.n6 VNB 0.01505f
C76 VGND.n7 VNB 0.03011f
C77 VGND.n8 VNB 0.03011f
C78 VGND.n9 VNB 0.02718f
C79 VGND.n10 VNB 0.01986f
.ends

.subckt sky130_efx_lvdig__nor3_2 A B C Y VGND VNB VPB VPWR
X0 a_357_324.t1 C.t2 Y.t3 VPB.t1 sky130_fd_pr__pfet_01v8_hvt ad=0.405 pd=2.91 as=0.2106 ps=1.47 w=1.08 l=0.15
X1 VGND.t4 A.t0 Y.t6 VNB.t5 sky130_fd_pr__nfet_01v8 ad=0.12285 pd=1.02 as=0.12285 ps=1.02 w=0.63 l=0.15
X2 Y.t2 B.t1 VGND.t2 VNB.t2 sky130_fd_pr__nfet_01v8 ad=0.12285 pd=1.02 as=0.12285 ps=1.02 w=0.63 l=0.15
X3 VGND.t3 B.t0 Y.t5 VNB.t3 sky130_fd_pr__nfet_01v8 ad=0.23625 pd=2.01 as=0.12285 ps=1.02 w=0.63 l=0.15
X4 VPWR.t1 A.t3 a_36_324.t2 VPB.t4 sky130_fd_pr__pfet_01v8_hvt ad=0.2106 pd=1.47 as=0.405 ps=2.91 w=1.08 l=0.15
X5 a_36_324.t3 A.t2 VPWR.t0 VPB.t5 sky130_fd_pr__pfet_01v8_hvt ad=0.2106 pd=1.47 as=0.2106 ps=1.47 w=1.08 l=0.15
X6 Y.t0 C.t1 VGND.t0 VNB.t0 sky130_fd_pr__nfet_01v8 ad=0.12285 pd=1.02 as=0.23625 ps=2.01 w=0.63 l=0.15
X7 VGND.t1 C.t0 Y.t1 VNB.t1 sky130_fd_pr__nfet_01v8 ad=0.23625 pd=2.01 as=0.12285 ps=1.02 w=0.63 l=0.15
X8 a_357_324.t3 B.t3 a_36_324.t0 VPB.t2 sky130_fd_pr__pfet_01v8_hvt ad=0.2106 pd=1.47 as=0.2106 ps=1.47 w=1.08 l=0.15
X9 a_36_324.t1 B.t2 a_357_324.t2 VPB.t3 sky130_fd_pr__pfet_01v8_hvt ad=0.405 pd=2.91 as=0.2106 ps=1.47 w=1.08 l=0.15
X10 Y.t7 A.t1 VGND.t5 VNB.t4 sky130_fd_pr__nfet_01v8 ad=0.12285 pd=1.02 as=0.23625 ps=2.01 w=0.63 l=0.15
X11 Y.t4 C.t3 a_357_324.t0 VPB.t0 sky130_fd_pr__pfet_01v8_hvt ad=0.2106 pd=1.47 as=0.405 ps=2.91 w=1.08 l=0.15
C0 A VGND 0.07602f
C1 VPB B 0.08255f
C2 VPB VPWR 0.1562f
C3 C Y 0.13793f
C4 B Y 0.07329f
C5 VPB VGND 0.01395f
C6 A VPB 0.09566f
C7 VPWR Y 0.01136f
C8 C B 0.02972f
C9 VGND Y 0.51634f
C10 A Y 0.03702f
C11 C VPWR 0.02297f
C12 B VPWR 0.02578f
C13 VGND C 0.05182f
C14 VPB Y 0.01613f
C15 VGND B 0.04313f
C16 A B 0.06097f
C17 VGND VPWR 0.08309f
C18 A VPWR 0.04408f
C19 VPB C 0.10171f
R0 VGND.n5 VGND.t1 247.951
R1 VGND.n21 VGND.t5 241.344
R2 VGND.n6 VGND.t0 234.944
R3 VGND.n3 VGND.t3 234.944
R4 VGND.n14 VGND.n13 197.8
R5 VGND.n13 VGND.t2 37.1434
R6 VGND.n13 VGND.t4 37.1434
R7 VGND.n22 VGND.n21 15.7005
R8 VGND.n8 VGND.n7 12.8005
R9 VGND.n12 VGND.n11 12.8005
R10 VGND.n15 VGND.n12 12.8005
R11 VGND.n19 VGND.n1 12.8005
R12 VGND.n20 VGND.n19 12.8005
R13 VGND.n6 VGND.n5 12.1406
R14 VGND.n20 VGND.n0 9.3005
R15 VGND.n19 VGND.n18 9.3005
R16 VGND.n17 VGND.n1 9.3005
R17 VGND.n16 VGND.n15 9.3005
R18 VGND.n12 VGND.n2 9.3005
R19 VGND.n11 VGND.n10 9.3005
R20 VGND.n9 VGND.n8 9.3005
R21 VGND.n7 VGND.n4 9.3005
R22 VGND.n7 VGND.n6 6.4005
R23 VGND.n8 VGND.n3 6.4005
R24 VGND.n11 VGND.n3 6.4005
R25 VGND.n15 VGND.n14 6.4005
R26 VGND.n14 VGND.n1 6.4005
R27 VGND.n21 VGND.n20 6.4005
R28 VGND.n5 VGND.n4 0.584022
R29 VGND.n9 VGND.n4 0.063
R30 VGND.n10 VGND.n9 0.063
R31 VGND.n10 VGND.n2 0.063
R32 VGND.n16 VGND.n2 0.063
R33 VGND.n17 VGND.n16 0.063
R34 VGND.n18 VGND.n17 0.063
R35 VGND.n18 VGND.n0 0.063
R36 VGND.n22 VGND.n0 0.063
R37 VGND VGND.n22 0.03175
R38 Y Y.n0 610.601
R39 Y.n3 Y.n1 249
R40 Y.n5 Y.n4 194.601
R41 Y.n3 Y.n2 185
R42 Y.n5 Y.n3 105.6
R43 Y.n4 Y.t1 37.1434
R44 Y.n4 Y.t0 37.1434
R45 Y.n2 Y.t5 37.1434
R46 Y.n2 Y.t2 37.1434
R47 Y.n1 Y.t6 37.1434
R48 Y.n1 Y.t7 37.1434
R49 Y.n0 Y.t3 35.5699
R50 Y.n0 Y.t4 35.5699
R51 Y Y.n5 9.6005
R52 VPWR VPWR.n0 602.652
R53 VPWR.n0 VPWR.t0 35.5699
R54 VPWR.n0 VPWR.t1 35.5699
R55 C.n0 C.t2 231.361
R56 C.n1 C.t3 231.361
R57 C C.n1 194.55
R58 C.n0 C.t0 187.981
R59 C.n1 C.t1 187.981
R60 C.n1 C.n0 72.3005
R61 B.n0 B.t2 231.361
R62 B.n1 B.t3 231.361
R63 B.n0 B.t0 187.981
R64 B.n1 B.t1 187.981
R65 B B.n2 158.4
R66 B.n2 B.n0 36.1505
R67 B.n2 B.n1 36.1505
R68 A.n0 A.t2 231.361
R69 A.n1 A.t3 231.361
R70 A A.n1 194.55
R71 A.n0 A.t0 187.981
R72 A.n1 A.t1 187.981
R73 A.n1 A.n0 72.3005
R74 VPB.t3 VPB.t0 604.545
R75 VPB VPB.t4 302.274
R76 VPB.t0 VPB.t1 259.091
R77 VPB.t2 VPB.t3 259.091
R78 VPB.t5 VPB.t2 259.091
R79 VPB.t4 VPB.t5 259.091
R80 VNB.t3 VNB.t0 2800
R81 VNB VNB.t4 1400
R82 VNB.t0 VNB.t1 1200
R83 VNB.t2 VNB.t3 1200
R84 VNB.t5 VNB.t2 1200
R85 VNB.t4 VNB.t5 1200
R86 a_357_324.t1 a_357_324.n1 372.87
R87 a_357_324.n1 a_357_324.n0 629.801
R88 a_357_324.n1 a_357_324.t0 334.469
R89 a_357_324.n0 a_357_324.t3 35.5699
R90 a_357_324.n0 a_357_324.t2 35.5699
R91 a_36_324.t1 a_36_324.n1 812.52
R92 a_36_324.n1 a_36_324.t2 372.87
R93 a_36_324.n1 a_36_324.n0 298.901
R94 a_36_324.n0 a_36_324.t3 35.5699
R95 a_36_324.n0 a_36_324.t0 35.5699
C20 VGND VNB 0.69231f
C21 Y VNB 0.20455f
C22 VPWR VNB 1.29411f
C23 C VNB 0.30035f
C24 B VNB 0.22659f
C25 A VNB 0.29856f
C26 VPB VNB 1.14644f
C27 a_36_324.t1 VNB 0.08492f
C28 a_36_324.t3 VNB 0.02318f
C29 a_36_324.t0 VNB 0.02318f
C30 a_36_324.n0 VNB 0.04742f
C31 a_36_324.n1 VNB 0.31061f
C32 a_36_324.t2 VNB 0.09546f
C33 a_357_324.t1 VNB 0.11139f
C34 a_357_324.t3 VNB 0.02705f
C35 a_357_324.t2 VNB 0.02705f
C36 a_357_324.n0 VNB 0.05942f
C37 a_357_324.t0 VNB 0.09695f
C38 a_357_324.n1 VNB 0.37718f
C39 VPB.t1 VNB 0.09849f
C40 VPB.t0 VNB 0.09849f
C41 VPB.t3 VNB 0.09849f
C42 VPB.t2 VNB 0.05909f
C43 VPB.t5 VNB 0.05909f
C44 VPB.t4 VNB 0.06402f
C45 A.t3 VNB 0.04122f
C46 A.t1 VNB 0.02448f
C47 A.t2 VNB 0.04122f
C48 A.t0 VNB 0.02448f
C49 A.n0 VNB 0.08682f
C50 A.n1 VNB 0.12947f
C51 B.t2 VNB 0.04637f
C52 B.t0 VNB 0.02753f
C53 B.n0 VNB 0.0768f
C54 B.t3 VNB 0.04637f
C55 B.t1 VNB 0.02753f
C56 B.n1 VNB 0.0768f
C57 B.n2 VNB 0.04342f
C58 C.t3 VNB 0.04294f
C59 C.t1 VNB 0.02549f
C60 C.t2 VNB 0.04294f
C61 C.t0 VNB 0.02549f
C62 C.n0 VNB 0.09043f
C63 C.n1 VNB 0.13485f
C64 VPWR.t0 VNB 0.01652f
C65 VPWR.t1 VNB 0.01652f
C66 VPWR.n0 VNB 0.03422f
C67 Y.t3 VNB 0.03668f
C68 Y.t4 VNB 0.03668f
C69 Y.n0 VNB 0.0762f
C70 Y.t6 VNB 0.0214f
C71 Y.t7 VNB 0.0214f
C72 Y.n1 VNB 0.07042f
C73 Y.t5 VNB 0.0214f
C74 Y.t2 VNB 0.0214f
C75 Y.n2 VNB 0.04279f
C76 Y.n3 VNB 0.24118f
C77 Y.t1 VNB 0.0214f
C78 Y.t0 VNB 0.0214f
C79 Y.n4 VNB 0.04586f
C80 Y.n5 VNB 0.14007f
C81 VGND.n0 VNB 0.02846f
C82 VGND.t5 VNB 0.02468f
C83 VGND.n1 VNB 0.01067f
C84 VGND.n2 VNB 0.02846f
C85 VGND.t3 VNB 0.02368f
C86 VGND.n3 VNB 0.03072f
C87 VGND.n4 VNB 0.13004f
C88 VGND.t0 VNB 0.02368f
C89 VGND.t1 VNB 0.02613f
C90 VGND.n5 VNB 0.0904f
C91 VGND.n6 VNB 0.03777f
C92 VGND.n7 VNB 0.01067f
C93 VGND.n8 VNB 0.01067f
C94 VGND.n9 VNB 0.02846f
C95 VGND.n10 VNB 0.02846f
C96 VGND.n11 VNB 0.01067f
C97 VGND.n12 VNB 0.01423f
C98 VGND.t2 VNB 0.00674f
C99 VGND.t4 VNB 0.00674f
C100 VGND.n13 VNB 0.01441f
C101 VGND.n14 VNB 0.02754f
C102 VGND.n15 VNB 0.01067f
C103 VGND.n16 VNB 0.02846f
C104 VGND.n17 VNB 0.02846f
C105 VGND.n18 VNB 0.02846f
C106 VGND.n19 VNB 0.01423f
C107 VGND.n20 VNB 0.01067f
C108 VGND.n21 VNB 0.04671f
C109 VGND.n22 VNB 0.0257f
.ends

.subckt sky130_efx_lvdig__o21a_1 A1 A2 B1 X VGND VNB VPB VPWR
X0 VGND.t0 A2.t0 nmos_n3f5_f1_l150_0.S0.t0 VNB.t1 sky130_fd_pr__nfet_01v8 ad=0.23625 pd=2.01 as=0.12285 ps=1.02 w=0.63 l=0.15
X1 a_141_324.t1 A1.t1 VPWR.t1 VPB.t3 sky130_fd_pr__pfet_01v8_hvt ad=0.2106 pd=1.47 as=0.405 ps=2.91 w=1.08 l=0.15
X2 X.t0 pmos_n6_f2_l150_hvt_fnf_0.D0.t3 VGND.t2 VNB.t0 sky130_fd_pr__nfet_01v8 ad=0.23625 pd=2.01 as=0.23625 ps=2.01 w=0.63 l=0.15
X3 pmos_n6_f2_l150_hvt_fnf_0.D0.t0 A2.t1 a_141_324.t0 VPB.t1 sky130_fd_pr__pfet_01v8_hvt ad=0.405 pd=2.91 as=0.2106 ps=1.47 w=1.08 l=0.15
X4 X.t1 pmos_n6_f2_l150_hvt_fnf_0.D0.t4 VPWR.t2 VPB.t0 sky130_fd_pr__pfet_01v8_hvt ad=0.405 pd=2.91 as=0.405 ps=2.91 w=1.08 l=0.15
X5 nmos_n3f5_f1_l150_0.S0.t2 A1.t0 VGND.t1 VNB.t3 sky130_fd_pr__nfet_01v8 ad=0.12285 pd=1.02 as=0.23625 ps=2.01 w=0.63 l=0.15
X6 pmos_n6_f2_l150_hvt_fnf_0.D0.t2 B1.t1 VPWR.t0 VPB.t2 sky130_fd_pr__pfet_01v8_hvt ad=0.405 pd=2.91 as=0.405 ps=2.91 w=1.08 l=0.15
X7 pmos_n6_f2_l150_hvt_fnf_0.D0.t1 B1.t0 nmos_n3f5_f1_l150_0.S0.t1 VNB.t2 sky130_fd_pr__nfet_01v8 ad=0.23625 pd=2.01 as=0.23625 ps=2.01 w=0.63 l=0.15
C0 A1 pmos_n6_f2_l150_hvt_fnf_0.D0 0.00444f
C1 B1 VGND 0.02114f
C2 A1 VPWR 0.06465f
C3 A1 nmos_n3f5_f1_l150_0.S0 0.00736f
C4 VGND VPB 0.01359f
C5 B1 VPB 0.05944f
C6 VGND pmos_n6_f2_l150_hvt_fnf_0.D0 0.15197f
C7 B1 pmos_n6_f2_l150_hvt_fnf_0.D0 0.12614f
C8 VGND VPWR 0.08217f
C9 B1 VPWR 0.02458f
C10 VGND nmos_n3f5_f1_l150_0.S0 0.24914f
C11 B1 nmos_n3f5_f1_l150_0.S0 0.04085f
C12 pmos_n6_f2_l150_hvt_fnf_0.D0 VPB 0.10556f
C13 X VGND 0.10221f
C14 VPB VPWR 0.17532f
C15 A2 A1 0.06327f
C16 nmos_n3f5_f1_l150_0.S0 VPB 0.00258f
C17 X VPB 0.00999f
C18 pmos_n6_f2_l150_hvt_fnf_0.D0 VPWR 0.32806f
C19 nmos_n3f5_f1_l150_0.S0 pmos_n6_f2_l150_hvt_fnf_0.D0 0.06892f
C20 nmos_n3f5_f1_l150_0.S0 VPWR 0.00947f
C21 X pmos_n6_f2_l150_hvt_fnf_0.D0 0.11842f
C22 A2 VGND 0.02541f
C23 A2 B1 0.04604f
C24 X VPWR 0.08434f
C25 A2 VPB 0.05339f
C26 A1 VGND 0.05438f
C27 A2 pmos_n6_f2_l150_hvt_fnf_0.D0 0.04374f
C28 A1 VPB 0.04956f
C29 A2 VPWR 0.02397f
C30 A2 nmos_n3f5_f1_l150_0.S0 0.05235f
R0 VGND.n2 VGND.t1 241.344
R1 VGND.n0 VGND.t0 234.944
R2 VGND VGND.t2 231.744
R3 VGND.n3 VGND.n2 15.7005
R4 VGND VGND.n9 14.5486
R5 VGND.n7 VGND.n6 12.8005
R6 VGND.n6 VGND.n5 12.8005
R7 VGND.n9 VGND.n0 12.6037
R8 VGND.n5 VGND.n4 9.3005
R9 VGND.n6 VGND.n1 9.3005
R10 VGND.n8 VGND.n7 9.3005
R11 VGND.n7 VGND.n0 6.4005
R12 VGND.n5 VGND.n2 6.4005
R13 VGND.n9 VGND.n8 0.117593
R14 VGND.n8 VGND.n1 0.063
R15 VGND.n4 VGND.n1 0.063
R16 VGND.n4 VGND.n3 0.063
R17 VGND.n3 VGND 0.03175
R18 X X.t1 366.469
R19 X.n0 X.t0 222.143
R20 X.n0 X 19.2005
R21 X X.n0 9.6005
R22 VPWR.n4 VPWR.t2 791.551
R23 VPWR.n3 VPWR.t0 786.92
R24 VPWR.n14 VPWR.t1 328.07
R25 VPWR.n14 VPWR.n13 25.6005
R26 VPWR VPWR.n14 16.0005
R27 VPWR.n13 VPWR.n12 15.7005
R28 VPWR.n7 VPWR.n2 12.8005
R29 VPWR.n8 VPWR.n7 12.8005
R30 VPWR.n9 VPWR.n8 12.8005
R31 VPWR.n9 VPWR.n0 12.8005
R32 VPWR.n4 VPWR.n3 12.4081
R33 VPWR.n11 VPWR.n0 9.3005
R34 VPWR.n10 VPWR.n9 9.3005
R35 VPWR.n8 VPWR.n1 9.3005
R36 VPWR.n7 VPWR.n6 9.3005
R37 VPWR.n5 VPWR.n2 9.3005
R38 VPWR.n3 VPWR.n2 6.4005
R39 VPWR.n13 VPWR.n0 6.4005
R40 VPWR.n5 VPWR.n4 0.313143
R41 VPWR.n6 VPWR.n5 0.063
R42 VPWR.n6 VPWR.n1 0.063
R43 VPWR.n10 VPWR.n1 0.063
R44 VPWR.n11 VPWR.n10 0.063
R45 VPWR.n12 VPWR.n11 0.063
R46 VPWR.n12 VPWR 0.03175
R47 B1.n0 B1.t1 247.428
R48 B1.n0 B1.t0 204.048
R49 B1 B1.n0 158.4
R50 A2.n0 A2.t1 247.428
R51 A2.n0 A2.t0 204.048
R52 A2 A2.n0 158.4
R53 A1.n0 A1.t1 247.428
R54 A1.n0 A1.t0 204.048
R55 A1 A1.n0 158.4
R56 VPB.t2 VPB.t0 604.545
R57 VPB.t1 VPB.t2 604.545
R58 VPB VPB.t3 302.274
R59 VPB.t3 VPB.t1 259.091
R60 VNB.t2 VNB.t0 2800
R61 VNB.t1 VNB.t2 2800
R62 VNB VNB.t3 1400
R63 VNB.t3 VNB.t1 1200
R64 nmos_n3f5_f1_l150_0.S0.n0 nmos_n3f5_f1_l150_0.S0.t2 37.1434
R65 nmos_n3f5_f1_l150_0.S0.n0 nmos_n3f5_f1_l150_0.S0.t0 37.1434
R66 nmos_n3f5_f1_l150_0.S0 nmos_n3f5_f1_l150_0.S0.n1 9.6005
R67 nmos_n3f5_f1_l150_0.S0.n1 nmos_n3f5_f1_l150_0.S0.n0 268.2
R68 nmos_n3f5_f1_l150_0.S0.n1 nmos_n3f5_f1_l150_0.S0.t1 222.143
R69 a_141_324.t0 a_141_324.t1 71.1394
R70 pmos_n6_f2_l150_hvt_fnf_0.D0.t1 pmos_n6_f2_l150_hvt_fnf_0.D0.n2 222.143
R71 pmos_n6_f2_l150_hvt_fnf_0.D0 pmos_n6_f2_l150_hvt_fnf_0.D0.n2 9.6005
R72 pmos_n6_f2_l150_hvt_fnf_0.D0.n2 pmos_n6_f2_l150_hvt_fnf_0.D0.n0 38.4005
R73 pmos_n6_f2_l150_hvt_fnf_0.D0 pmos_n6_f2_l150_hvt_fnf_0.D0.n0 44.8005
R74 pmos_n6_f2_l150_hvt_fnf_0.D0.t0 pmos_n6_f2_l150_hvt_fnf_0.D0 334.469
R75 pmos_n6_f2_l150_hvt_fnf_0.D0.n0 pmos_n6_f2_l150_hvt_fnf_0.D0.n1 190.4
R76 pmos_n6_f2_l150_hvt_fnf_0.D0.n1 pmos_n6_f2_l150_hvt_fnf_0.D0.t3 204.048
R77 pmos_n6_f2_l150_hvt_fnf_0.D0.n1 pmos_n6_f2_l150_hvt_fnf_0.D0.t4 247.428
R78 pmos_n6_f2_l150_hvt_fnf_0.D0.n0 pmos_n6_f2_l150_hvt_fnf_0.D0.t2 334.469
C31 VGND VNB 0.68782f
C32 X VNB 0.26371f
C33 VPWR VNB 0.50444f
C34 B1 VNB 0.19347f
C35 A2 VNB 0.1818f
C36 A1 VNB 0.20788f
C37 VPB VNB 1.06066f
C38 nmos_n3f5_f1_l150_0.S0 VNB 0.06127f
C39 pmos_n6_f2_l150_hvt_fnf_0.D0 VNB 0.36897f
C40 pmos_n6_f2_l150_hvt_fnf_0.D0.t1 VNB 0.05536f
C41 pmos_n6_f2_l150_hvt_fnf_0.D0.t2 VNB 0.10094f
C42 pmos_n6_f2_l150_hvt_fnf_0.D0.n0 VNB 0.31164f
C43 pmos_n6_f2_l150_hvt_fnf_0.D0.t4 VNB 0.03066f
C44 pmos_n6_f2_l150_hvt_fnf_0.D0.t3 VNB 0.0191f
C45 pmos_n6_f2_l150_hvt_fnf_0.D0.n1 VNB 0.09074f
C46 pmos_n6_f2_l150_hvt_fnf_0.D0.t0 VNB 0.10094f
C47 pmos_n6_f2_l150_hvt_fnf_0.D0.n2 VNB 0.0728f
C48 a_141_324.t0 VNB 0.02252f
C49 a_141_324.t1 VNB 0.02252f
C50 nmos_n3f5_f1_l150_0.S0.t0 VNB 0.023f
C51 nmos_n3f5_f1_l150_0.S0.n0 VNB 0.08552f
C52 nmos_n3f5_f1_l150_0.S0.t1 VNB 0.07752f
C53 nmos_n3f5_f1_l150_0.S0.n1 VNB 0.19588f
C54 nmos_n3f5_f1_l150_0.S0.t2 VNB 0.023f
C55 VPB.t0 VNB 0.13692f
C56 VPB.t2 VNB 0.13692f
C57 VPB.t1 VNB 0.0978f
C58 VPB.t3 VNB 0.06357f
C59 A1.t1 VNB 0.04703f
C60 A1.t0 VNB 0.02929f
C61 A1.n0 VNB 0.11578f
C62 A2.t1 VNB 0.05949f
C63 A2.t0 VNB 0.03705f
C64 A2.n0 VNB 0.14644f
C65 B1.t1 VNB 0.06142f
C66 B1.t0 VNB 0.03825f
C67 B1.n0 VNB 0.1512f
C68 VPWR.n0 VNB 0.01184f
C69 VPWR.n1 VNB 0.03157f
C70 VPWR.n2 VNB 0.01184f
C71 VPWR.t2 VNB 0.04599f
C72 VPWR.t0 VNB 0.04563f
C73 VPWR.n3 VNB 0.04388f
C74 VPWR.n4 VNB 0.14404f
C75 VPWR.n5 VNB 0.18609f
C76 VPWR.n6 VNB 0.03157f
C77 VPWR.n7 VNB 0.01578f
C78 VPWR.n8 VNB 0.01578f
C79 VPWR.n9 VNB 0.01578f
C80 VPWR.n10 VNB 0.03157f
C81 VPWR.n11 VNB 0.03157f
C82 VPWR.n12 VNB 0.0285f
C83 VPWR.n13 VNB 0.03069f
C84 VPWR.t1 VNB 0.04537f
C85 VPWR.n14 VNB 0.02961f
C86 X.t1 VNB 0.08475f
C87 X.t0 VNB 0.04211f
C88 X.n0 VNB 0.0356f
C89 VGND.t2 VNB 0.02448f
C90 VGND.t0 VNB 0.02464f
C91 VGND.n0 VNB 0.04084f
C92 VGND.n1 VNB 0.02962f
C93 VGND.t1 VNB 0.02569f
C94 VGND.n2 VNB 0.04861f
C95 VGND.n3 VNB 0.02674f
C96 VGND.n4 VNB 0.02962f
C97 VGND.n5 VNB 0.01111f
C98 VGND.n6 VNB 0.01481f
C99 VGND.n7 VNB 0.01111f
C100 VGND.n8 VNB 0.09405f
C101 VGND.n9 VNB 0.26876f
.ends

.subckt sky130_efx_lvdig__or2_1 A B X VGND VNB VPB VPWR
X0 VGND.t1 B.t0 a_141_36.t1 VNB.t0 sky130_fd_pr__nfet_01v8 ad=0.16875 pd=1.65 as=0.08775 ps=0.84 w=0.45 l=0.15
X1 a_141_450.t1 A.t1 VPWR.t0 VPB.t2 sky130_fd_pr__pfet_01v8_hvt ad=0.08775 pd=0.84 as=0.16875 ps=1.65 w=0.45 l=0.15
X2 a_141_36.t2 A.t0 VGND.t2 VNB.t2 sky130_fd_pr__nfet_01v8 ad=0.08775 pd=0.84 as=0.16875 ps=1.65 w=0.45 l=0.15
X3 a_141_36.t0 B.t1 a_141_450.t0 VPB.t0 sky130_fd_pr__pfet_01v8_hvt ad=0.16875 pd=1.65 as=0.08775 ps=0.84 w=0.45 l=0.15
X4 X.t1 a_141_36.t4 VPWR.t1 VPB.t1 sky130_fd_pr__pfet_01v8_hvt ad=0.405 pd=2.91 as=0.405 ps=2.91 w=1.08 l=0.15
X5 X.t0 a_141_36.t3 VGND.t0 VNB.t1 sky130_fd_pr__nfet_01v8 ad=0.23625 pd=2.01 as=0.23625 ps=2.01 w=0.63 l=0.15
C0 A VPWR 0.03612f
C1 VPWR VPB 0.14188f
C2 A B 0.08246f
C3 VPB B 0.10842f
C4 VGND X 0.10221f
C5 VPWR B 0.01943f
C6 A VGND 0.04458f
C7 VGND VPB 0.01592f
C8 VPB X 0.01417f
C9 VGND VPWR 0.06339f
C10 VPWR X 0.08434f
C11 A VPB 0.09793f
C12 VGND B 0.04521f
C13 X B 0.00138f
R0 VGND.n8 VGND.t1 253
R1 VGND.n2 VGND.t2 253
R2 VGND VGND.t0 231.744
R3 VGND.n3 VGND.n2 15.7005
R4 VGND VGND.n9 14.6867
R5 VGND.n7 VGND.n6 12.8005
R6 VGND.n6 VGND.n1 12.8005
R7 VGND.n9 VGND.n8 11.2737
R8 VGND.n4 VGND.n1 9.3005
R9 VGND.n6 VGND.n5 9.3005
R10 VGND.n7 VGND.n0 9.3005
R11 VGND.n8 VGND.n7 6.4005
R12 VGND.n2 VGND.n1 6.4005
R13 VGND.n9 VGND.n0 1.44789
R14 VGND.n5 VGND.n0 0.063
R15 VGND.n5 VGND.n4 0.063
R16 VGND.n4 VGND.n3 0.063
R17 VGND.n3 VGND 0.03175
R18 X X.t1 366.469
R19 X.n0 X.t0 222.143
R20 X.n0 X 19.2005
R21 X X.n0 9.6005
R22 VPWR.n0 VPWR.t1 793.481
R23 VPWR.n0 VPWR.t0 690.116
R24 VPWR VPWR.n0 0.110184
R25 B.n0 B.t1 348.647
R26 B.n0 B.t0 232.968
R27 B B.n0 158.4
R28 A.n0 A.t1 348.647
R29 A.n0 A.t0 232.968
R30 A A.n0 158.4
R31 VPB.t0 VPB.t1 604.545
R32 VPB VPB.t2 302.274
R33 VPB.t2 VPB.t0 259.091
R34 VNB.t0 VNB.t1 2800
R35 VNB VNB.t2 1400
R36 VNB.t2 VNB.t0 1200
R37 a_141_450.t0 a_141_450.t1 170.733
R38 a_141_36.t0 a_141_36.n2 689.567
R39 a_141_36.n2 a_141_36.n1 190.4
R40 a_141_36.n1 a_141_36.t3 204.048
R41 a_141_36.n1 a_141_36.t4 247.428
R42 a_141_36.n2 a_141_36.n0 245.8
R43 a_141_36.n0 a_141_36.t2 52.0005
R44 a_141_36.n0 a_141_36.t1 52.0005
C14 VGND VNB 0.55224f
C15 X VNB 0.26234f
C16 VPWR VNB 0.48063f
C17 B VNB 0.22837f
C18 A VNB 0.25616f
C19 VPB VNB 0.81732f
C20 a_141_36.t0 VNB 0.05567f
C21 a_141_36.t2 VNB 0.01548f
C22 a_141_36.t1 VNB 0.01548f
C23 a_141_36.n0 VNB 0.06808f
C24 a_141_36.t4 VNB 0.04045f
C25 a_141_36.t3 VNB 0.02519f
C26 a_141_36.n1 VNB 0.1197f
C27 a_141_36.n2 VNB 0.49384f
C28 a_141_450.t0 VNB 0.01104f
C29 a_141_450.t1 VNB 0.01104f
C30 VPB.t1 VNB 0.21712f
C31 VPB.t0 VNB 0.1357f
C32 VPB.t2 VNB 0.08821f
C33 A.t1 VNB 0.04893f
C34 A.t0 VNB 0.03484f
C35 A.n0 VNB 0.17032f
C36 B.t1 VNB 0.06457f
C37 B.t0 VNB 0.04598f
C38 B.n0 VNB 0.22476f
C39 VPWR.t1 VNB 0.04486f
C40 VPWR.t0 VNB 0.01901f
C41 VPWR.n0 VNB 0.36585f
C42 X.t1 VNB 0.08564f
C43 X.t0 VNB 0.04255f
C44 X.n0 VNB 0.03597f
C45 VGND.t0 VNB 0.02077f
C46 VGND.n0 VNB 0.16869f
C47 VGND.t1 VNB 0.01477f
C48 VGND.n1 VNB 0.00942f
C49 VGND.t2 VNB 0.01477f
C50 VGND.n2 VNB 0.03545f
C51 VGND.n3 VNB 0.02269f
C52 VGND.n4 VNB 0.02513f
C53 VGND.n5 VNB 0.02513f
C54 VGND.n6 VNB 0.01257f
C55 VGND.n7 VNB 0.00942f
C56 VGND.n8 VNB 0.03451f
C57 VGND.n9 VNB 0.03366f
.ends

.subckt sky130_efx_lvdig__or2_2 A B X VGND VNB VPB VPWR
X0 VGND.t0 B.t0 a_141_36.t1 VNB.t0 sky130_fd_pr__nfet_01v8 ad=0.16875 pd=1.65 as=0.08775 ps=0.84 w=0.45 l=0.15
X1 VGND.t3 a_141_36.t3 X.t3 VNB.t3 sky130_fd_pr__nfet_01v8 ad=0.23625 pd=2.01 as=0.12285 ps=1.02 w=0.63 l=0.15
X2 a_141_450.t1 A.t1 VPWR.t0 VPB.t3 sky130_fd_pr__pfet_01v8_hvt ad=0.08775 pd=0.84 as=0.16875 ps=1.65 w=0.45 l=0.15
X3 a_141_36.t2 A.t0 VGND.t1 VNB.t2 sky130_fd_pr__nfet_01v8 ad=0.08775 pd=0.84 as=0.16875 ps=1.65 w=0.45 l=0.15
X4 a_141_36.t0 B.t1 a_141_450.t0 VPB.t0 sky130_fd_pr__pfet_01v8_hvt ad=0.16875 pd=1.65 as=0.08775 ps=0.84 w=0.45 l=0.15
X5 X.t2 a_141_36.t6 VPWR.t2 VPB.t2 sky130_fd_pr__pfet_01v8_hvt ad=0.2106 pd=1.47 as=0.405 ps=2.91 w=1.08 l=0.15
X6 VPWR.t1 a_141_36.t5 X.t1 VPB.t1 sky130_fd_pr__pfet_01v8_hvt ad=0.405 pd=2.91 as=0.2106 ps=1.47 w=1.08 l=0.15
X7 X.t0 a_141_36.t4 VGND.t2 VNB.t1 sky130_fd_pr__nfet_01v8 ad=0.12285 pd=1.02 as=0.23625 ps=2.01 w=0.63 l=0.15
C0 VPWR B 0.01988f
C1 A VGND 0.04458f
C2 VGND X 0.15357f
C3 B VPB 0.10919f
C4 VPWR VPB 0.15165f
C5 A B 0.08246f
C6 A VPWR 0.03612f
C7 B X 0.00138f
C8 VPWR X 0.17204f
C9 A VPB 0.09793f
C10 B VGND 0.04534f
C11 VPWR VGND 0.0815f
C12 X VPB 0.00744f
C13 VGND VPB 0.01454f
R0 VGND.n3 VGND.t0 253
R1 VGND.n4 VGND.t1 253
R2 VGND VGND.t3 231.744
R3 VGND VGND.t2 231.744
R4 VGND.n0 VGND 16.2074
R5 VGND.n5 VGND.n4 15.7005
R6 VGND.n13 VGND.n1 12.8005
R7 VGND.n9 VGND.n8 12.8005
R8 VGND.n8 VGND.n7 12.8005
R9 VGND.n14 VGND.n0 12.1406
R10 VGND VGND.n14 9.6005
R11 VGND.n7 VGND.n6 9.3005
R12 VGND.n8 VGND.n2 9.3005
R13 VGND.n10 VGND.n9 9.3005
R14 VGND.n11 VGND.n1 9.3005
R15 VGND.n13 VGND.n12 9.3005
R16 VGND.n14 VGND.n13 6.4005
R17 VGND.n3 VGND.n1 6.4005
R18 VGND.n9 VGND.n3 6.4005
R19 VGND.n7 VGND.n4 6.4005
R20 VGND.n12 VGND.n0 0.584022
R21 VGND.n12 VGND.n11 0.063
R22 VGND.n11 VGND.n10 0.063
R23 VGND.n10 VGND.n2 0.063
R24 VGND.n6 VGND.n2 0.063
R25 VGND.n6 VGND.n5 0.063
R26 VGND.n5 VGND 0.03175
R27 X X.n0 308.5
R28 X.n2 X.n1 185
R29 X.n1 X.t3 37.1434
R30 X.n1 X.t0 37.1434
R31 X.n0 X.t1 35.5699
R32 X.n0 X.t2 35.5699
R33 X X.n2 19.2005
R34 X.n2 X 9.6005
R35 VPWR.n12 VPWR.t2 786.92
R36 VPWR.n4 VPWR.t0 683.168
R37 VPWR.n14 VPWR.t1 328.07
R38 VPWR.n14 VPWR.n13 32.2074
R39 VPWR VPWR.n14 16.0005
R40 VPWR.n4 VPWR.n3 15.7005
R41 VPWR.n11 VPWR.n10 12.8005
R42 VPWR.n10 VPWR.n1 12.8005
R43 VPWR.n6 VPWR.n1 12.8005
R44 VPWR.n6 VPWR.n5 12.8005
R45 VPWR.n13 VPWR.n12 12.1406
R46 VPWR.n5 VPWR.n2 9.3005
R47 VPWR.n7 VPWR.n6 9.3005
R48 VPWR.n8 VPWR.n1 9.3005
R49 VPWR.n10 VPWR.n9 9.3005
R50 VPWR.n11 VPWR.n0 9.3005
R51 VPWR.n12 VPWR.n11 6.4005
R52 VPWR.n5 VPWR.n4 6.4005
R53 VPWR.n13 VPWR.n0 0.584022
R54 VPWR.n9 VPWR.n0 0.063
R55 VPWR.n9 VPWR.n8 0.063
R56 VPWR.n8 VPWR.n7 0.063
R57 VPWR.n7 VPWR.n2 0.063
R58 VPWR.n3 VPWR.n2 0.063
R59 VPWR.n3 VPWR 0.03175
R60 B.n0 B.t1 348.647
R61 B.n0 B.t0 232.968
R62 B B.n0 158.4
R63 A.n0 A.t1 348.647
R64 A.n0 A.t0 232.968
R65 A A.n0 158.4
R66 VPB.t0 VPB.t2 604.545
R67 VPB VPB.t3 302.274
R68 VPB.t2 VPB.t1 259.091
R69 VPB.t3 VPB.t0 259.091
R70 VNB.t0 VNB.t1 2800
R71 VNB VNB.t2 1400
R72 VNB.t1 VNB.t3 1200
R73 VNB.t2 VNB.t0 1200
R74 a_141_450.t0 a_141_450.t1 170.733
R75 a_141_36.t0 a_141_36.n3 689.567
R76 a_141_36.n3 a_141_36.n2 226.55
R77 a_141_36.n2 a_141_36.n1 72.3005
R78 a_141_36.n2 a_141_36.t6 231.361
R79 a_141_36.n2 a_141_36.t4 187.981
R80 a_141_36.n1 a_141_36.t5 231.361
R81 a_141_36.n1 a_141_36.t3 187.981
R82 a_141_36.n3 a_141_36.n0 245.8
R83 a_141_36.n0 a_141_36.t2 52.0005
R84 a_141_36.n0 a_141_36.t1 52.0005
C14 VGND VNB 0.64367f
C15 X VNB 0.27522f
C16 VPWR VNB 0.46788f
C17 B VNB 0.22789f
C18 A VNB 0.25616f
C19 VPB VNB 0.9022f
C20 a_141_36.t0 VNB 0.05498f
C21 a_141_36.t2 VNB 0.01529f
C22 a_141_36.t1 VNB 0.01529f
C23 a_141_36.n0 VNB 0.06724f
C24 a_141_36.t3 VNB 0.02234f
C25 a_141_36.t5 VNB 0.03763f
C26 a_141_36.n1 VNB 0.07926f
C27 a_141_36.t4 VNB 0.02234f
C28 a_141_36.t6 VNB 0.03763f
C29 a_141_36.n2 VNB 0.13597f
C30 a_141_36.n3 VNB 0.49746f
C31 a_141_450.t0 VNB 0.01104f
C32 a_141_450.t1 VNB 0.01104f
C33 VPB.t1 VNB 0.13384f
C34 VPB.t2 VNB 0.13384f
C35 VPB.t0 VNB 0.13384f
C36 VPB.t3 VNB 0.087f
C37 A.t1 VNB 0.04893f
C38 A.t0 VNB 0.03484f
C39 A.n0 VNB 0.17032f
C40 B.t1 VNB 0.06478f
C41 B.t0 VNB 0.04612f
C42 B.n0 VNB 0.22547f
C43 VPWR.n0 VNB 0.14001f
C44 VPWR.t2 VNB 0.04429f
C45 VPWR.n1 VNB 0.01532f
C46 VPWR.n2 VNB 0.03064f
C47 VPWR.t0 VNB 0.01846f
C48 VPWR.n3 VNB 0.02767f
C49 VPWR.n4 VNB 0.04277f
C50 VPWR.n5 VNB 0.01149f
C51 VPWR.n6 VNB 0.01532f
C52 VPWR.n7 VNB 0.03064f
C53 VPWR.n8 VNB 0.03064f
C54 VPWR.n9 VNB 0.03064f
C55 VPWR.n10 VNB 0.01532f
C56 VPWR.n11 VNB 0.01149f
C57 VPWR.n12 VNB 0.04182f
C58 VPWR.n13 VNB 0.07061f
C59 VPWR.t1 VNB 0.04404f
C60 VPWR.n14 VNB 0.03652f
C61 X.t1 VNB 0.03342f
C62 X.t2 VNB 0.03342f
C63 X.n0 VNB 0.07138f
C64 X.t3 VNB 0.0195f
C65 X.t0 VNB 0.0195f
C66 X.n1 VNB 0.039f
C67 X.n2 VNB 0.04628f
C68 VGND.t2 VNB 0.02102f
C69 VGND.t3 VNB 0.02102f
C70 VGND.n0 VNB 0.04752f
C71 VGND.n1 VNB 0.00954f
C72 VGND.n2 VNB 0.02543f
C73 VGND.t0 VNB 0.01494f
C74 VGND.n3 VNB 0.03022f
C75 VGND.t1 VNB 0.01494f
C76 VGND.n4 VNB 0.03587f
C77 VGND.n5 VNB 0.02296f
C78 VGND.n6 VNB 0.02543f
C79 VGND.n7 VNB 0.00954f
C80 VGND.n8 VNB 0.01271f
C81 VGND.n9 VNB 0.00954f
C82 VGND.n10 VNB 0.02543f
C83 VGND.n11 VNB 0.02543f
C84 VGND.n12 VNB 0.11618f
C85 VGND.n13 VNB 0.00954f
C86 VGND.n14 VNB 0.01742f
.ends

.subckt sky130_efx_lvdig__or2_4 A B X VGND VNB VPB VPWR
X0 VPWR.t3 pmos_n6_f2_l150_hvt_fnf_0.D0.t7 X.t6 VPB.t2 sky130_fd_pr__pfet_01v8_hvt ad=0.405 pd=2.91 as=0.2106 ps=1.47 w=1.08 l=0.15
X1 VGND.t5 B.t0 pmos_n6_f2_l150_hvt_fnf_0.D0.t1 VNB.t5 sky130_fd_pr__nfet_01v8 ad=0.23625 pd=2.01 as=0.12285 ps=1.02 w=0.63 l=0.15
X2 a_141_324.t0 A.t1 VPWR.t2 VPB.t3 sky130_fd_pr__pfet_01v8_hvt ad=0.2106 pd=1.47 as=0.405 ps=2.91 w=1.08 l=0.15
X3 pmos_n6_f2_l150_hvt_fnf_0.D0.t2 B.t1 a_141_324.t1 VPB.t4 sky130_fd_pr__pfet_01v8_hvt ad=0.405 pd=2.91 as=0.2106 ps=1.47 w=1.08 l=0.15
X4 X.t2 pmos_n6_f2_l150_hvt_fnf_0.D0.t4 VGND.t2 VNB.t1 sky130_fd_pr__nfet_01v8 ad=0.12285 pd=1.02 as=0.12285 ps=1.02 w=0.63 l=0.15
X5 VGND.t3 pmos_n6_f2_l150_hvt_fnf_0.D0.t3 X.t3 VNB.t2 sky130_fd_pr__nfet_01v8 ad=0.23625 pd=2.01 as=0.12285 ps=1.02 w=0.63 l=0.15
X6 VGND.t1 pmos_n6_f2_l150_hvt_fnf_0.D0.t5 X.t1 VNB.t0 sky130_fd_pr__nfet_01v8 ad=0.12285 pd=1.02 as=0.12285 ps=1.02 w=0.63 l=0.15
X7 pmos_n6_f2_l150_hvt_fnf_0.D0.t0 A.t0 VGND.t0 VNB.t4 sky130_fd_pr__nfet_01v8 ad=0.12285 pd=1.02 as=0.23625 ps=2.01 w=0.63 l=0.15
X8 X.t4 pmos_n6_f2_l150_hvt_fnf_0.D0.t10 VPWR.t1 VPB.t1 sky130_fd_pr__pfet_01v8_hvt ad=0.2106 pd=1.47 as=0.405 ps=2.91 w=1.08 l=0.15
X9 VPWR.t0 pmos_n6_f2_l150_hvt_fnf_0.D0.t9 X.t0 VPB.t0 sky130_fd_pr__pfet_01v8_hvt ad=0.2106 pd=1.47 as=0.2106 ps=1.47 w=1.08 l=0.15
X10 X.t5 pmos_n6_f2_l150_hvt_fnf_0.D0.t6 VGND.t4 VNB.t3 sky130_fd_pr__nfet_01v8 ad=0.12285 pd=1.02 as=0.23625 ps=2.01 w=0.63 l=0.15
X11 X.t7 pmos_n6_f2_l150_hvt_fnf_0.D0.t8 VPWR.t4 VPB.t5 sky130_fd_pr__pfet_01v8_hvt ad=0.2106 pd=1.47 as=0.2106 ps=1.47 w=1.08 l=0.15
C0 VGND A 0.05438f
C1 B VPB 0.05339f
C2 pmos_n6_f2_l150_hvt_fnf_0.D0 VPB 0.22386f
C3 B A 0.04923f
C4 pmos_n6_f2_l150_hvt_fnf_0.D0 A 0.056f
C5 VPWR VPB 0.17778f
C6 VPWR A 0.06465f
C7 X VPB 0.0153f
C8 VGND B 0.05399f
C9 pmos_n6_f2_l150_hvt_fnf_0.D0 VGND 0.29912f
C10 VGND VPWR 0.1033f
C11 VGND X 0.34107f
C12 pmos_n6_f2_l150_hvt_fnf_0.D0 B 0.15417f
C13 VPWR B 0.02048f
C14 A VPB 0.04956f
C15 pmos_n6_f2_l150_hvt_fnf_0.D0 VPWR 0.30487f
C17 pmos_n6_f2_l150_hvt_fnf_0.D0 X 0.28854f
C18 VGND VPB 0.01259f
C19 X VPWR 0.43561f
R0 VGND.n11 VGND.t5 241.344
R1 VGND.n12 VGND.t0 241.344
R2 VGND VGND.t3 231.744
R3 VGND VGND.t4 231.744
R4 VGND VGND.n3 194.601
R5 VGND.n3 VGND.t2 37.1434
R6 VGND.n3 VGND.t1 37.1434
R7 VGND.n4 VGND 16.2074
R8 VGND.n13 VGND.n12 15.7005
R9 VGND.n7 VGND.n6 12.8005
R10 VGND.n7 VGND.n0 12.8005
R11 VGND.n21 VGND.n1 12.8005
R12 VGND.n17 VGND.n16 12.8005
R13 VGND.n16 VGND.n15 12.8005
R14 VGND.n5 VGND.n4 12.1406
R15 VGND.n5 VGND 9.6005
R16 VGND VGND.n22 9.6005
R17 VGND.n15 VGND.n14 9.3005
R18 VGND.n16 VGND.n10 9.3005
R19 VGND.n18 VGND.n17 9.3005
R20 VGND.n19 VGND.n1 9.3005
R21 VGND.n21 VGND.n20 9.3005
R22 VGND.n9 VGND.n0 9.3005
R23 VGND.n8 VGND.n7 9.3005
R24 VGND.n6 VGND.n2 9.3005
R25 VGND.n6 VGND.n5 6.4005
R26 VGND.n22 VGND.n0 6.4005
R27 VGND.n22 VGND.n21 6.4005
R28 VGND.n11 VGND.n1 6.4005
R29 VGND.n17 VGND.n11 6.4005
R30 VGND.n15 VGND.n12 6.4005
R31 VGND.n4 VGND.n2 0.584022
R32 VGND.n8 VGND.n2 0.063
R33 VGND.n9 VGND.n8 0.063
R34 VGND.n20 VGND.n9 0.063
R35 VGND.n20 VGND.n19 0.063
R36 VGND.n19 VGND.n18 0.063
R37 VGND.n18 VGND.n10 0.063
R38 VGND.n14 VGND.n10 0.063
R39 VGND.n14 VGND.n13 0.063
R40 VGND.n13 VGND 0.03175
R41 X X.n3 308.5
R42 X X.n0 308.5
R43 X.n5 X.n4 185
R44 X.n2 X.n1 185
R45 X.n7 X.n6 38.4005
R46 X.n4 X.t3 37.1434
R47 X.n4 X.t2 37.1434
R48 X.n1 X.t1 37.1434
R49 X.n1 X.t5 37.1434
R50 X.n3 X.t6 35.5699
R51 X.n3 X.t7 35.5699
R52 X.n0 X.t0 35.5699
R53 X.n0 X.t4 35.5699
R54 X.n6 X.n5 19.2005
R55 X.n7 X.n2 19.2005
R56 X.n6 X 9.6005
R57 X.n5 X 9.6005
R58 X X.n7 9.6005
R59 X.n2 X 9.6005
R60 X.n7 X 6.4005
R61 VPWR.n5 VPWR.t1 786.92
R62 VPWR.n8 VPWR.t2 328.07
R63 VPWR.n24 VPWR.t3 328.07
R64 VPWR.n2 VPWR.n1 292.5
R65 VPWR.n1 VPWR.t4 35.5699
R66 VPWR.n1 VPWR.t0 35.5699
R67 VPWR.n24 VPWR.n23 32.2074
R68 VPWR.n9 VPWR.n8 25.6005
R69 VPWR.n22 VPWR.n2 25.6005
R70 VPWR.n8 VPWR 16.0005
R71 VPWR.n2 VPWR 16.0005
R72 VPWR VPWR.n24 16.0005
R73 VPWR.n9 VPWR.n7 15.7005
R74 VPWR.n21 VPWR.n20 12.8005
R75 VPWR.n20 VPWR.n3 12.8005
R76 VPWR.n16 VPWR.n15 12.8005
R77 VPWR.n15 VPWR.n14 12.8005
R78 VPWR.n14 VPWR.n6 12.8005
R79 VPWR.n10 VPWR.n6 12.8005
R80 VPWR.n23 VPWR.n22 12.1406
R81 VPWR.n11 VPWR.n10 9.3005
R82 VPWR.n12 VPWR.n6 9.3005
R83 VPWR.n14 VPWR.n13 9.3005
R84 VPWR.n15 VPWR.n4 9.3005
R85 VPWR.n17 VPWR.n16 9.3005
R86 VPWR.n18 VPWR.n3 9.3005
R87 VPWR.n20 VPWR.n19 9.3005
R88 VPWR.n21 VPWR.n0 9.3005
R89 VPWR.n22 VPWR.n21 6.4005
R90 VPWR.n5 VPWR.n3 6.4005
R91 VPWR.n16 VPWR.n5 6.4005
R92 VPWR.n10 VPWR.n9 6.4005
R93 VPWR.n23 VPWR.n0 0.584022
R94 VPWR.n19 VPWR.n0 0.063
R95 VPWR.n19 VPWR.n18 0.063
R96 VPWR.n18 VPWR.n17 0.063
R97 VPWR.n17 VPWR.n4 0.063
R98 VPWR.n13 VPWR.n4 0.063
R99 VPWR.n13 VPWR.n12 0.063
R100 VPWR.n12 VPWR.n11 0.063
R101 VPWR.n11 VPWR.n7 0.063
R102 VPWR.n7 VPWR 0.03175
R103 B.n0 B.t1 247.428
R104 B.n0 B.t0 204.048
R105 B B.n0 158.4
R106 A.n0 A.t1 247.428
R107 A.n0 A.t0 204.048
R108 A A.n0 158.4
R109 VPB.t4 VPB.t1 604.545
R110 VPB VPB.t3 302.274
R111 VPB.t5 VPB.t2 259.091
R112 VPB.t0 VPB.t5 259.091
R113 VPB.t1 VPB.t0 259.091
R114 VPB.t3 VPB.t4 259.091
R115 VNB.t5 VNB.t3 2800
R116 VNB VNB.t4 1400
R117 VNB.t1 VNB.t2 1200
R118 VNB.t0 VNB.t1 1200
R119 VNB.t3 VNB.t0 1200
R120 VNB.t4 VNB.t5 1200
R121 a_141_324.t0 a_141_324.t1 71.1394
R122 pmos_n6_f2_l150_hvt_fnf_0.D0.t0 pmos_n6_f2_l150_hvt_fnf_0.D0.n0 37.1434
R123 pmos_n6_f2_l150_hvt_fnf_0.D0.n0 pmos_n6_f2_l150_hvt_fnf_0.D0.t1 37.1434
R124 pmos_n6_f2_l150_hvt_fnf_0.D0 pmos_n6_f2_l150_hvt_fnf_0.D0.n0 242.601
R125 pmos_n6_f2_l150_hvt_fnf_0.D0 pmos_n6_f2_l150_hvt_fnf_0.D0.t2 334.469
R126 pmos_n6_f2_l150_hvt_fnf_0.D0 pmos_n6_f2_l150_hvt_fnf_0.D0.n4 226.55
R127 pmos_n6_f2_l150_hvt_fnf_0.D0.n4 pmos_n6_f2_l150_hvt_fnf_0.D0.n3 72.3005
R128 pmos_n6_f2_l150_hvt_fnf_0.D0.n3 pmos_n6_f2_l150_hvt_fnf_0.D0.n2 72.3005
R129 pmos_n6_f2_l150_hvt_fnf_0.D0.n2 pmos_n6_f2_l150_hvt_fnf_0.D0.n1 72.3005
R130 pmos_n6_f2_l150_hvt_fnf_0.D0.n4 pmos_n6_f2_l150_hvt_fnf_0.D0.t10 231.361
R131 pmos_n6_f2_l150_hvt_fnf_0.D0.n4 pmos_n6_f2_l150_hvt_fnf_0.D0.t6 187.981
R132 pmos_n6_f2_l150_hvt_fnf_0.D0.n3 pmos_n6_f2_l150_hvt_fnf_0.D0.t9 231.361
R133 pmos_n6_f2_l150_hvt_fnf_0.D0.n3 pmos_n6_f2_l150_hvt_fnf_0.D0.t5 187.981
R134 pmos_n6_f2_l150_hvt_fnf_0.D0.n2 pmos_n6_f2_l150_hvt_fnf_0.D0.t8 231.361
R135 pmos_n6_f2_l150_hvt_fnf_0.D0.n2 pmos_n6_f2_l150_hvt_fnf_0.D0.t4 187.981
R136 pmos_n6_f2_l150_hvt_fnf_0.D0.n1 pmos_n6_f2_l150_hvt_fnf_0.D0.t7 231.361
R137 pmos_n6_f2_l150_hvt_fnf_0.D0.n1 pmos_n6_f2_l150_hvt_fnf_0.D0.t3 187.981
C20 VGND VNB 0.79778f
C21 X VNB 0.35874f
C22 VPWR VNB 0.60221f
C23 B VNB 0.18505f
C24 A VNB 0.21195f
C25 VPB VNB 1.14781f
C26 pmos_n6_f2_l150_hvt_fnf_0.D0 VNB 0.92495f
C27 pmos_n6_f2_l150_hvt_fnf_0.D0.t0 VNB 0.02039f
C28 pmos_n6_f2_l150_hvt_fnf_0.D0.n0 VNB 0.07568f
C29 pmos_n6_f2_l150_hvt_fnf_0.D0.t3 VNB 0.02129f
C30 pmos_n6_f2_l150_hvt_fnf_0.D0.t7 VNB 0.03585f
C31 pmos_n6_f2_l150_hvt_fnf_0.D0.n1 VNB 0.07551f
C32 pmos_n6_f2_l150_hvt_fnf_0.D0.t4 VNB 0.02129f
C33 pmos_n6_f2_l150_hvt_fnf_0.D0.t8 VNB 0.03585f
C34 pmos_n6_f2_l150_hvt_fnf_0.D0.n2 VNB 0.09702f
C35 pmos_n6_f2_l150_hvt_fnf_0.D0.t5 VNB 0.02129f
C36 pmos_n6_f2_l150_hvt_fnf_0.D0.t9 VNB 0.03585f
C37 pmos_n6_f2_l150_hvt_fnf_0.D0.n3 VNB 0.09702f
C38 pmos_n6_f2_l150_hvt_fnf_0.D0.t6 VNB 0.02129f
C39 pmos_n6_f2_l150_hvt_fnf_0.D0.t10 VNB 0.03585f
C40 pmos_n6_f2_l150_hvt_fnf_0.D0.n4 VNB 0.12953f
C41 pmos_n6_f2_l150_hvt_fnf_0.D0.t2 VNB 0.12529f
C42 pmos_n6_f2_l150_hvt_fnf_0.D0.t1 VNB 0.02039f
C43 a_141_324.t0 VNB 0.02157f
C44 a_141_324.t1 VNB 0.02157f
C45 VPB.t2 VNB 0.1024f
C46 VPB.t5 VNB 0.06144f
C47 VPB.t0 VNB 0.06144f
C48 VPB.t1 VNB 0.1024f
C49 VPB.t4 VNB 0.1024f
C50 VPB.t3 VNB 0.06656f
C51 A.t1 VNB 0.05286f
C52 A.t0 VNB 0.03292f
C53 A.n0 VNB 0.13011f
C54 B.t1 VNB 0.06401f
C55 B.t0 VNB 0.03986f
C56 B.n0 VNB 0.15757f
C57 VPWR.n0 VNB 0.1617f
C58 VPWR.t4 VNB 0.01438f
C59 VPWR.t0 VNB 0.01438f
C60 VPWR.n1 VNB 0.02875f
C61 VPWR.n2 VNB 0.02875f
C62 VPWR.n3 VNB 0.01327f
C63 VPWR.n4 VNB 0.03539f
C64 VPWR.t1 VNB 0.05115f
C65 VPWR.n5 VNB 0.03953f
C66 VPWR.n6 VNB 0.01769f
C67 VPWR.n7 VNB 0.03195f
C68 VPWR.t2 VNB 0.05086f
C69 VPWR.n8 VNB 0.03319f
C70 VPWR.n9 VNB 0.0344f
C71 VPWR.n10 VNB 0.01327f
C72 VPWR.n11 VNB 0.03539f
C73 VPWR.n12 VNB 0.03539f
C74 VPWR.n13 VNB 0.03539f
C75 VPWR.n14 VNB 0.01769f
C76 VPWR.n15 VNB 0.01769f
C77 VPWR.n16 VNB 0.01327f
C78 VPWR.n17 VNB 0.03539f
C79 VPWR.n18 VNB 0.03539f
C80 VPWR.n19 VNB 0.03539f
C81 VPWR.n20 VNB 0.01769f
C82 VPWR.n21 VNB 0.01327f
C83 VPWR.n22 VNB 0.0353f
C84 VPWR.n23 VNB 0.08155f
C85 VPWR.t3 VNB 0.05086f
C86 VPWR.n24 VNB 0.04217f
C87 X.t0 VNB 0.0334f
C88 X.t4 VNB 0.0334f
C89 X.n0 VNB 0.07133f
C90 X.t1 VNB 0.01948f
C91 X.t5 VNB 0.01948f
C92 X.n1 VNB 0.03897f
C93 X.n2 VNB 0.04625f
C94 X.t6 VNB 0.0334f
C95 X.t7 VNB 0.0334f
C96 X.n3 VNB 0.07133f
C97 X.t3 VNB 0.01948f
C98 X.t2 VNB 0.01948f
C99 X.n4 VNB 0.03897f
C100 X.n5 VNB 0.04625f
C101 X.n6 VNB 0.12847f
C102 X.n7 VNB 0.11819f
C103 VGND.t4 VNB 0.0241f
C104 VGND.n0 VNB 0.01093f
C105 VGND.n1 VNB 0.01093f
C106 VGND.n2 VNB 0.13319f
C107 VGND.t2 VNB 0.00691f
C108 VGND.t1 VNB 0.00691f
C109 VGND.n3 VNB 0.01462f
C110 VGND.t3 VNB 0.0241f
C111 VGND.n4 VNB 0.05447f
C112 VGND.n5 VNB 0.01997f
C113 VGND.n6 VNB 0.01093f
C114 VGND.n7 VNB 0.01457f
C115 VGND.n8 VNB 0.02915f
C116 VGND.n9 VNB 0.02915f
C117 VGND.n10 VNB 0.02915f
C118 VGND.t5 VNB 0.02528f
C119 VGND.n11 VNB 0.04137f
C120 VGND.t0 VNB 0.02528f
C121 VGND.n12 VNB 0.04784f
C122 VGND.n13 VNB 0.02632f
C123 VGND.n14 VNB 0.02915f
C124 VGND.n15 VNB 0.01093f
C125 VGND.n16 VNB 0.01457f
C126 VGND.n17 VNB 0.01093f
C127 VGND.n18 VNB 0.02915f
C128 VGND.n19 VNB 0.02915f
C129 VGND.n20 VNB 0.02915f
C130 VGND.n21 VNB 0.01093f
C131 VGND.n22 VNB 0.01275f
.ends

.subckt sky130_efx_lvdig__or3_1 A B C X VGND VNB VPB VPWR
X0 a_393_450.t1 B.t1 a_141_450.t0 VPB.t2 sky130_fd_pr__pfet_01v8_hvt ad=0.08775 pd=0.84 as=0.16875 ps=1.65 w=0.45 l=0.15
X1 a_141_36.t0 C.t1 a_393_450.t0 VPB.t1 sky130_fd_pr__pfet_01v8_hvt ad=0.16875 pd=1.65 as=0.08775 ps=0.84 w=0.45 l=0.15
X2 X.t0 a_141_36.t4 VGND.t3 VNB.t0 sky130_fd_pr__nfet_01v8 ad=0.23625 pd=2.01 as=0.23625 ps=2.01 w=0.63 l=0.15
X3 X.t1 a_141_36.t5 VPWR.t1 VPB.t0 sky130_fd_pr__pfet_01v8_hvt ad=0.405 pd=2.91 as=0.405 ps=2.91 w=1.08 l=0.15
X4 a_141_450.t1 A.t1 VPWR.t0 VPB.t3 sky130_fd_pr__pfet_01v8_hvt ad=0.16875 pd=1.65 as=0.16875 ps=1.65 w=0.45 l=0.15
X5 a_141_36.t3 A.t0 VGND.t2 VNB.t3 sky130_fd_pr__nfet_01v8 ad=0.16875 pd=1.65 as=0.16875 ps=1.65 w=0.45 l=0.15
X6 a_141_36.t2 B.t0 VGND.t1 VNB.t2 sky130_fd_pr__nfet_01v8 ad=0.08775 pd=0.84 as=0.16875 ps=1.65 w=0.45 l=0.15
X7 VGND.t0 C.t0 a_141_36.t1 VNB.t1 sky130_fd_pr__nfet_01v8 ad=0.16875 pd=1.65 as=0.08775 ps=0.84 w=0.45 l=0.15
C0 C VPWR 0.0171f
C1 VGND VPB 0.01688f
C2 C B 0.08246f
C3 VGND A 0.04537f
C4 X VGND 0.10221f
C5 VPB VPWR 0.17424f
C6 B VPB 0.10467f
C7 A VPWR 0.03682f
C8 A B 0.03135f
C9 C VPB 0.10794f
C10 X VPWR 0.08434f
C11 VGND VPWR 0.07949f
C12 VGND B 0.04407f
C13 X C 0.00138f
C14 VGND C 0.04521f
C15 A VPB 0.11458f
C16 B VPWR 0.01679f
C17 X VPB 0.00999f
R0 VGND.n14 VGND.t0 253
R1 VGND.n1 VGND.t1 253
R2 VGND.n3 VGND.t2 253
R3 VGND VGND.t3 231.744
R4 VGND.n4 VGND.n3 15.7005
R5 VGND VGND.n15 13.7372
R6 VGND.n14 VGND.n13 12.8005
R7 VGND.n13 VGND.n12 12.8005
R8 VGND.n12 VGND.n1 12.8005
R9 VGND.n8 VGND.n1 12.8005
R10 VGND.n8 VGND.n7 12.8005
R11 VGND.n7 VGND.n6 12.8005
R12 VGND.n6 VGND.n5 9.3005
R13 VGND.n7 VGND.n2 9.3005
R14 VGND.n9 VGND.n8 9.3005
R15 VGND.n10 VGND.n1 9.3005
R16 VGND.n12 VGND.n11 9.3005
R17 VGND.n13 VGND.n0 9.3005
R18 VGND.n6 VGND.n3 6.4005
R19 VGND.n15 VGND.n14 5.5582
R20 VGND.n15 VGND.n0 0.763402
R21 VGND.n11 VGND.n0 0.063
R22 VGND.n11 VGND.n10 0.063
R23 VGND.n10 VGND.n9 0.063
R24 VGND.n9 VGND.n2 0.063
R25 VGND.n5 VGND.n2 0.063
R26 VGND.n5 VGND.n4 0.063
R27 VGND.n4 VGND 0.03175
R28 X X.t1 366.469
R29 X.n0 X.t0 222.143
R30 X.n0 X 19.2005
R31 X X.n0 9.6005
R32 VPWR.n0 VPWR.t1 792.122
R33 VPWR.n0 VPWR.t0 690.143
R34 VPWR VPWR.n0 0.0844344
R35 C.n0 C.t1 348.647
R36 C.n0 C.t0 232.968
R37 C C.n0 158.4
R38 B.n0 B.t1 348.647
R39 B.n0 B.t0 232.968
R40 B B.n0 158.4
R41 A.n0 A.t1 348.647
R42 A.n0 A.t0 232.968
R43 A A.n0 158.4
R44 VPB.t1 VPB.t0 604.545
R45 VPB.t3 VPB.t2 604.545
R46 VPB VPB.t3 302.274
R47 VPB.t2 VPB.t1 259.091
R48 VNB.t1 VNB.t0 2800
R49 VNB.t3 VNB.t2 2800
R50 VNB VNB.t3 1400
R51 VNB.t2 VNB.t1 1200
R52 a_393_450.t0 a_393_450.t1 170.733
R53 a_141_450.t0 a_141_450.t1 1366.33
R54 a_141_36.t0 a_141_36.n3 689.567
R55 a_141_36.n3 a_141_36.n1 19.2005
R56 a_141_36.n3 a_141_36.n2 190.4
R57 a_141_36.n2 a_141_36.t4 204.048
R58 a_141_36.n2 a_141_36.t5 247.428
R59 a_141_36.n1 a_141_36.n0 226.601
R60 a_141_36.n0 a_141_36.t2 52.0005
R61 a_141_36.n0 a_141_36.t1 52.0005
R62 a_141_36.n1 a_141_36.t3 323.401
C18 VGND VNB 0.68549f
C19 X VNB 0.2645f
C20 VPWR VNB 0.50561f
C21 C VNB 0.22865f
C22 B VNB 0.22414f
C23 A VNB 0.26498f
C24 VPB VNB 1.0764f
C25 a_141_36.t0 VNB 0.05404f
C26 a_141_36.t3 VNB 0.1029f
C27 a_141_36.t2 VNB 0.01503f
C28 a_141_36.t1 VNB 0.01503f
C29 a_141_36.n0 VNB 0.0494f
C30 a_141_36.n1 VNB 0.50142f
C31 a_141_36.t5 VNB 0.03927f
C32 a_141_36.t4 VNB 0.02445f
C33 a_141_36.n2 VNB 0.1162f
C34 a_141_36.n3 VNB 0.28245f
C35 a_141_450.t0 VNB 0.1366f
C36 a_141_450.t1 VNB 0.1366f
C37 a_393_450.t0 VNB 0.01111f
C38 a_393_450.t1 VNB 0.01111f
C39 VPB.t0 VNB 0.19988f
C40 VPB.t1 VNB 0.14277f
C41 VPB.t2 VNB 0.14277f
C42 VPB.t3 VNB 0.14991f
C43 A.t1 VNB 0.04458f
C44 A.t0 VNB 0.03174f
C45 A.n0 VNB 0.15515f
C46 B.t1 VNB 0.06397f
C47 B.t0 VNB 0.04555f
C48 B.n0 VNB 0.22266f
C49 C.t1 VNB 0.06443f
C50 C.t0 VNB 0.04587f
C51 C.n0 VNB 0.22425f
C52 VPWR.t1 VNB 0.05065f
C53 VPWR.t0 VNB 0.02145f
C54 VPWR.n0 VNB 0.64241f
C55 X.t1 VNB 0.08451f
C56 X.t0 VNB 0.04199f
C57 X.n0 VNB 0.0355f
C58 VGND.t3 VNB 0.02183f
C59 VGND.n0 VNB 0.16154f
C60 VGND.t0 VNB 0.01551f
C61 VGND.t1 VNB 0.01551f
C62 VGND.n1 VNB 0.03798f
C63 VGND.n2 VNB 0.0264f
C64 VGND.t2 VNB 0.01551f
C65 VGND.n3 VNB 0.03724f
C66 VGND.n4 VNB 0.02384f
C67 VGND.n5 VNB 0.0264f
C68 VGND.n6 VNB 0.0099f
C69 VGND.n7 VNB 0.0132f
C70 VGND.n8 VNB 0.0132f
C71 VGND.n9 VNB 0.0264f
C72 VGND.n10 VNB 0.0264f
C73 VGND.n11 VNB 0.0264f
C74 VGND.n12 VNB 0.0132f
C75 VGND.n13 VNB 0.0132f
C76 VGND.n14 VNB 0.04123f
C77 VGND.n15 VNB 0.04237f
.ends
