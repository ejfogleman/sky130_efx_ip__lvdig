* Copyright (c) 2026 Eric Fogleman
* SPDX-License-Identifier: Apache-2.0
* Derived from SkyWater sky130_fd_sc_hd (Apache-2.0); see NOTICE
*
* sky130_efx_lvdig standard cells: layout-extracted netlist with parasitic
* capacitance, one .subckt per cell from the layouts in mag/ (generated by
* `make libspice` / `PEX=c`; don't edit): every non-zero node-to-node and
* node-to-substrate capacitance (ext2spice cthresh 0; the substrate node is
* VNB), no resistance.
* Magic on a flattened copy of each cell (every device has its own
* source/drain area and perimeter). Internal nets have Magic's coordinate
* names (a_<x>_<y>#). Ports are in the same order as cdl/sky130_efx_lvdig.cdl
* (the schematic netlist), so the netlists can be swapped in a testbench.
*
* Cell topologies and device sizes are derived from SkyWater's sky130_fd_sc_hd
* (Apache-2.0; see NOTICE). Layouts are independent.
*
* Not interchangeable with the PDK's sky130_fd_sc_hd netlists:
*  - device widths are on the efx lambda grid (L = 0.18 um; e.g. 0.42 -> 0.45,
*    0.65 -> 0.63, 1.00 -> 1.08), conb_1's resistors W 0.45 x L 0.54
*  - ports: logic pins, then VGND VNB VPB VPWR (hd: power pins in between),
*    so instantiate by the .subckt lines below, not by hd's pin order
* Devices are sky130_fd_pr models; include the PDK model library first, e.g.
*   .lib $PDK_ROOT/sky130A/libs.tech/ngspice/sky130.lib.spice tt

.subckt sky130_efx_lvdig__a21o_1 A1 A2 B1 X VGND VNB VPB VPWR
X0 nmos_n3f5_f2_l150_fnf_0.D0 A1 a_141_36# VNB sky130_fd_pr__nfet_01v8 ad=0.23625 pd=2.01 as=0.12285 ps=1.02 w=0.63 l=0.15
X1 VPWR A2 pmos_n6_f2_l150_hvt_ftf_0.S0 VPB sky130_fd_pr__pfet_01v8_hvt ad=0.2106 pd=1.47 as=0.405 ps=2.91 w=1.08 l=0.15
X2 X nmos_n3f5_f2_l150_fnf_0.D0 VGND VNB sky130_fd_pr__nfet_01v8 ad=0.23625 pd=2.01 as=0.23625 ps=2.01 w=0.63 l=0.15
X3 pmos_n6_f2_l150_hvt_ftf_0.S0 A1 VPWR VPB sky130_fd_pr__pfet_01v8_hvt ad=0.405 pd=2.91 as=0.2106 ps=1.47 w=1.08 l=0.15
X4 X nmos_n3f5_f2_l150_fnf_0.D0 VPWR VPB sky130_fd_pr__pfet_01v8_hvt ad=0.405 pd=2.91 as=0.405 ps=2.91 w=1.08 l=0.15
X5 a_141_36# A2 VGND VNB sky130_fd_pr__nfet_01v8 ad=0.12285 pd=1.02 as=0.23625 ps=2.01 w=0.63 l=0.15
X6 pmos_n6_f2_l150_hvt_ftf_0.S0 B1 nmos_n3f5_f2_l150_fnf_0.D0 VPB sky130_fd_pr__pfet_01v8_hvt ad=0.405 pd=2.91 as=0.405 ps=2.91 w=1.08 l=0.15
X7 VGND B1 nmos_n3f5_f2_l150_fnf_0.D0 VNB sky130_fd_pr__nfet_01v8 ad=0.23625 pd=2.01 as=0.23625 ps=2.01 w=0.63 l=0.15
C0 X nmos_n3f5_f2_l150_fnf_0.D0 0.10826f
C1 X VPB 0.01078f
C2 VPB nmos_n3f5_f2_l150_fnf_0.D0 0.08619f
C3 B1 pmos_n6_f2_l150_hvt_ftf_0.S0 0.0115f
C4 VGND A2 0.05267f
C5 B1 A1 0.01968f
C6 A2 nmos_n3f5_f2_l150_fnf_0.D0 0.00301f
C7 A2 VPB 0.04956f
C8 VGND pmos_n6_f2_l150_hvt_ftf_0.S0 0.01831f
C9 pmos_n6_f2_l150_hvt_ftf_0.S0 a_141_36# 0.00307f
C10 X pmos_n6_f2_l150_hvt_ftf_0.S0 0.00575f
C11 A1 VGND 0.02239f
C12 VPWR B1 0.01315f
C13 nmos_n3f5_f2_l150_fnf_0.D0 pmos_n6_f2_l150_hvt_ftf_0.S0 0.09534f
C14 VPB pmos_n6_f2_l150_hvt_ftf_0.S0 0.03277f
C15 A1 nmos_n3f5_f2_l150_fnf_0.D0 0.05417f
C16 A1 VPB 0.05339f
C17 VPWR VGND 0.07871f
C18 A2 pmos_n6_f2_l150_hvt_ftf_0.S0 0.05856f
C19 VPWR a_141_36# 0.00143f
C20 X VPWR 0.08434f
C21 A1 A2 0.06327f
C22 VPWR nmos_n3f5_f2_l150_fnf_0.D0 0.08205f
C23 VPWR VPB 0.16185f
C24 B1 VGND 0.054f
C26 A1 pmos_n6_f2_l150_hvt_ftf_0.S0 0.05856f
C27 B1 nmos_n3f5_f2_l150_fnf_0.D0 0.14331f
C28 VPWR A2 0.02169f
C29 B1 VPB 0.05944f
C30 VGND a_141_36# 0.01672f
C31 X VGND 0.10221f
C32 VPWR pmos_n6_f2_l150_hvt_ftf_0.S0 0.37233f
C33 VGND nmos_n3f5_f2_l150_fnf_0.D0 0.27376f
C34 nmos_n3f5_f2_l150_fnf_0.D0 a_141_36# 0.00657f
C35 VGND VPB 0.01447f
C36 VPWR A1 0.02241f
C37 VGND VNB 0.63677f
C38 X VNB 0.11242f
C39 VPWR VNB 0.44437f
C40 B1 VNB 0.12675f
C41 A1 VNB 0.1215f
C42 A2 VNB 0.15633f
C43 VPB VNB 1.02643f
C44 pmos_n6_f2_l150_hvt_ftf_0.S0 VNB 0.0481f
C45 nmos_n3f5_f2_l150_fnf_0.D0 VNB 0.20412f
.ends

.subckt sky130_efx_lvdig__a22o_1 A1 A2 B1 B2 X VGND VNB VPB VPWR
X0 nmos_n3f5_f2_l150_fnf_1.S0 A1 a_141_36# VNB sky130_fd_pr__nfet_01v8 ad=0.23625 pd=2.01 as=0.12285 ps=1.02 w=0.63 l=0.15
X1 X nmos_n3f5_f2_l150_fnf_1.S0 VGND VNB sky130_fd_pr__nfet_01v8 ad=0.23625 pd=2.01 as=0.23625 ps=2.01 w=0.63 l=0.15
X2 a_141_324# A2 VPWR VPB sky130_fd_pr__pfet_01v8_hvt ad=0.2106 pd=1.47 as=0.405 ps=2.91 w=1.08 l=0.15
X3 VPWR A1 a_141_324# VPB sky130_fd_pr__pfet_01v8_hvt ad=0.405 pd=2.91 as=0.2106 ps=1.47 w=1.08 l=0.15
X4 VGND B2 a_501_36# VNB sky130_fd_pr__nfet_01v8 ad=0.23625 pd=2.01 as=0.12285 ps=1.02 w=0.63 l=0.15
X5 X nmos_n3f5_f2_l150_fnf_1.S0 VPWR VPB sky130_fd_pr__pfet_01v8_hvt ad=0.405 pd=2.91 as=0.405 ps=2.91 w=1.08 l=0.15
X6 a_141_36# A2 VGND VNB sky130_fd_pr__nfet_01v8 ad=0.12285 pd=1.02 as=0.23625 ps=2.01 w=0.63 l=0.15
X7 nmos_n3f5_f2_l150_fnf_1.S0 B1 a_141_324# VPB sky130_fd_pr__pfet_01v8_hvt ad=0.2106 pd=1.47 as=0.405 ps=2.91 w=1.08 l=0.15
X8 a_141_324# B2 nmos_n3f5_f2_l150_fnf_1.S0 VPB sky130_fd_pr__pfet_01v8_hvt ad=0.405 pd=2.91 as=0.2106 ps=1.47 w=1.08 l=0.15
X9 a_501_36# B1 nmos_n3f5_f2_l150_fnf_1.S0 VNB sky130_fd_pr__nfet_01v8 ad=0.12285 pd=1.02 as=0.23625 ps=2.01 w=0.63 l=0.15
C0 A1 nmos_n3f5_f2_l150_fnf_1.S0 0.0319f
C1 X nmos_n3f5_f2_l150_fnf_1.S0 0.10829f
C3 VGND a_141_324# 0.01586f
C4 VPB a_141_324# 0.03116f
C5 VPWR a_141_324# 0.43308f
C6 B2 a_141_324# 0.01189f
C7 B1 a_141_324# 0.05315f
C8 VGND A2 0.05375f
C9 a_141_324# a_141_36# 0.00295f
C10 A1 a_141_324# 0.056f
C11 X a_141_324# 0.00612f
C12 A2 VPB 0.04956f
C13 A2 VPWR 0.06512f
C14 VGND a_501_36# 0.01034f
C15 nmos_n3f5_f2_l150_fnf_1.S0 a_141_324# 0.11281f
C16 VGND VPB 0.01785f
C18 VGND VPWR 0.09518f
C19 VPB VPWR 0.20187f
C20 A1 A2 0.06327f
C21 VGND B2 0.0531f
C22 VGND B1 0.01843f
C23 A2 nmos_n3f5_f2_l150_fnf_1.S0 0.00276f
C24 VGND a_141_36# 0.01672f
C25 VPB B2 0.05339f
C26 A1 VGND 0.02228f
C27 VGND X 0.10221f
C28 B2 VPWR 0.01229f
C29 VPB B1 0.05339f
C30 B1 VPWR 0.013f
C31 nmos_n3f5_f2_l150_fnf_1.S0 a_501_36# 0.01365f
C32 VGND nmos_n3f5_f2_l150_fnf_1.S0 0.28348f
C33 VPWR a_141_36# 0.00147f
C34 A1 VPB 0.05339f
C35 VPB X 0.01417f
C36 A1 VPWR 0.02379f
C37 X VPWR 0.08434f
C38 VPB nmos_n3f5_f2_l150_fnf_1.S0 0.08336f
C39 VPWR nmos_n3f5_f2_l150_fnf_1.S0 0.08292f
C40 B1 B2 0.04923f
C42 A1 B1 0.04604f
C44 B2 nmos_n3f5_f2_l150_fnf_1.S0 0.14147f
C45 A2 a_141_324# 0.00973f
C46 B1 nmos_n3f5_f2_l150_fnf_1.S0 0.09117f
C47 nmos_n3f5_f2_l150_fnf_1.S0 a_141_36# 0.00657f
C48 VGND VNB 0.72048f
C49 X VNB 0.10825f
C50 VPWR VNB 0.5411f
C51 B2 VNB 0.11489f
C52 B1 VNB 0.11489f
C53 A1 VNB 0.1172f
C54 A2 VNB 0.15633f
C55 VPB VNB 1.1975f
C56 a_141_324# VNB 0.00964f
C57 nmos_n3f5_f2_l150_fnf_1.S0 VNB 0.20223f
.ends

.subckt sky130_efx_lvdig__and2_1 A B X VGND VNB VPB VPWR
X0 a_141_450# A a_141_36# VNB sky130_fd_pr__nfet_01v8 ad=0.16875 pd=1.65 as=0.08775 ps=0.84 w=0.45 l=0.15
X1 a_141_450# B VPWR VPB sky130_fd_pr__pfet_01v8_hvt ad=0.08775 pd=0.84 as=0.16875 ps=1.65 w=0.45 l=0.15
X2 a_141_36# B VGND VNB sky130_fd_pr__nfet_01v8 ad=0.08775 pd=0.84 as=0.16875 ps=1.65 w=0.45 l=0.15
X3 VPWR A a_141_450# VPB sky130_fd_pr__pfet_01v8_hvt ad=0.16875 pd=1.65 as=0.08775 ps=0.84 w=0.45 l=0.15
X4 X a_141_450# VPWR VPB sky130_fd_pr__pfet_01v8_hvt ad=0.405 pd=2.91 as=0.405 ps=2.91 w=1.08 l=0.15
X5 X a_141_450# VGND VNB sky130_fd_pr__nfet_01v8 ad=0.23625 pd=2.01 as=0.23625 ps=2.01 w=0.63 l=0.15
C0 VGND VPB 0.01587f
C1 VPWR a_141_450# 0.22713f
C2 X A 0.00172f
C3 VGND B 0.04411f
C4 X a_141_450# 0.11164f
C5 X VPWR 0.08657f
C6 VGND A 0.0195f
C7 a_141_450# a_141_36# 0.00967f
C9 B VPB 0.09793f
C10 VGND a_141_450# 0.18928f
C11 VGND VPWR 0.06339f
C12 VPB A 0.10842f
C13 VGND X 0.10221f
C14 VPB a_141_450# 0.10665f
C15 B A 0.08246f
C16 VPB VPWR 0.14391f
C17 VGND a_141_36# 0.01015f
C18 B a_141_450# 0.06559f
C19 B VPWR 0.0366f
C20 VPB X 0.01538f
C21 a_141_450# A 0.19739f
C22 VPWR A 0.02484f
C23 VGND VNB 0.50841f
C24 X VNB 0.10825f
C25 VPWR VNB 0.37608f
C26 A VNB 0.13782f
C27 B VNB 0.18798f
C28 VPB VNB 0.76982f
C29 a_141_450# VNB 0.22095f
.ends

.subckt sky130_efx_lvdig__and2_2 A B X VGND VNB VPB VPWR
X0 a_141_450# A a_141_36# VNB sky130_fd_pr__nfet_01v8 ad=0.16875 pd=1.65 as=0.08775 ps=0.84 w=0.45 l=0.15
X1 VGND a_141_450# X VNB sky130_fd_pr__nfet_01v8 ad=0.23625 pd=2.01 as=0.12285 ps=1.02 w=0.63 l=0.15
X2 a_141_450# B VPWR VPB sky130_fd_pr__pfet_01v8_hvt ad=0.08775 pd=0.84 as=0.16875 ps=1.65 w=0.45 l=0.15
X3 a_141_36# B VGND VNB sky130_fd_pr__nfet_01v8 ad=0.08775 pd=0.84 as=0.16875 ps=1.65 w=0.45 l=0.15
X4 VPWR A a_141_450# VPB sky130_fd_pr__pfet_01v8_hvt ad=0.16875 pd=1.65 as=0.08775 ps=0.84 w=0.45 l=0.15
X5 X a_141_450# VPWR VPB sky130_fd_pr__pfet_01v8_hvt ad=0.2106 pd=1.47 as=0.405 ps=2.91 w=1.08 l=0.15
X6 VPWR a_141_450# X VPB sky130_fd_pr__pfet_01v8_hvt ad=0.405 pd=2.91 as=0.2106 ps=1.47 w=1.08 l=0.15
X7 X a_141_450# VGND VNB sky130_fd_pr__nfet_01v8 ad=0.12285 pd=1.02 as=0.23625 ps=2.01 w=0.63 l=0.15
C0 VGND VPB 0.01449f
C1 VPWR a_141_450# 0.25795f
C2 X A 0.00172f
C3 VGND B 0.04411f
C4 X a_141_450# 0.16072f
C5 X VPWR 0.17427f
C6 VGND A 0.01963f
C7 a_141_450# a_141_36# 0.00967f
C9 VGND a_141_450# 0.21652f
C10 B VPB 0.09793f
C11 VGND VPWR 0.0815f
C12 VGND X 0.15357f
C13 VPB A 0.10919f
C14 B A 0.08246f
C15 a_141_450# VPB 0.15106f
C16 VPWR VPB 0.15368f
C17 VGND a_141_36# 0.01015f
C18 B a_141_450# 0.06559f
C19 B VPWR 0.0366f
C20 X VPB 0.00865f
C21 a_141_450# A 0.19739f
C22 VPWR A 0.0253f
C23 VGND VNB 0.57207f
C24 X VNB 0.03806f
C25 VPWR VNB 0.44447f
C26 A VNB 0.13705f
C27 B VNB 0.18798f
C28 VPB VNB 0.85536f
C29 a_141_450# VNB 0.30918f
.ends

.subckt sky130_efx_lvdig__and2_4 A B X VGND VNB VPB VPWR
X0 VPWR nmos_n3f5_f2_l150_fnf_0.D0 X VPB sky130_fd_pr__pfet_01v8_hvt ad=0.405 pd=2.91 as=0.2106 ps=1.47 w=1.08 l=0.15
X1 nmos_n3f5_f2_l150_fnf_0.D0 A a_141_36# VNB sky130_fd_pr__nfet_01v8 ad=0.23625 pd=2.01 as=0.12285 ps=1.02 w=0.63 l=0.15
X2 nmos_n3f5_f2_l150_fnf_0.D0 B VPWR VPB sky130_fd_pr__pfet_01v8_hvt ad=0.2106 pd=1.47 as=0.405 ps=2.91 w=1.08 l=0.15
X3 VPWR A nmos_n3f5_f2_l150_fnf_0.D0 VPB sky130_fd_pr__pfet_01v8_hvt ad=0.405 pd=2.91 as=0.2106 ps=1.47 w=1.08 l=0.15
X4 X nmos_n3f5_f2_l150_fnf_0.D0 VGND VNB sky130_fd_pr__nfet_01v8 ad=0.12285 pd=1.02 as=0.12285 ps=1.02 w=0.63 l=0.15
X5 VGND nmos_n3f5_f2_l150_fnf_0.D0 X VNB sky130_fd_pr__nfet_01v8 ad=0.23625 pd=2.01 as=0.12285 ps=1.02 w=0.63 l=0.15
X6 VGND nmos_n3f5_f2_l150_fnf_0.D0 X VNB sky130_fd_pr__nfet_01v8 ad=0.12285 pd=1.02 as=0.12285 ps=1.02 w=0.63 l=0.15
X7 a_141_36# B VGND VNB sky130_fd_pr__nfet_01v8 ad=0.12285 pd=1.02 as=0.23625 ps=2.01 w=0.63 l=0.15
X8 X nmos_n3f5_f2_l150_fnf_0.D0 VPWR VPB sky130_fd_pr__pfet_01v8_hvt ad=0.2106 pd=1.47 as=0.405 ps=2.91 w=1.08 l=0.15
X9 VPWR nmos_n3f5_f2_l150_fnf_0.D0 X VPB sky130_fd_pr__pfet_01v8_hvt ad=0.2106 pd=1.47 as=0.2106 ps=1.47 w=1.08 l=0.15
X10 X nmos_n3f5_f2_l150_fnf_0.D0 VGND VNB sky130_fd_pr__nfet_01v8 ad=0.12285 pd=1.02 as=0.23625 ps=2.01 w=0.63 l=0.15
X11 X nmos_n3f5_f2_l150_fnf_0.D0 VPWR VPB sky130_fd_pr__pfet_01v8_hvt ad=0.2106 pd=1.47 as=0.2106 ps=1.47 w=1.08 l=0.15
C0 VGND VPB 0.01254f
C1 VPWR nmos_n3f5_f2_l150_fnf_0.D0 0.37571f
C3 VGND B 0.0539f
C4 X nmos_n3f5_f2_l150_fnf_0.D0 0.28553f
C5 X VPWR 0.43734f
C6 VGND A 0.01875f
C7 nmos_n3f5_f2_l150_fnf_0.D0 a_141_36# 0.01356f
C9 VGND nmos_n3f5_f2_l150_fnf_0.D0 0.2867f
C10 B VPB 0.04956f
C11 VGND VPWR 0.1038f
C12 VGND X 0.34107f
C13 VPB A 0.05339f
C14 B A 0.04923f
C15 nmos_n3f5_f2_l150_fnf_0.D0 VPB 0.2201f
C16 VPWR VPB 0.17877f
C17 VGND a_141_36# 0.01034f
C18 B nmos_n3f5_f2_l150_fnf_0.D0 0.05785f
C19 B VPWR 0.06512f
C20 X VPB 0.0153f
C21 nmos_n3f5_f2_l150_fnf_0.D0 A 0.18781f
C22 VPWR A 0.02376f
C23 VGND VNB 0.69156f
C24 X VNB 0.0492f
C25 VPWR VNB 0.54373f
C26 A VNB 0.11489f
C27 B VNB 0.15402f
C28 VPB VNB 1.11197f
C29 nmos_n3f5_f2_l150_fnf_0.D0 VNB 0.4529f
.ends

.subckt sky130_efx_lvdig__and3_1 A B C X VGND VNB VPB VPWR
X0 a_141_450# B VPWR VPB sky130_fd_pr__pfet_01v8_hvt ad=0.08775 pd=0.84 as=0.16875 ps=1.65 w=0.45 l=0.15
X1 VPWR A a_141_450# VPB sky130_fd_pr__pfet_01v8_hvt ad=0.16875 pd=1.65 as=0.08775 ps=0.84 w=0.45 l=0.15
X2 X a_141_450# VGND VNB sky130_fd_pr__nfet_01v8 ad=0.23625 pd=2.01 as=0.23625 ps=2.01 w=0.63 l=0.15
X3 X a_141_450# VPWR VPB sky130_fd_pr__pfet_01v8_hvt ad=0.405 pd=2.91 as=0.405 ps=2.91 w=1.08 l=0.15
X4 a_141_450# C VPWR VPB sky130_fd_pr__pfet_01v8_hvt ad=0.16875 pd=1.65 as=0.16875 ps=1.65 w=0.45 l=0.15
X5 a_141_36# C VGND VNB sky130_fd_pr__nfet_01v8 ad=0.16875 pd=1.65 as=0.16875 ps=1.65 w=0.45 l=0.15
X6 a_393_36# B a_141_36# VNB sky130_fd_pr__nfet_01v8 ad=0.08775 pd=0.84 as=0.16875 ps=1.65 w=0.45 l=0.15
X7 a_141_450# A a_393_36# VNB sky130_fd_pr__nfet_01v8 ad=0.16875 pd=1.65 as=0.08775 ps=0.84 w=0.45 l=0.15
C0 VPB a_141_36# 0.00167f
C1 a_141_450# a_393_36# 0.00974f
C2 X VPB 0.01121f
C3 A a_141_450# 0.19749f
C4 VGND C 0.0448f
C5 C a_141_36# 0.00406f
C6 A B 0.08246f
C7 C VPB 0.11458f
C9 VGND a_141_450# 0.17733f
C10 a_141_450# a_141_36# 0.03382f
C11 X a_141_450# 0.11164f
C12 B VGND 0.01946f
C13 VPWR A 0.02484f
C14 B a_141_36# 0.02154f
C15 VPB a_141_450# 0.14783f
C16 B VPB 0.10467f
C17 VPWR VGND 0.07949f
C18 C a_141_450# 0.01937f
C19 VPWR a_141_36# 0.00147f
C20 X VPWR 0.08657f
C21 B C 0.0414f
C22 VGND a_393_36# 0.00635f
C23 a_141_36# a_393_36# 0.00379f
C24 VPWR VPB 0.18804f
C25 A VGND 0.01753f
C26 A a_141_36# 0.0014f
C27 X A 0.00172f
C28 B a_141_450# 0.11896f
C29 VPWR C 0.03739f
C30 A VPB 0.10794f
C31 VGND a_141_36# 0.1634f
C32 X VGND 0.10221f
C33 VPWR a_141_450# 0.37677f
C34 VGND VPB 0.01692f
C35 VPWR B 0.02487f
C36 VGND VNB 0.62894f
C37 X VNB 0.11242f
C38 VPWR VNB 0.46137f
C39 A VNB 0.13831f
C40 B VNB 0.13713f
C41 C VNB 0.20711f
C42 VPB VNB 1.02643f
C43 a_141_36# VNB 0.02322f
C44 a_141_450# VNB 0.22971f
.ends

.subckt sky130_efx_lvdig__and4_2 A B C D X VGND VNB VPB VPWR
X0 a_249_36# C a_141_36# VNB sky130_fd_pr__nfet_01v8 ad=0.16875 pd=1.65 as=0.08775 ps=0.84 w=0.45 l=0.15
X1 X a_141_450# VGND VNB sky130_fd_pr__nfet_01v8 ad=0.12285 pd=1.02 as=0.23625 ps=2.01 w=0.63 l=0.15
X2 a_141_450# B VPWR VPB sky130_fd_pr__pfet_01v8_hvt ad=0.08775 pd=0.84 as=0.16875 ps=1.65 w=0.45 l=0.15
X3 VPWR A a_141_450# VPB sky130_fd_pr__pfet_01v8_hvt ad=0.16875 pd=1.65 as=0.08775 ps=0.84 w=0.45 l=0.15
X4 a_141_450# A a_501_36# VNB sky130_fd_pr__nfet_01v8 ad=0.16875 pd=1.65 as=0.08775 ps=0.84 w=0.45 l=0.15
X5 a_141_450# D VPWR VPB sky130_fd_pr__pfet_01v8_hvt ad=0.08775 pd=0.84 as=0.16875 ps=1.65 w=0.45 l=0.15
X6 X a_141_450# VPWR VPB sky130_fd_pr__pfet_01v8_hvt ad=0.2106 pd=1.47 as=0.405 ps=2.91 w=1.08 l=0.15
X7 a_141_36# D VGND VNB sky130_fd_pr__nfet_01v8 ad=0.08775 pd=0.84 as=0.16875 ps=1.65 w=0.45 l=0.15
X8 VGND a_141_450# X VNB sky130_fd_pr__nfet_01v8 ad=0.23625 pd=2.01 as=0.12285 ps=1.02 w=0.63 l=0.15
X9 VPWR a_141_450# X VPB sky130_fd_pr__pfet_01v8_hvt ad=0.405 pd=2.91 as=0.2106 ps=1.47 w=1.08 l=0.15
X10 VPWR C a_141_450# VPB sky130_fd_pr__pfet_01v8_hvt ad=0.16875 pd=1.65 as=0.08775 ps=0.84 w=0.45 l=0.15
X11 a_501_36# B a_249_36# VNB sky130_fd_pr__nfet_01v8 ad=0.08775 pd=0.84 as=0.16875 ps=1.65 w=0.45 l=0.15
C0 C a_141_450# 0.06867f
C1 X a_141_450# 0.16072f
C2 VGND a_141_36# 0.01236f
C4 VGND D 0.04393f
C5 a_141_36# a_249_36# 0.00469f
C6 D VPB 0.09793f
C7 D VPWR 0.0366f
C8 VGND a_501_36# 0.00635f
C9 a_141_450# a_141_36# 0.0019f
C10 VGND VPB 0.02051f
C12 VGND VPWR 0.11115f
C13 VPB VPWR 0.23111f
C14 D a_249_36# 0.00175f
C15 C D 0.0965f
C16 VGND A 0.01761f
C17 VGND B 0.01936f
C18 D a_141_450# 0.01619f
C19 a_249_36# a_501_36# 0.00379f
C20 VGND a_249_36# 0.14074f
C21 VPB A 0.10919f
C22 VGND X 0.15357f
C23 C VGND 0.02153f
C24 A VPWR 0.0253f
C25 VPB B 0.10467f
C26 B VPWR 0.025f
C27 a_141_450# a_501_36# 0.00974f
C29 VGND a_141_450# 0.21419f
C30 VPWR a_249_36# 0.00145f
C31 C VPB 0.10467f
C32 VPB X 0.00865f
C33 C VPWR 0.025f
C34 X VPWR 0.17427f
C35 VPB a_141_450# 0.20205f
C36 VPWR a_141_450# 0.45207f
C37 B A 0.08246f
C38 A a_249_36# 0.0014f
C39 B a_249_36# 0.02154f
C40 A X 0.00172f
C41 C B 0.05771f
C42 C a_249_36# 0.02154f
C43 A a_141_450# 0.19749f
C44 B a_141_450# 0.11782f
C45 a_141_450# a_249_36# 0.02577f
C46 VGND VNB 0.78061f
C47 X VNB 0.03806f
C48 VPWR VNB 0.58749f
C49 A VNB 0.13705f
C50 B VNB 0.1307f
C51 C VNB 0.13301f
C52 D VNB 0.19029f
C53 VPB VNB 1.28304f
C54 a_249_36# VNB 0.02119f
C55 a_141_450# VNB 0.31609f
.ends

.subckt sky130_efx_lvdig__buf_1 A X VGND VNB VPB VPWR
X0 pmos_n4f5_f1_l150_hvt_0.D0 A VPWR VPB sky130_fd_pr__pfet_01v8_hvt ad=0.30375 pd=2.37 as=0.30375 ps=2.37 w=0.81 l=0.15
X1 X pmos_n4f5_f1_l150_hvt_0.D0 VPWR VPB sky130_fd_pr__pfet_01v8_hvt ad=0.30375 pd=2.37 as=0.30375 ps=2.37 w=0.81 l=0.15
X2 pmos_n4f5_f1_l150_hvt_0.D0 A VGND VNB sky130_fd_pr__nfet_01v8 ad=0.2025 pd=1.83 as=0.2025 ps=1.83 w=0.54 l=0.15
X3 X pmos_n4f5_f1_l150_hvt_0.D0 VGND VNB sky130_fd_pr__nfet_01v8 ad=0.2025 pd=1.83 as=0.2025 ps=1.83 w=0.54 l=0.15
C0 VPWR pmos_n4f5_f1_l150_hvt_0.D0 0.20543f
C1 VGND X 0.09485f
C2 X VPB 0.01701f
C3 X pmos_n4f5_f1_l150_hvt_0.D0 0.0765f
C4 VGND A 0.04989f
C5 VPWR X 0.11669f
C6 VGND VPB 0.01397f
C7 VGND VPWR 0.05372f
C8 VGND pmos_n4f5_f1_l150_hvt_0.D0 0.17189f
C9 A VPB 0.08142f
C10 A pmos_n4f5_f1_l150_hvt_0.D0 0.07406f
C11 VPWR A 0.04838f
C12 VPWR VPB 0.12004f
C13 VPB pmos_n4f5_f1_l150_hvt_0.D0 0.11957f
C14 VGND VNB 0.42439f
C15 X VNB 0.11341f
C16 VPWR VNB 0.33045f
C17 A VNB 0.18333f
C18 VPB VNB 0.59875f
C19 pmos_n4f5_f1_l150_hvt_0.D0 VNB 0.23795f
.ends

.subckt sky130_efx_lvdig__buf_2 A X VGND VNB VPB VPWR
X0 pmos_n3f5_f1_l150_hvt_0.D0 A VPWR VPB sky130_fd_pr__pfet_01v8_hvt ad=0.23625 pd=2.01 as=0.23625 ps=2.01 w=0.63 l=0.15
X1 pmos_n3f5_f1_l150_hvt_0.D0 A VGND VNB sky130_fd_pr__nfet_01v8 ad=0.16875 pd=1.65 as=0.16875 ps=1.65 w=0.45 l=0.15
X2 X pmos_n3f5_f1_l150_hvt_0.D0 VPWR VPB sky130_fd_pr__pfet_01v8_hvt ad=0.2106 pd=1.47 as=0.405 ps=2.91 w=1.08 l=0.15
X3 VPWR pmos_n3f5_f1_l150_hvt_0.D0 X VPB sky130_fd_pr__pfet_01v8_hvt ad=0.405 pd=2.91 as=0.2106 ps=1.47 w=1.08 l=0.15
X4 X pmos_n3f5_f1_l150_hvt_0.D0 VGND VNB sky130_fd_pr__nfet_01v8 ad=0.12285 pd=1.02 as=0.23625 ps=2.01 w=0.63 l=0.15
X5 VGND pmos_n3f5_f1_l150_hvt_0.D0 X VNB sky130_fd_pr__nfet_01v8 ad=0.23625 pd=2.01 as=0.12285 ps=1.02 w=0.63 l=0.15
C0 VPWR pmos_n3f5_f1_l150_hvt_0.D0 0.23881f
C1 VGND X 0.15357f
C3 X VPB 0.00808f
C4 X pmos_n3f5_f1_l150_hvt_0.D0 0.11017f
C5 VGND A 0.04637f
C6 VPWR X 0.22627f
C7 VGND VPB 0.01756f
C8 VGND VPWR 0.08723f
C9 VGND pmos_n3f5_f1_l150_hvt_0.D0 0.19525f
C10 A VPB 0.10218f
C11 A pmos_n3f5_f1_l150_hvt_0.D0 0.09439f
C12 VPWR A 0.04391f
C13 VPWR VPB 0.15612f
C14 pmos_n3f5_f1_l150_hvt_0.D0 VPB 0.15195f
C15 VGND VNB 0.53408f
C16 X VNB 0.03639f
C17 VPWR VNB 0.42104f
C18 A VNB 0.20034f
C19 VPB VNB 0.76982f
C20 pmos_n3f5_f1_l150_hvt_0.D0 VNB 0.32719f
.ends

.subckt sky130_efx_lvdig__buf_4 A X VGND VNB VPB VPWR
X0 nmos_n3f5_f1_l150_0.D0 A VPWR VPB sky130_fd_pr__pfet_01v8_hvt ad=0.405 pd=2.91 as=0.405 ps=2.91 w=1.08 l=0.15
X1 VGND nmos_n3f5_f1_l150_0.D0 X VNB sky130_fd_pr__nfet_01v8 ad=0.23625 pd=2.01 as=0.12285 ps=1.02 w=0.63 l=0.15
X2 X nmos_n3f5_f1_l150_0.D0 VGND VNB sky130_fd_pr__nfet_01v8 ad=0.12285 pd=1.02 as=0.12285 ps=1.02 w=0.63 l=0.15
X3 nmos_n3f5_f1_l150_0.D0 A VGND VNB sky130_fd_pr__nfet_01v8 ad=0.23625 pd=2.01 as=0.23625 ps=2.01 w=0.63 l=0.15
X4 X nmos_n3f5_f1_l150_0.D0 VPWR VPB sky130_fd_pr__pfet_01v8_hvt ad=0.2106 pd=1.47 as=0.405 ps=2.91 w=1.08 l=0.15
X5 VPWR nmos_n3f5_f1_l150_0.D0 X VPB sky130_fd_pr__pfet_01v8_hvt ad=0.2106 pd=1.47 as=0.2106 ps=1.47 w=1.08 l=0.15
X6 X nmos_n3f5_f1_l150_0.D0 VPWR VPB sky130_fd_pr__pfet_01v8_hvt ad=0.2106 pd=1.47 as=0.2106 ps=1.47 w=1.08 l=0.15
X7 X nmos_n3f5_f1_l150_0.D0 VGND VNB sky130_fd_pr__nfet_01v8 ad=0.12285 pd=1.02 as=0.23625 ps=2.01 w=0.63 l=0.15
X8 VGND nmos_n3f5_f1_l150_0.D0 X VNB sky130_fd_pr__nfet_01v8 ad=0.12285 pd=1.02 as=0.12285 ps=1.02 w=0.63 l=0.15
X9 VPWR nmos_n3f5_f1_l150_0.D0 X VPB sky130_fd_pr__pfet_01v8_hvt ad=0.405 pd=2.91 as=0.2106 ps=1.47 w=1.08 l=0.15
C0 VPWR nmos_n3f5_f1_l150_0.D0 0.35976f
C1 VGND X 0.34107f
C2 X VPB 0.01594f
C3 X nmos_n3f5_f1_l150_0.D0 0.24311f
C4 VGND A 0.05517f
C5 VPWR X 0.48984f
C6 VGND VPB 0.01601f
C7 VGND VPWR 0.0988f
C8 VGND nmos_n3f5_f1_l150_0.D0 0.27844f
C9 A VPB 0.05561f
C10 A nmos_n3f5_f1_l150_0.D0 0.08133f
C11 VPWR A 0.06591f
C12 VPWR VPB 0.18657f
C13 VPB nmos_n3f5_f1_l150_0.D0 0.21827f
C14 VGND VNB 0.65469f
C15 X VNB 0.04753f
C16 VPWR VNB 0.51428f
C17 A VNB 0.16588f
C18 VPB VNB 1.02643f
C19 nmos_n3f5_f1_l150_0.D0 VNB 0.45288f
.ends

.subckt sky130_efx_lvdig__clkbuf_1 A X VGND VNB VPB VPWR
X0 pmos_n4f5_f1_l150_hvt_0.D0 A VPWR VPB sky130_fd_pr__pfet_01v8_hvt ad=0.30375 pd=2.37 as=0.30375 ps=2.37 w=0.81 l=0.15
X1 X pmos_n4f5_f1_l150_hvt_0.D0 VPWR VPB sky130_fd_pr__pfet_01v8_hvt ad=0.30375 pd=2.37 as=0.30375 ps=2.37 w=0.81 l=0.15
X2 pmos_n4f5_f1_l150_hvt_0.D0 A VGND VNB sky130_fd_pr__nfet_01v8 ad=0.2025 pd=1.83 as=0.2025 ps=1.83 w=0.54 l=0.15
X3 X pmos_n4f5_f1_l150_hvt_0.D0 VGND VNB sky130_fd_pr__nfet_01v8 ad=0.2025 pd=1.83 as=0.2025 ps=1.83 w=0.54 l=0.15
C0 VPWR pmos_n4f5_f1_l150_hvt_0.D0 0.21283f
C1 VGND X 0.09485f
C2 X VPB 0.01701f
C3 X pmos_n4f5_f1_l150_hvt_0.D0 0.08363f
C4 VGND A 0.04989f
C5 VPWR X 0.11669f
C6 VGND VPB 0.01225f
C7 VGND VPWR 0.05022f
C8 VGND pmos_n4f5_f1_l150_hvt_0.D0 0.18132f
C9 A VPB 0.08142f
C10 A pmos_n4f5_f1_l150_hvt_0.D0 0.09073f
C11 VPWR A 0.04838f
C12 VPWR VPB 0.1192f
C13 VPB pmos_n4f5_f1_l150_hvt_0.D0 0.11187f
C14 VGND VNB 0.42297f
C15 X VNB 0.11341f
C16 VPWR VNB 0.32862f
C17 A VNB 0.18389f
C18 VPB VNB 0.59875f
C19 pmos_n4f5_f1_l150_hvt_0.D0 VNB 0.22555f
.ends

.subckt sky130_efx_lvdig__clkbuf_2 A X VGND VNB VPB VPWR
X0 pmos_n6_f1_l150_hvt_0.D0 A VPWR VPB sky130_fd_pr__pfet_01v8_hvt ad=0.405 pd=2.91 as=0.405 ps=2.91 w=1.08 l=0.15
X1 pmos_n6_f1_l150_hvt_0.D0 A VGND VNB sky130_fd_pr__nfet_01v8 ad=0.16875 pd=1.65 as=0.16875 ps=1.65 w=0.45 l=0.15
X2 X pmos_n6_f1_l150_hvt_0.D0 VPWR VPB sky130_fd_pr__pfet_01v8_hvt ad=0.2106 pd=1.47 as=0.405 ps=2.91 w=1.08 l=0.15
X3 VPWR pmos_n6_f1_l150_hvt_0.D0 X VPB sky130_fd_pr__pfet_01v8_hvt ad=0.405 pd=2.91 as=0.2106 ps=1.47 w=1.08 l=0.15
X4 X pmos_n6_f1_l150_hvt_0.D0 VGND VNB sky130_fd_pr__nfet_01v8 ad=0.08775 pd=0.84 as=0.16875 ps=1.65 w=0.45 l=0.15
X5 VGND pmos_n6_f1_l150_hvt_0.D0 X VNB sky130_fd_pr__nfet_01v8 ad=0.16875 pd=1.65 as=0.08775 ps=0.84 w=0.45 l=0.15
C0 VPWR pmos_n6_f1_l150_hvt_0.D0 0.2974f
C1 VGND X 0.12436f
C2 X VPB 0.00808f
C3 X pmos_n6_f1_l150_hvt_0.D0 0.12829f
C4 VGND A 0.04557f
C5 VPWR X 0.22621f
C6 VGND VPB 0.01523f
C7 VGND VPWR 0.07646f
C8 VGND pmos_n6_f1_l150_hvt_0.D0 0.19144f
C9 A VPB 0.05561f
C10 A pmos_n6_f1_l150_hvt_0.D0 0.08603f
C11 VPWR A 0.06598f
C12 VPWR VPB 0.15293f
C13 VPB pmos_n6_f1_l150_hvt_0.D0 0.12607f
C14 VGND VNB 0.5309f
C15 X VNB 0.04762f
C16 VPWR VNB 0.4362f
C17 A VNB 0.18777f
C18 VPB VNB 0.76982f
C19 pmos_n6_f1_l150_hvt_0.D0 VNB 0.32358f
.ends

.subckt sky130_efx_lvdig__clkbuf_4 A X VGND VNB VPB VPWR
X0 nmos_n2f5_f1_l150_0.D0 A VPWR VPB sky130_fd_pr__pfet_01v8_hvt ad=0.405 pd=2.91 as=0.405 ps=2.91 w=1.08 l=0.15
X1 VGND nmos_n2f5_f1_l150_0.D0 X VNB sky130_fd_pr__nfet_01v8 ad=0.16875 pd=1.65 as=0.08775 ps=0.84 w=0.45 l=0.15
X2 X nmos_n2f5_f1_l150_0.D0 VGND VNB sky130_fd_pr__nfet_01v8 ad=0.08775 pd=0.84 as=0.08775 ps=0.84 w=0.45 l=0.15
X3 nmos_n2f5_f1_l150_0.D0 A VGND VNB sky130_fd_pr__nfet_01v8 ad=0.16875 pd=1.65 as=0.16875 ps=1.65 w=0.45 l=0.15
X4 X nmos_n2f5_f1_l150_0.D0 VPWR VPB sky130_fd_pr__pfet_01v8_hvt ad=0.2106 pd=1.47 as=0.405 ps=2.91 w=1.08 l=0.15
X5 VPWR nmos_n2f5_f1_l150_0.D0 X VPB sky130_fd_pr__pfet_01v8_hvt ad=0.2106 pd=1.47 as=0.2106 ps=1.47 w=1.08 l=0.15
X6 X nmos_n2f5_f1_l150_0.D0 VPWR VPB sky130_fd_pr__pfet_01v8_hvt ad=0.2106 pd=1.47 as=0.2106 ps=1.47 w=1.08 l=0.15
X7 X nmos_n2f5_f1_l150_0.D0 VGND VNB sky130_fd_pr__nfet_01v8 ad=0.08775 pd=0.84 as=0.16875 ps=1.65 w=0.45 l=0.15
X8 VGND nmos_n2f5_f1_l150_0.D0 X VNB sky130_fd_pr__nfet_01v8 ad=0.08775 pd=0.84 as=0.08775 ps=0.84 w=0.45 l=0.15
X9 VPWR nmos_n2f5_f1_l150_0.D0 X VPB sky130_fd_pr__pfet_01v8_hvt ad=0.405 pd=2.91 as=0.2106 ps=1.47 w=1.08 l=0.15
C0 VPWR nmos_n2f5_f1_l150_0.D0 0.35995f
C1 VGND X 0.27569f
C2 X VPB 0.01594f
C3 X nmos_n2f5_f1_l150_0.D0 0.258f
C4 VGND A 0.04557f
C5 VPWR X 0.48974f
C6 VGND VPB 0.0159f
C7 VGND VPWR 0.09609f
C8 VGND nmos_n2f5_f1_l150_0.D0 0.23943f
C9 A VPB 0.05561f
C10 A nmos_n2f5_f1_l150_0.D0 0.08603f
C11 VPWR A 0.06598f
C12 VPWR VPB 0.18657f
C13 VPB nmos_n2f5_f1_l150_0.D0 0.21827f
C14 VGND VNB 0.64977f
C15 X VNB 0.06461f
C16 VPWR VNB 0.51679f
C17 A VNB 0.18777f
C18 VPB VNB 1.02643f
C19 nmos_n2f5_f1_l150_0.D0 VNB 0.52005f
.ends

.subckt sky130_efx_lvdig__clkbuf_8 A X VGND VNB VPB VPWR
X0 VPWR nmos_n2f5_f1_l150_0.D0 X VPB sky130_fd_pr__pfet_01v8_hvt ad=0.2106 pd=1.47 as=0.2106 ps=1.47 w=1.08 l=0.15
X1 VGND A nmos_n2f5_f1_l150_0.D0 VNB sky130_fd_pr__nfet_01v8 ad=0.16875 pd=1.65 as=0.08775 ps=0.84 w=0.45 l=0.15
X2 nmos_n2f5_f1_l150_0.D0 A VPWR VPB sky130_fd_pr__pfet_01v8_hvt ad=0.2106 pd=1.47 as=0.405 ps=2.91 w=1.08 l=0.15
X3 VGND nmos_n2f5_f1_l150_0.D0 X VNB sky130_fd_pr__nfet_01v8 ad=0.08775 pd=0.84 as=0.08775 ps=0.84 w=0.45 l=0.15
X4 VPWR A nmos_n2f5_f1_l150_0.D0 VPB sky130_fd_pr__pfet_01v8_hvt ad=0.405 pd=2.91 as=0.2106 ps=1.47 w=1.08 l=0.15
X5 X nmos_n2f5_f1_l150_0.D0 VGND VNB sky130_fd_pr__nfet_01v8 ad=0.08775 pd=0.84 as=0.08775 ps=0.84 w=0.45 l=0.15
X6 X nmos_n2f5_f1_l150_0.D0 VGND VNB sky130_fd_pr__nfet_01v8 ad=0.08775 pd=0.84 as=0.08775 ps=0.84 w=0.45 l=0.15
X7 VGND nmos_n2f5_f1_l150_0.D0 X VNB sky130_fd_pr__nfet_01v8 ad=0.08775 pd=0.84 as=0.08775 ps=0.84 w=0.45 l=0.15
X8 VGND nmos_n2f5_f1_l150_0.D0 X VNB sky130_fd_pr__nfet_01v8 ad=0.08775 pd=0.84 as=0.08775 ps=0.84 w=0.45 l=0.15
X9 X nmos_n2f5_f1_l150_0.D0 VPWR VPB sky130_fd_pr__pfet_01v8_hvt ad=0.2106 pd=1.47 as=0.2106 ps=1.47 w=1.08 l=0.15
X10 VPWR nmos_n2f5_f1_l150_0.D0 X VPB sky130_fd_pr__pfet_01v8_hvt ad=0.2106 pd=1.47 as=0.2106 ps=1.47 w=1.08 l=0.15
X11 nmos_n2f5_f1_l150_0.D0 A VGND VNB sky130_fd_pr__nfet_01v8 ad=0.08775 pd=0.84 as=0.16875 ps=1.65 w=0.45 l=0.15
X12 X nmos_n2f5_f1_l150_0.D0 VGND VNB sky130_fd_pr__nfet_01v8 ad=0.08775 pd=0.84 as=0.08775 ps=0.84 w=0.45 l=0.15
X13 VGND nmos_n2f5_f1_l150_0.D0 X VNB sky130_fd_pr__nfet_01v8 ad=0.16875 pd=1.65 as=0.08775 ps=0.84 w=0.45 l=0.15
X14 X nmos_n2f5_f1_l150_0.D0 VPWR VPB sky130_fd_pr__pfet_01v8_hvt ad=0.2106 pd=1.47 as=0.2106 ps=1.47 w=1.08 l=0.15
X15 X nmos_n2f5_f1_l150_0.D0 VPWR VPB sky130_fd_pr__pfet_01v8_hvt ad=0.2106 pd=1.47 as=0.405 ps=2.91 w=1.08 l=0.15
X16 VPWR nmos_n2f5_f1_l150_0.D0 X VPB sky130_fd_pr__pfet_01v8_hvt ad=0.405 pd=2.91 as=0.2106 ps=1.47 w=1.08 l=0.15
X17 VPWR nmos_n2f5_f1_l150_0.D0 X VPB sky130_fd_pr__pfet_01v8_hvt ad=0.2106 pd=1.47 as=0.2106 ps=1.47 w=1.08 l=0.15
X18 X nmos_n2f5_f1_l150_0.D0 VGND VNB sky130_fd_pr__nfet_01v8 ad=0.08775 pd=0.84 as=0.16875 ps=1.65 w=0.45 l=0.15
X19 X nmos_n2f5_f1_l150_0.D0 VPWR VPB sky130_fd_pr__pfet_01v8_hvt ad=0.2106 pd=1.47 as=0.2106 ps=1.47 w=1.08 l=0.15
C0 VPWR nmos_n2f5_f1_l150_0.D0 0.55102f
C1 VGND X 0.57834f
C3 X VPB 0.03202f
C4 X nmos_n2f5_f1_l150_0.D0 0.51213f
C5 VGND A 0.06874f
C6 VPWR X 1.01681f
C7 VGND VPB 0.01485f
C8 VGND VPWR 0.14178f
C9 VGND nmos_n2f5_f1_l150_0.D0 0.37117f
C10 A VPB 0.10171f
C11 A nmos_n2f5_f1_l150_0.D0 0.15466f
C12 VPWR A 0.09501f
C13 VPWR VPB 0.26249f
C14 VPB nmos_n2f5_f1_l150_0.D0 0.39577f
C15 VGND VNB 0.92512f
C16 X VNB 0.10103f
C17 VPWR VNB 0.70358f
C18 A VNB 0.28601f
C19 VPB VNB 1.62518f
C20 nmos_n2f5_f1_l150_0.D0 VNB 0.91647f
.ends

.subckt sky130_efx_lvdig__clkdlybuf4s50_1 A X VGND VNB VPB VPWR
X0 a_141_36# A VPWR VPB sky130_fd_pr__pfet_01v8_hvt ad=0.405 pd=2.91 as=0.405 ps=2.91 w=1.08 l=0.15
X1 X a_788_36# VGND VNB sky130_fd_pr__nfet_01v8 ad=0.16875 pd=1.65 as=0.16875 ps=1.65 w=0.45 l=0.15
X2 a_788_36# a_464_36# VGND VNB sky130_fd_pr__nfet_01v8 ad=0.2394 pd=2.02 as=0.2394 ps=2.02 w=0.63 l=0.5
X3 X a_788_36# VPWR VPB sky130_fd_pr__pfet_01v8_hvt ad=0.405 pd=2.91 as=0.405 ps=2.91 w=1.08 l=0.15
X4 a_141_36# A VGND VNB sky130_fd_pr__nfet_01v8 ad=0.16875 pd=1.65 as=0.16875 ps=1.65 w=0.45 l=0.15
X5 a_464_36# a_141_36# VPWR VPB sky130_fd_pr__pfet_01v8_hvt ad=0.3078 pd=2.38 as=0.3078 ps=2.38 w=0.81 l=0.5
X6 a_464_36# a_141_36# VGND VNB sky130_fd_pr__nfet_01v8 ad=0.2394 pd=2.02 as=0.2394 ps=2.02 w=0.63 l=0.5
X7 a_788_36# a_464_36# VPWR VPB sky130_fd_pr__pfet_01v8_hvt ad=0.3078 pd=2.38 as=0.3078 ps=2.38 w=0.81 l=0.5
C0 VPWR a_788_36# 0.21019f
C1 VPWR a_141_36# 0.28685f
C2 VPB a_464_36# 0.15449f
C3 X a_788_36# 0.07683f
C4 VGND VPB 0.02028f
C5 X VPWR 0.13854f
C7 a_464_36# a_788_36# 0.12043f
C8 VGND A 0.04596f
C9 VGND a_788_36# 0.15333f
C10 a_141_36# a_464_36# 0.12415f
C11 VPWR a_464_36# 0.23145f
C12 VGND a_141_36# 0.23325f
C13 VGND VPWR 0.11658f
C15 VGND X 0.08761f
C16 VPB A 0.05563f
C17 VPB a_788_36# 0.08476f
C18 VGND a_464_36# 0.2214f
C19 VPB a_141_36# 0.14802f
C20 VPB VPWR 0.25551f
C22 a_141_36# A 0.08296f
C23 VPB X 0.01018f
C25 VPWR A 0.06592f
C26 VGND VNB 0.79617f
C27 X VNB 0.11582f
C28 VPWR VNB 0.58791f
C29 A VNB 0.18914f
C30 VPB VNB 1.36858f
C31 a_788_36# VNB 0.20691f
C32 a_464_36# VNB 0.22168f
C33 a_141_36# VNB 0.24337f
.ends

.subckt sky130_efx_lvdig__clkinv_1 A Y VGND VNB VPB VPWR
X0 Y A VPWR VPB sky130_fd_pr__pfet_01v8_hvt ad=0.15795 pd=1.2 as=0.30375 ps=2.37 w=0.81 l=0.15
X1 VPWR A Y VPB sky130_fd_pr__pfet_01v8_hvt ad=0.30375 pd=2.37 as=0.15795 ps=1.2 w=0.81 l=0.15
X2 Y A VGND VNB sky130_fd_pr__nfet_01v8 ad=0.16875 pd=1.65 as=0.16875 ps=1.65 w=0.45 l=0.15
C0 VGND A 0.05057f
C1 Y VPB 0.01586f
C2 VPWR VPB 0.08051f
C3 Y VPWR 0.18243f
C4 A VPB 0.13829f
C5 Y A 0.10592f
C6 VGND VPB 0.01034f
C7 VGND Y 0.08768f
C8 VPWR A 0.07453f
C9 VGND VPWR 0.04265f
C10 VGND VNB 0.34264f
C11 Y VNB 0.09942f
C12 VPWR VNB 0.3126f
C13 A VNB 0.28405f
C14 VPB VNB 0.42768f
.ends

.subckt sky130_efx_lvdig__clkinv_2 A Y VGND VNB VPB VPWR
X0 VGND A Y VNB sky130_fd_pr__nfet_01v8 ad=0.16875 pd=1.65 as=0.08775 ps=0.84 w=0.45 l=0.15
X1 Y A VPWR VPB sky130_fd_pr__pfet_01v8_hvt ad=0.2106 pd=1.47 as=0.405 ps=2.91 w=1.08 l=0.15
X2 VPWR A Y VPB sky130_fd_pr__pfet_01v8_hvt ad=0.2106 pd=1.47 as=0.2106 ps=1.47 w=1.08 l=0.15
X3 Y A VPWR VPB sky130_fd_pr__pfet_01v8_hvt ad=0.405 pd=2.91 as=0.2106 ps=1.47 w=1.08 l=0.15
X4 Y A VGND VNB sky130_fd_pr__nfet_01v8 ad=0.08775 pd=0.84 as=0.16875 ps=1.65 w=0.45 l=0.15
C0 VGND A 0.07387f
C1 Y VPB 0.02176f
C2 VPWR VPB 0.10048f
C3 Y VPWR 0.40078f
C4 A VPB 0.14568f
C5 Y A 0.16914f
C6 VGND VPB 0.0105f
C7 VGND Y 0.16327f
C8 VPWR A 0.12664f
C9 VGND VPWR 0.05128f
C10 VGND VNB 0.44592f
C11 Y VNB 0.121f
C12 VPWR VNB 0.34061f
C13 A VNB 0.367f
C14 VPB VNB 0.59875f
.ends

.subckt sky130_efx_lvdig__clkinv_4 A Y VGND VNB VPB VPWR
X0 VGND A Y VNB sky130_fd_pr__nfet_01v8 ad=0.08775 pd=0.84 as=0.08775 ps=0.84 w=0.45 l=0.15
X1 Y A VGND VNB sky130_fd_pr__nfet_01v8 ad=0.08775 pd=0.84 as=0.08775 ps=0.84 w=0.45 l=0.15
X2 VGND A Y VNB sky130_fd_pr__nfet_01v8 ad=0.16875 pd=1.65 as=0.08775 ps=0.84 w=0.45 l=0.15
X3 Y A VPWR VPB sky130_fd_pr__pfet_01v8_hvt ad=0.2106 pd=1.47 as=0.405 ps=2.91 w=1.08 l=0.15
X4 VPWR A Y VPB sky130_fd_pr__pfet_01v8_hvt ad=0.2106 pd=1.47 as=0.2106 ps=1.47 w=1.08 l=0.15
X5 Y A VPWR VPB sky130_fd_pr__pfet_01v8_hvt ad=0.2106 pd=1.47 as=0.2106 ps=1.47 w=1.08 l=0.15
X6 VPWR A Y VPB sky130_fd_pr__pfet_01v8_hvt ad=0.2106 pd=1.47 as=0.2106 ps=1.47 w=1.08 l=0.15
X7 Y A VPWR VPB sky130_fd_pr__pfet_01v8_hvt ad=0.2106 pd=1.47 as=0.2106 ps=1.47 w=1.08 l=0.15
X8 Y A VGND VNB sky130_fd_pr__nfet_01v8 ad=0.08775 pd=0.84 as=0.16875 ps=1.65 w=0.45 l=0.15
X9 VPWR A Y VPB sky130_fd_pr__pfet_01v8_hvt ad=0.405 pd=2.91 as=0.2106 ps=1.47 w=1.08 l=0.15
C0 VGND A 0.12756f
C1 Y VPB 0.02289f
C2 VPWR VPB 0.14389f
C3 Y VPWR 0.75192f
C4 A VPB 0.28229f
C5 Y A 0.3313f
C6 VGND VPB 0.00938f
C7 VGND Y 0.31478f
C8 VPWR A 0.21866f
C9 VGND VPWR 0.08396f
C10 VGND VNB 0.61384f
C11 Y VNB 0.09422f
C12 VPWR VNB 0.49588f
C13 A VNB 0.62263f
C14 VPB VNB 0.9409f
.ends

.subckt sky130_efx_lvdig__clkinv_8 A Y VGND VNB VPB VPWR
X0 Y A VGND VNB sky130_fd_pr__nfet_01v8 ad=0.08775 pd=0.84 as=0.08775 ps=0.84 w=0.45 l=0.15
X1 VGND A Y VNB sky130_fd_pr__nfet_01v8 ad=0.08775 pd=0.84 as=0.08775 ps=0.84 w=0.45 l=0.15
X2 VGND A Y VNB sky130_fd_pr__nfet_01v8 ad=0.08775 pd=0.84 as=0.08775 ps=0.84 w=0.45 l=0.15
X3 Y A VGND VNB sky130_fd_pr__nfet_01v8 ad=0.08775 pd=0.84 as=0.08775 ps=0.84 w=0.45 l=0.15
X4 VGND A Y VNB sky130_fd_pr__nfet_01v8 ad=0.08775 pd=0.84 as=0.08775 ps=0.84 w=0.45 l=0.15
X5 VPWR A Y VPB sky130_fd_pr__pfet_01v8_hvt ad=0.2106 pd=1.47 as=0.2106 ps=1.47 w=1.08 l=0.15
X6 Y A VPWR VPB sky130_fd_pr__pfet_01v8_hvt ad=0.2106 pd=1.47 as=0.405 ps=2.91 w=1.08 l=0.15
X7 Y A VPWR VPB sky130_fd_pr__pfet_01v8_hvt ad=0.2106 pd=1.47 as=0.2106 ps=1.47 w=1.08 l=0.15
X8 VPWR A Y VPB sky130_fd_pr__pfet_01v8_hvt ad=0.2106 pd=1.47 as=0.2106 ps=1.47 w=1.08 l=0.15
X9 VPWR A Y VPB sky130_fd_pr__pfet_01v8_hvt ad=0.405 pd=2.91 as=0.2106 ps=1.47 w=1.08 l=0.15
X10 Y A VPWR VPB sky130_fd_pr__pfet_01v8_hvt ad=0.2106 pd=1.47 as=0.2106 ps=1.47 w=1.08 l=0.15
X11 VPWR A Y VPB sky130_fd_pr__pfet_01v8_hvt ad=0.2106 pd=1.47 as=0.2106 ps=1.47 w=1.08 l=0.15
X12 Y A VGND VNB sky130_fd_pr__nfet_01v8 ad=0.08775 pd=0.84 as=0.08775 ps=0.84 w=0.45 l=0.15
X13 VGND A Y VNB sky130_fd_pr__nfet_01v8 ad=0.16875 pd=1.65 as=0.08775 ps=0.84 w=0.45 l=0.15
X14 Y A VPWR VPB sky130_fd_pr__pfet_01v8_hvt ad=0.2106 pd=1.47 as=0.2106 ps=1.47 w=1.08 l=0.15
X15 Y A VGND VNB sky130_fd_pr__nfet_01v8 ad=0.08775 pd=0.84 as=0.16875 ps=1.65 w=0.45 l=0.15
X16 VPWR A Y VPB sky130_fd_pr__pfet_01v8_hvt ad=0.2106 pd=1.47 as=0.2106 ps=1.47 w=1.08 l=0.15
X17 Y A VPWR VPB sky130_fd_pr__pfet_01v8_hvt ad=0.2106 pd=1.47 as=0.2106 ps=1.47 w=1.08 l=0.15
X18 VPWR A Y VPB sky130_fd_pr__pfet_01v8_hvt ad=0.2106 pd=1.47 as=0.2106 ps=1.47 w=1.08 l=0.15
X19 Y A VPWR VPB sky130_fd_pr__pfet_01v8_hvt ad=0.2106 pd=1.47 as=0.2106 ps=1.47 w=1.08 l=0.15
C0 VGND Y 0.6489f
C1 Y A 0.67362f
C2 Y VPB 0.04648f
C3 VPWR Y 1.54119f
C4 VGND A 0.23015f
C5 VGND VPB 0.01141f
C6 VGND VPWR 0.14227f
C7 A VPB 0.5589f
C8 VPWR A 0.40455f
C9 VPWR VPB 0.24483f
C10 VGND VNB 0.99473f
C11 Y VNB 0.14706f
C12 VPWR VNB 0.7425f
C13 A VNB 1.1305f
C14 VPB VNB 1.71072f
.ends

.subckt sky130_efx_lvdig__conb_1 HI LO VGND VNB VPB VPWR
X0 LO VGND sky130_fd_pr__res_generic_po w=0.45 l=0.54
X1 VPWR HI sky130_fd_pr__res_generic_po w=0.45 l=0.54
C0 LO HI 0.03836f
C1 HI VPB 0.04337f
C2 HI VGND 0.00121f
C3 VPWR HI 0.01662f
C4 LO VPB 0.00575f
C5 LO VGND 0.01662f
C6 LO VPWR 0.00121f
C7 VPB VGND 0.01152f
C8 VPWR VPB 0.09955f
C9 VPWR VGND 0.0242f
C10 VGND VNB 0.34028f
C11 LO VNB 0.09623f
C12 HI VNB 0.0586f
C13 VPWR VNB 0.25225f
C14 VPB VNB 0.25661f
.ends

.subckt sky130_efx_lvdig__decap10 VGND VNB VPB VPWR
X0 VPWR VGND VPWR VPB sky130_fd_pr__pfet_01v8_hvt ad=0.324 pd=2.52 as=0.648 ps=5.04 w=0.9 l=0.72
X1 VGND VPWR VGND VNB sky130_fd_pr__nfet_01v8 ad=0.2268 pd=1.98 as=0.4536 ps=3.96 w=0.63 l=0.72
C0 VPB VPWR 0.09704f
C1 VPB VGND 0.12613f
C2 VGND VPWR 0.42724f
C3 VPWR VNB 0.55522f
C4 VGND VNB 0.50734f
C5 VPB VNB 0.42768f
.ends

.subckt sky130_efx_lvdig__decap20 VGND VNB VPB VPWR
X0 VPWR VGND VPWR VPB sky130_fd_pr__pfet_01v8_hvt ad=0.324 pd=2.52 as=0.648 ps=5.04 w=0.9 l=2.52
X1 VGND VPWR VGND VNB sky130_fd_pr__nfet_01v8 ad=0.2268 pd=1.98 as=0.4536 ps=3.96 w=0.63 l=2.52
C0 VPB VPWR 0.13934f
C1 VPB VGND 0.26411f
C2 VGND VPWR 0.97973f
C3 VPWR VNB 0.89151f
C4 VGND VNB 0.74864f
C5 VPB VNB 0.85536f
.ends

.subckt sky130_efx_lvdig__dfbbp_1 CLK D RESET_B SET_B Q Q_N VGND VNB VPB VPWR
X0 a_3093_378# a_2229_36# a_2583_327# VPB sky130_fd_pr__pfet_01v8_hvt ad=0.15795 pd=1.2 as=0.13725 ps=1.2 w=0.81 l=0.15
X1 a_3813_36# a_2583_327# VGND VNB sky130_fd_pr__nfet_01v8 ad=0.16875 pd=1.65 as=0.16875 ps=1.65 w=0.45 l=0.15
X2 Q a_3813_36# VPWR VPB sky130_fd_pr__pfet_01v8_hvt ad=0.405 pd=2.91 as=0.405 ps=2.91 w=1.08 l=0.15
X3 a_1509_378# a_1296_440# VPWR VPB sky130_fd_pr__pfet_01v8_hvt ad=0.15795 pd=1.2 as=0.30375 ps=2.37 w=0.81 l=0.15
X4 VPWR a_1296_440# a_3093_378# VPB sky130_fd_pr__pfet_01v8_hvt ad=0.30375 pd=2.37 as=0.15795 ps=1.2 w=0.81 l=0.15
X5 Q_N a_2583_327# VPWR VPB sky130_fd_pr__pfet_01v8_hvt ad=0.405 pd=2.91 as=0.405 ps=2.91 w=1.08 l=0.15
X6 a_969_450# a_141_36# a_753_36# VPB sky130_fd_pr__pfet_01v8_hvt ad=0.16875 pd=1.2 as=0.20925 ps=1.38 w=0.45 l=0.15
X7 VPWR a_1088_165# a_969_450# VPB sky130_fd_pr__pfet_01v8_hvt ad=0.16875 pd=1.65 as=0.16875 ps=1.2 w=0.45 l=0.15
X8 a_2985_36# SET_B VGND VNB sky130_fd_pr__nfet_01v8 ad=0.1125 pd=1.02 as=0.16875 ps=1.65 w=0.45 l=0.15
X9 a_141_36# CLK VPWR VPB sky130_fd_pr__pfet_01v8_hvt ad=0.23625 pd=2.01 as=0.23625 ps=2.01 w=0.63 l=0.15
X10 a_1088_165# a_753_36# a_1509_378# VPB sky130_fd_pr__pfet_01v8_hvt ad=0.13725 pd=1.2 as=0.15795 ps=1.2 w=0.81 l=0.15
X11 a_645_36# D VGND VNB sky130_fd_pr__nfet_01v8 ad=0.08258 pd=0.84 as=0.16875 ps=1.65 w=0.45 l=0.15
X12 a_753_36# a_141_36# a_645_36# VNB sky130_fd_pr__special_nfet_01v8 ad=0.1674 pd=1.29 as=0.08258 ps=0.84 w=0.36 l=0.15
X13 a_2445_450# a_393_36# a_2229_36# VPB sky130_fd_pr__pfet_01v8_hvt ad=0.16875 pd=1.2 as=0.20925 ps=1.38 w=0.45 l=0.15
X14 a_2583_327# a_2229_36# a_2985_36# VNB sky130_fd_pr__nfet_01v8 ad=0.12285 pd=1.02 as=0.1125 ps=1.02 w=0.63 l=0.15
X15 a_2985_36# a_1296_440# a_2583_327# VNB sky130_fd_pr__nfet_01v8 ad=0.23625 pd=2.01 as=0.12285 ps=1.02 w=0.63 l=0.15
X16 a_2085_36# a_1088_165# VGND VNB sky130_fd_pr__nfet_01v8 ad=0.13972 pd=1.2 as=0.23625 ps=2.01 w=0.63 l=0.15
X17 Q a_3813_36# VGND VNB sky130_fd_pr__nfet_01v8 ad=0.23625 pd=2.01 as=0.23625 ps=2.01 w=0.63 l=0.15
X18 a_1296_440# RESET_B VPWR VPB sky130_fd_pr__pfet_01v8_hvt ad=0.23625 pd=2.01 as=0.23625 ps=2.01 w=0.63 l=0.15
X19 a_3813_36# a_2583_327# VPWR VPB sky130_fd_pr__pfet_01v8_hvt ad=0.23625 pd=2.01 as=0.23625 ps=2.01 w=0.63 l=0.15
X20 a_141_36# CLK VGND VNB sky130_fd_pr__nfet_01v8 ad=0.16875 pd=1.65 as=0.16875 ps=1.65 w=0.45 l=0.15
X21 a_393_36# a_141_36# VPWR VPB sky130_fd_pr__pfet_01v8_hvt ad=0.23625 pd=2.01 as=0.23625 ps=2.01 w=0.63 l=0.15
X22 a_969_36# a_393_36# a_753_36# VNB sky130_fd_pr__special_nfet_01v8 ad=0.15593 pd=1.2 as=0.1674 ps=1.29 w=0.36 l=0.15
X23 VGND a_1088_165# a_969_36# VNB sky130_fd_pr__nfet_01v8 ad=0.16875 pd=1.65 as=0.15593 ps=1.2 w=0.45 l=0.15
X24 Q_N a_2583_327# VGND VNB sky130_fd_pr__nfet_01v8 ad=0.23625 pd=2.01 as=0.23625 ps=2.01 w=0.63 l=0.15
X25 a_2583_327# SET_B VPWR VPB sky130_fd_pr__pfet_01v8_hvt ad=0.13725 pd=1.2 as=0.16875 ps=1.65 w=0.45 l=0.15
X26 a_2445_36# a_141_36# a_2229_36# VNB sky130_fd_pr__special_nfet_01v8 ad=0.15593 pd=1.2 as=0.1674 ps=1.29 w=0.36 l=0.15
X27 a_645_36# D VPWR VPB sky130_fd_pr__pfet_01v8_hvt ad=0.08775 pd=0.84 as=0.16875 ps=1.65 w=0.45 l=0.15
X28 a_2229_36# a_393_36# a_2085_36# VNB sky130_fd_pr__special_nfet_01v8 ad=0.1674 pd=1.29 as=0.13972 ps=1.2 w=0.36 l=0.15
X29 a_1296_440# RESET_B VGND VNB sky130_fd_pr__nfet_01v8 ad=0.16875 pd=1.65 as=0.16875 ps=1.65 w=0.45 l=0.15
X30 a_2085_378# a_1088_165# VPWR VPB sky130_fd_pr__pfet_01v8_hvt ad=0.17775 pd=1.38 as=0.30375 ps=2.37 w=0.81 l=0.15
X31 a_2229_36# a_141_36# a_2085_378# VPB sky130_fd_pr__pfet_01v8_hvt ad=0.20925 pd=1.38 as=0.17775 ps=1.38 w=0.45 l=0.15
X32 VPWR SET_B a_1088_165# VPB sky130_fd_pr__pfet_01v8_hvt ad=0.16875 pd=1.65 as=0.13725 ps=1.2 w=0.45 l=0.15
X33 a_753_36# a_393_36# a_645_36# VPB sky130_fd_pr__pfet_01v8_hvt ad=0.20925 pd=1.38 as=0.08775 ps=0.84 w=0.45 l=0.15
X34 a_393_36# a_141_36# VGND VNB sky130_fd_pr__nfet_01v8 ad=0.16875 pd=1.65 as=0.16875 ps=1.65 w=0.45 l=0.15
X35 VGND a_2583_327# a_2445_36# VNB sky130_fd_pr__nfet_01v8 ad=0.16875 pd=1.65 as=0.15593 ps=1.2 w=0.45 l=0.15
X36 VPWR a_2583_327# a_2445_450# VPB sky130_fd_pr__pfet_01v8_hvt ad=0.16875 pd=1.65 as=0.16875 ps=1.2 w=0.45 l=0.15
X37 VGND SET_B a_1404_36# VNB sky130_fd_pr__nfet_01v8 ad=0.16875 pd=1.65 as=0.1125 ps=1.02 w=0.45 l=0.15
X38 a_1088_165# a_1296_440# a_1404_36# VNB sky130_fd_pr__nfet_01v8 ad=0.12285 pd=1.02 as=0.23625 ps=2.01 w=0.63 l=0.15
X39 a_1404_36# a_753_36# a_1088_165# VNB sky130_fd_pr__nfet_01v8 ad=0.1125 pd=1.02 as=0.12285 ps=1.02 w=0.63 l=0.15
C0 a_141_36# a_2085_378# 0.00142f
C1 a_1296_440# a_3813_36# 0.05657f
C2 RESET_B a_3813_36# 0.02006f
C4 CLK VPWR 0.04196f
C5 a_393_36# a_1296_440# 0.15009f
C6 Q a_1296_440# 0.07018f
C7 VGND SET_B 0.8464f
C8 RESET_B Q 0.02636f
C9 VPWR a_1296_440# 2.12377f
C10 a_753_36# a_645_36# 0.04498f
C11 RESET_B VPWR 0.03681f
C12 VPB a_645_36# 0.02422f
C13 a_1088_165# a_393_36# 0.23034f
C14 a_969_450# VPWR 0.0225f
C15 a_2583_327# a_2229_36# 0.29498f
C16 a_1088_165# VPWR 0.18626f
C17 a_753_36# a_1404_36# 0.00743f
C18 Q_N a_3813_36# 0.03531f
C19 VGND CLK 0.04537f
C20 a_393_36# a_2445_450# 0.00194f
C22 VPWR a_2445_450# 0.01954f
C23 SET_B a_2085_36# 0.00704f
C24 VGND a_1296_440# 0.24203f
C25 VGND RESET_B 0.0448f
C26 Q_N VPWR 0.15785f
C27 a_2583_327# VPB 0.41812f
C29 VGND a_1088_165# 0.21204f
C30 a_2229_36# VPB 0.10094f
C31 Q a_3813_36# 0.07073f
C32 VPWR a_3813_36# 0.21175f
C33 a_2583_327# a_2985_36# 0.12366f
C34 a_2229_36# a_2985_36# 0.02607f
C37 a_2229_36# a_2085_378# 0.00444f
C38 a_393_36# VPWR 0.16715f
C39 Q VPWR 0.15785f
C40 a_141_36# SET_B 0.15438f
C41 Q_N VGND 0.12455f
C42 VPB a_753_36# 0.12152f
C43 a_1404_36# a_969_36# 0.00145f
C45 VGND a_3813_36# 0.18409f
C46 a_1296_440# a_1509_378# 0.00855f
C47 VPB a_2985_36# 0.00284f
C48 a_141_36# CLK 0.09924f
C49 SET_B a_2445_36# 0.00867f
C50 VGND a_393_36# 0.52984f
C51 VGND Q 0.12455f
C52 a_1088_165# a_1509_378# 0.00792f
C53 a_141_36# a_1296_440# 0.21673f
C54 VGND VPWR 0.06538f
C56 a_141_36# a_969_450# 0.0071f
C57 a_141_36# a_1088_165# 0.15711f
C58 D a_393_36# 0.09861f
C59 SET_B a_1404_36# 0.01628f
C60 D VPWR 0.03564f
C61 a_753_36# a_969_36# 0.00965f
C62 a_393_36# a_2085_36# 0.00205f
C65 VPWR a_2085_36# 0.00101f
C66 a_2583_327# a_3093_378# 0.01673f
C68 a_2583_327# SET_B 0.0809f
C69 a_2229_36# SET_B 0.16378f
C73 VPWR a_1509_378# 0.01233f
C74 a_1404_36# a_1296_440# 0.00639f
C75 VGND D 0.03533f
C76 a_141_36# a_393_36# 1.38935f
C78 a_141_36# VPWR 0.51667f
C79 a_1088_165# a_1404_36# 0.16334f
C80 VGND a_2085_36# 0.01561f
C81 a_753_36# SET_B 0.06169f
C82 VPB SET_B 0.24074f
C83 a_2583_327# a_1296_440# 0.22138f
C84 a_2583_327# RESET_B 0.00425f
C85 a_2229_36# a_1296_440# 0.12291f
C87 SET_B a_2985_36# 0.01886f
C88 a_2229_36# a_1088_165# 0.00147f
C89 a_141_36# VGND 0.25046f
C90 a_393_36# a_645_36# 0.07535f
C91 CLK VPB 0.09785f
C92 a_753_36# a_1296_440# 0.10257f
C93 VPWR a_645_36# 0.08042f
C95 VPB a_1296_440# 0.59969f
C96 Q_N a_2583_327# 0.10499f
C97 a_2229_36# a_2445_450# 0.01115f
C98 VPB RESET_B 0.10492f
C99 a_393_36# a_1404_36# 0.15118f
C100 a_969_450# a_753_36# 0.01125f
C101 a_753_36# a_1088_165# 0.24303f
C102 a_1296_440# a_2985_36# 0.04357f
C103 a_141_36# D 0.07933f
C105 VPB a_1088_165# 0.23983f
C106 a_1296_440# a_2085_378# 0.00869f
C107 a_2583_327# a_3813_36# 0.067f
C108 VGND a_2445_36# 0.01736f
C109 a_2583_327# a_393_36# 0.04348f
C111 VGND a_645_36# 0.07973f
C113 a_2229_36# a_393_36# 0.12464f
C114 a_2583_327# VPWR 0.32704f
C115 Q_N VPB 0.01998f
C116 a_2229_36# VPWR 0.09712f
C117 a_141_36# a_1509_378# 0.00229f
C118 VGND a_1404_36# 0.2782f
C120 VPB a_3813_36# 0.09412f
C121 D a_645_36# 0.06045f
C122 a_753_36# a_393_36# 0.16748f
C124 VPB a_393_36# 0.30026f
C125 a_753_36# VPWR 0.13878f
C126 VPB Q 0.01836f
C128 a_2583_327# VGND 0.18827f
C129 VPB VPWR 0.97198f
C130 a_2229_36# VGND 0.13668f
C131 a_1088_165# a_969_36# 0.00259f
C133 VPWR a_2985_36# 0.001f
C134 a_393_36# a_2085_378# 0.00104f
C135 VPWR a_2085_378# 0.01982f
C136 a_141_36# a_2445_36# 0.00173f
C137 a_141_36# a_645_36# 0.15148f
C138 VGND a_753_36# 0.08192f
C139 a_3093_378# a_1296_440# 0.00794f
C140 SET_B a_1296_440# 0.0586f
C141 VGND VPB 0.05087f
C142 a_2229_36# a_2085_36# 0.00346f
C144 VGND a_2985_36# 0.28018f
C145 SET_B a_1088_165# 0.09591f
C146 VGND a_2085_378# 0.00137f
C147 a_393_36# a_969_36# 0.00712f
C148 D VPB 0.11625f
C150 a_2583_327# a_141_36# 0.02694f
C152 a_141_36# a_2229_36# 0.15212f
C153 RESET_B a_1296_440# 0.07541f
C154 a_969_450# a_1296_440# 0.00179f
C155 a_1088_165# a_1296_440# 0.09088f
C156 a_753_36# a_1509_378# 0.00552f
C159 VGND a_969_36# 0.01995f
C161 SET_B a_393_36# 0.23121f
C162 a_141_36# a_753_36# 0.23916f
C164 VPWR a_3093_378# 0.01236f
C165 SET_B VPWR 0.0429f
C166 a_2229_36# a_2445_36# 0.0111f
C167 a_141_36# VPB 0.51324f
C168 a_1296_440# a_2445_450# 0.00876f
C169 Q_N a_1296_440# 0.04516f
C171 Q VNB 0.02432f
C172 Q_N VNB 0.01953f
C173 RESET_B VNB 0.18367f
C174 VGND VNB 2.78038f
C175 SET_B VNB 0.58231f
C176 VPWR VNB 1.86588f
C177 D VNB 0.13204f
C178 CLK VNB 0.19841f
C179 VPB VNB 5.30323f
C180 a_2985_36# VNB 0.02385f
C181 a_3813_36# VNB 0.16507f
C182 a_1404_36# VNB 0.01441f
C183 a_2229_36# VNB 0.15469f
C184 a_2583_327# VNB 0.50006f
C185 a_753_36# VNB 0.14401f
C186 a_645_36# VNB 0.02294f
C187 a_1296_440# VNB 0.39786f
C188 a_1088_165# VNB 0.33518f
C189 a_393_36# VNB 0.43063f
C190 a_141_36# VNB 0.6062f
.ends

.subckt sky130_efx_lvdig__dfrbp_1 CLK D RESET_B Q Q_N VGND VNB VPB VPWR
X0 Q a_2060_165# VGND VNB sky130_fd_pr__nfet_01v8 ad=0.23625 pd=2.01 as=0.23625 ps=2.01 w=0.63 l=0.15
X1 a_969_450# a_141_36# a_753_36# VPB sky130_fd_pr__pfet_01v8_hvt ad=0.16875 pd=1.2 as=0.20925 ps=1.38 w=0.45 l=0.15
X2 VPWR a_1088_165# a_969_450# VPB sky130_fd_pr__pfet_01v8_hvt ad=0.08775 pd=0.84 as=0.16875 ps=1.2 w=0.45 l=0.15
X3 a_141_36# CLK VPWR VPB sky130_fd_pr__pfet_01v8_hvt ad=0.23625 pd=2.01 as=0.23625 ps=2.01 w=0.63 l=0.15
X4 VPWR a_1725_36# a_2060_165# VPB sky130_fd_pr__pfet_01v8_hvt ad=0.16875 pd=1.65 as=0.08775 ps=0.84 w=0.45 l=0.15
X5 a_645_36# D VGND VNB sky130_fd_pr__nfet_01v8 ad=0.08258 pd=0.84 as=0.16875 ps=1.65 w=0.45 l=0.15
X6 a_753_36# a_141_36# a_645_36# VNB sky130_fd_pr__special_nfet_01v8 ad=0.1674 pd=1.29 as=0.08258 ps=0.84 w=0.36 l=0.15
X7 Q_N a_2841_36# VPWR VPB sky130_fd_pr__pfet_01v8_hvt ad=0.405 pd=2.91 as=0.405 ps=2.91 w=1.08 l=0.15
X8 a_969_450# RESET_B VPWR VPB sky130_fd_pr__pfet_01v8_hvt ad=0.16875 pd=1.65 as=0.08775 ps=0.84 w=0.45 l=0.15
X9 Q a_2060_165# VPWR VPB sky130_fd_pr__pfet_01v8_hvt ad=0.405 pd=2.91 as=0.405 ps=2.91 w=1.08 l=0.15
X10 a_1941_450# a_393_36# a_1725_36# VPB sky130_fd_pr__pfet_01v8_hvt ad=0.16875 pd=1.2 as=0.20925 ps=1.38 w=0.45 l=0.15
X11 VGND a_2060_165# a_1941_36# VNB sky130_fd_pr__nfet_01v8 ad=0.08775 pd=0.84 as=0.15593 ps=1.2 w=0.45 l=0.15
X12 Q_N a_2841_36# VGND VNB sky130_fd_pr__nfet_01v8 ad=0.23625 pd=2.01 as=0.23625 ps=2.01 w=0.63 l=0.15
X13 a_141_36# CLK VGND VNB sky130_fd_pr__nfet_01v8 ad=0.16875 pd=1.65 as=0.16875 ps=1.65 w=0.45 l=0.15
X14 a_1088_165# a_753_36# VGND VNB sky130_fd_pr__nfet_01v8 ad=0.13702 pd=1.2 as=0.23625 ps=2.01 w=0.63 l=0.15
X15 a_393_36# a_141_36# VPWR VPB sky130_fd_pr__pfet_01v8_hvt ad=0.23625 pd=2.01 as=0.23625 ps=2.01 w=0.63 l=0.15
X16 a_969_36# a_393_36# a_753_36# VNB sky130_fd_pr__special_nfet_01v8 ad=0.15593 pd=1.2 as=0.1674 ps=1.29 w=0.36 l=0.15
X17 a_1149_36# a_1088_165# a_969_36# VNB sky130_fd_pr__nfet_01v8 ad=0.08775 pd=0.84 as=0.15593 ps=1.2 w=0.45 l=0.15
X18 VGND RESET_B a_1149_36# VNB sky130_fd_pr__nfet_01v8 ad=0.16875 pd=1.65 as=0.08775 ps=0.84 w=0.45 l=0.15
X19 VPWR a_2060_165# a_1941_450# VPB sky130_fd_pr__pfet_01v8_hvt ad=0.08775 pd=0.84 as=0.16875 ps=1.2 w=0.45 l=0.15
X20 a_2060_165# a_1725_36# a_2229_36# VNB sky130_fd_pr__nfet_01v8 ad=0.16875 pd=1.65 as=0.08775 ps=0.84 w=0.45 l=0.15
X21 a_2229_36# RESET_B VGND VNB sky130_fd_pr__nfet_01v8 ad=0.08775 pd=0.84 as=0.08775 ps=0.84 w=0.45 l=0.15
X22 a_645_36# D VPWR VPB sky130_fd_pr__pfet_01v8_hvt ad=0.08775 pd=0.84 as=0.16875 ps=1.65 w=0.45 l=0.15
X23 a_2060_165# RESET_B VPWR VPB sky130_fd_pr__pfet_01v8_hvt ad=0.08775 pd=0.84 as=0.08775 ps=0.84 w=0.45 l=0.15
X24 a_2841_36# a_2060_165# VGND VNB sky130_fd_pr__nfet_01v8 ad=0.16875 pd=1.65 as=0.16875 ps=1.65 w=0.45 l=0.15
X25 a_1725_36# a_141_36# a_1088_165# VPB sky130_fd_pr__pfet_01v8_hvt ad=0.20925 pd=1.38 as=0.17415 ps=1.38 w=0.45 l=0.15
X26 a_753_36# a_393_36# a_645_36# VPB sky130_fd_pr__pfet_01v8_hvt ad=0.20925 pd=1.38 as=0.08775 ps=0.84 w=0.45 l=0.15
X27 a_1088_165# a_753_36# VPWR VPB sky130_fd_pr__pfet_01v8_hvt ad=0.17415 pd=1.38 as=0.30375 ps=2.37 w=0.81 l=0.15
X28 a_393_36# a_141_36# VGND VNB sky130_fd_pr__nfet_01v8 ad=0.16875 pd=1.65 as=0.16875 ps=1.65 w=0.45 l=0.15
X29 a_2841_36# a_2060_165# VPWR VPB sky130_fd_pr__pfet_01v8_hvt ad=0.23625 pd=2.01 as=0.23625 ps=2.01 w=0.63 l=0.15
X30 a_1941_36# a_141_36# a_1725_36# VNB sky130_fd_pr__special_nfet_01v8 ad=0.15593 pd=1.2 as=0.1674 ps=1.29 w=0.36 l=0.15
X31 a_1725_36# a_393_36# a_1088_165# VNB sky130_fd_pr__special_nfet_01v8 ad=0.1674 pd=1.29 as=0.13702 ps=1.2 w=0.36 l=0.15
C0 a_753_36# a_141_36# 0.26238f
C1 a_969_36# VGND 0.01733f
C2 a_645_36# VGND 0.07973f
C3 a_1088_165# a_1149_36# 0.00499f
C4 a_645_36# a_141_36# 0.1515f
C5 Q_N VPWR 0.13857f
C8 a_969_450# VPWR 0.31722f
C9 a_969_450# a_753_36# 0.03755f
C10 a_2841_36# a_2060_165# 0.067f
C11 a_393_36# VPWR 0.16374f
C12 a_393_36# a_753_36# 0.18375f
C13 D VPB 0.11625f
C14 RESET_B VPB 0.26969f
C16 a_393_36# a_969_36# 0.00712f
C17 a_1725_36# VPWR 0.10784f
C18 a_2060_165# VPWR 0.30709f
C19 D VGND 0.03531f
C20 a_393_36# a_645_36# 0.07535f
C21 RESET_B VGND 0.064f
C22 D a_141_36# 0.07935f
C23 RESET_B a_141_36# 0.12282f
C24 a_2841_36# Q 0.03531f
C26 VPB VGND 0.04601f
C27 a_1088_165# VPWR 0.10986f
C28 a_1088_165# a_753_36# 0.22834f
C29 CLK VPWR 0.04196f
C30 VPB a_141_36# 0.47949f
C32 a_1088_165# a_969_36# 0.00254f
C34 a_969_450# RESET_B 0.08113f
C35 a_141_36# VGND 0.31437f
C36 Q VPWR 0.1707f
C37 a_393_36# D 0.09861f
C38 a_393_36# RESET_B 0.17237f
C39 VPB Q_N 0.01435f
C40 a_1941_450# VPWR 0.01954f
C41 a_969_450# VPB 0.02169f
C42 RESET_B a_1725_36# 0.16906f
C43 Q_N VGND 0.10221f
C44 a_753_36# a_1149_36# 0.00188f
C45 RESET_B a_2060_165# 0.18498f
C46 a_393_36# VPB 0.28962f
C48 a_969_450# a_141_36# 0.0791f
C49 a_1725_36# VPB 0.14352f
C50 a_393_36# VGND 0.54006f
C51 a_2060_165# VPB 0.32795f
C53 a_1088_165# RESET_B 0.14905f
C54 a_393_36# a_141_36# 1.12349f
C55 a_1725_36# VGND 0.09182f
C56 RESET_B a_1941_36# 0.00166f
C57 a_1725_36# a_141_36# 0.16186f
C58 a_2060_165# VGND 0.29256f
C59 a_2841_36# VPWR 0.22976f
C60 a_2060_165# a_141_36# 0.05535f
C61 a_1088_165# VPB 0.10846f
C62 RESET_B Q 0.00136f
C63 CLK VPB 0.09785f
C64 RESET_B a_1941_450# 0.00876f
C66 a_2229_36# VGND 0.01143f
C67 a_1088_165# VGND 0.21474f
C69 CLK VGND 0.04537f
C70 a_1088_165# a_141_36# 0.071f
C71 VPB Q 0.01836f
C72 a_1941_36# VGND 0.01995f
C74 a_753_36# VPWR 0.12161f
C75 CLK a_141_36# 0.09924f
C76 a_1941_36# a_141_36# 0.00331f
C77 a_969_36# a_753_36# 0.00965f
C78 a_393_36# a_1725_36# 0.12511f
C79 Q VGND 0.12516f
C80 a_645_36# VPWR 0.08042f
C81 a_393_36# a_2060_165# 0.02289f
C83 a_645_36# a_753_36# 0.04498f
C84 a_1088_165# a_969_450# 0.01004f
C85 a_2060_165# a_1725_36# 0.26033f
C87 a_1149_36# VGND 0.01143f
C89 a_1088_165# a_393_36# 0.27871f
C92 a_1088_165# a_1725_36# 0.04489f
C93 a_2060_165# a_2229_36# 0.00952f
C94 a_1725_36# a_1941_36# 0.00965f
C95 a_2841_36# VPB 0.09198f
C96 D VPWR 0.03564f
C97 a_2060_165# a_1941_36# 0.00277f
C98 RESET_B VPWR 0.58229f
C99 RESET_B a_753_36# 0.12175f
C100 a_393_36# a_1941_450# 0.00194f
C101 a_1725_36# Q 0.00104f
C102 a_2841_36# VGND 0.18408f
C103 a_2060_165# Q 0.11061f
C105 a_1725_36# a_1941_450# 0.01125f
C106 a_393_36# a_1149_36# 0.00304f
C107 D a_645_36# 0.06045f
C109 VPB VPWR 0.69688f
C110 VPB a_753_36# 0.12579f
C111 VGND VPWR 0.13306f
C112 a_753_36# VGND 0.0875f
C113 a_2841_36# Q_N 0.07073f
C114 a_645_36# VPB 0.02422f
C115 a_141_36# VPWR 0.47472f
C116 Q_N VNB 0.10703f
C117 Q VNB 0.0171f
C118 VGND VNB 2.02269f
C119 VPWR VNB 1.38982f
C120 RESET_B VNB 0.19691f
C121 D VNB 0.13204f
C122 CLK VNB 0.19841f
C123 VPB VNB 3.84912f
C124 a_969_450# VNB 0.0028f
C125 a_645_36# VNB 0.02294f
C126 a_2841_36# VNB 0.18599f
C127 a_1725_36# VNB 0.15264f
C128 a_2060_165# VNB 0.48832f
C129 a_753_36# VNB 0.16567f
C130 a_1088_165# VNB 0.17373f
C131 a_393_36# VNB 0.40194f
C132 a_141_36# VNB 0.58852f
.ends

.subckt sky130_efx_lvdig__dfrbp_2 CLK D RESET_B Q Q_N VGND VNB VPB VPWR
X0 VGND a_2060_165# Q VNB sky130_fd_pr__nfet_01v8 ad=0.23625 pd=2.01 as=0.12285 ps=1.02 w=0.63 l=0.15
X1 a_2949_36# a_2060_165# VPWR VPB sky130_fd_pr__pfet_01v8_hvt ad=0.23625 pd=2.01 as=0.23625 ps=2.01 w=0.63 l=0.15
X2 Q a_2060_165# VGND VNB sky130_fd_pr__nfet_01v8 ad=0.12285 pd=1.02 as=0.23625 ps=2.01 w=0.63 l=0.15
X3 a_969_450# a_141_36# a_753_36# VPB sky130_fd_pr__pfet_01v8_hvt ad=0.16875 pd=1.2 as=0.20925 ps=1.38 w=0.45 l=0.15
X4 VPWR a_1088_165# a_969_450# VPB sky130_fd_pr__pfet_01v8_hvt ad=0.08775 pd=0.84 as=0.16875 ps=1.2 w=0.45 l=0.15
X5 a_141_36# CLK VPWR VPB sky130_fd_pr__pfet_01v8_hvt ad=0.23625 pd=2.01 as=0.23625 ps=2.01 w=0.63 l=0.15
X6 VPWR a_1725_36# a_2060_165# VPB sky130_fd_pr__pfet_01v8_hvt ad=0.16875 pd=1.65 as=0.08775 ps=0.84 w=0.45 l=0.15
X7 a_645_36# D VGND VNB sky130_fd_pr__nfet_01v8 ad=0.08258 pd=0.84 as=0.16875 ps=1.65 w=0.45 l=0.15
X8 a_753_36# a_141_36# a_645_36# VNB sky130_fd_pr__special_nfet_01v8 ad=0.1674 pd=1.29 as=0.08258 ps=0.84 w=0.36 l=0.15
X9 a_969_450# RESET_B VPWR VPB sky130_fd_pr__pfet_01v8_hvt ad=0.16875 pd=1.65 as=0.08775 ps=0.84 w=0.45 l=0.15
X10 Q a_2060_165# VPWR VPB sky130_fd_pr__pfet_01v8_hvt ad=0.2106 pd=1.47 as=0.405 ps=2.91 w=1.08 l=0.15
X11 Q_N a_2949_36# VPWR VPB sky130_fd_pr__pfet_01v8_hvt ad=0.2106 pd=1.47 as=0.405 ps=2.91 w=1.08 l=0.15
X12 a_1941_450# a_393_36# a_1725_36# VPB sky130_fd_pr__pfet_01v8_hvt ad=0.16875 pd=1.2 as=0.20925 ps=1.38 w=0.45 l=0.15
X13 VGND a_2060_165# a_1941_36# VNB sky130_fd_pr__nfet_01v8 ad=0.08775 pd=0.84 as=0.15593 ps=1.2 w=0.45 l=0.15
X14 a_2949_36# a_2060_165# VGND VNB sky130_fd_pr__nfet_01v8 ad=0.16875 pd=1.65 as=0.16875 ps=1.65 w=0.45 l=0.15
X15 VPWR a_2060_165# Q VPB sky130_fd_pr__pfet_01v8_hvt ad=0.405 pd=2.91 as=0.2106 ps=1.47 w=1.08 l=0.15
X16 VPWR a_2949_36# Q_N VPB sky130_fd_pr__pfet_01v8_hvt ad=0.405 pd=2.91 as=0.2106 ps=1.47 w=1.08 l=0.15
X17 Q_N a_2949_36# VGND VNB sky130_fd_pr__nfet_01v8 ad=0.12285 pd=1.02 as=0.23625 ps=2.01 w=0.63 l=0.15
X18 a_141_36# CLK VGND VNB sky130_fd_pr__nfet_01v8 ad=0.16875 pd=1.65 as=0.16875 ps=1.65 w=0.45 l=0.15
X19 a_1088_165# a_753_36# VGND VNB sky130_fd_pr__nfet_01v8 ad=0.13702 pd=1.2 as=0.23625 ps=2.01 w=0.63 l=0.15
X20 a_393_36# a_141_36# VPWR VPB sky130_fd_pr__pfet_01v8_hvt ad=0.23625 pd=2.01 as=0.23625 ps=2.01 w=0.63 l=0.15
X21 a_969_36# a_393_36# a_753_36# VNB sky130_fd_pr__special_nfet_01v8 ad=0.15593 pd=1.2 as=0.1674 ps=1.29 w=0.36 l=0.15
X22 a_1149_36# a_1088_165# a_969_36# VNB sky130_fd_pr__nfet_01v8 ad=0.08775 pd=0.84 as=0.15593 ps=1.2 w=0.45 l=0.15
X23 VGND RESET_B a_1149_36# VNB sky130_fd_pr__nfet_01v8 ad=0.16875 pd=1.65 as=0.08775 ps=0.84 w=0.45 l=0.15
X24 VPWR a_2060_165# a_1941_450# VPB sky130_fd_pr__pfet_01v8_hvt ad=0.08775 pd=0.84 as=0.16875 ps=1.2 w=0.45 l=0.15
X25 a_2060_165# a_1725_36# a_2229_36# VNB sky130_fd_pr__nfet_01v8 ad=0.16875 pd=1.65 as=0.08775 ps=0.84 w=0.45 l=0.15
X26 a_2229_36# RESET_B VGND VNB sky130_fd_pr__nfet_01v8 ad=0.08775 pd=0.84 as=0.08775 ps=0.84 w=0.45 l=0.15
X27 a_645_36# D VPWR VPB sky130_fd_pr__pfet_01v8_hvt ad=0.08775 pd=0.84 as=0.16875 ps=1.65 w=0.45 l=0.15
X28 a_2060_165# RESET_B VPWR VPB sky130_fd_pr__pfet_01v8_hvt ad=0.08775 pd=0.84 as=0.08775 ps=0.84 w=0.45 l=0.15
X29 a_1725_36# a_141_36# a_1088_165# VPB sky130_fd_pr__pfet_01v8_hvt ad=0.20925 pd=1.38 as=0.17415 ps=1.38 w=0.45 l=0.15
X30 VGND a_2949_36# Q_N VNB sky130_fd_pr__nfet_01v8 ad=0.23625 pd=2.01 as=0.12285 ps=1.02 w=0.63 l=0.15
X31 a_753_36# a_393_36# a_645_36# VPB sky130_fd_pr__pfet_01v8_hvt ad=0.20925 pd=1.38 as=0.08775 ps=0.84 w=0.45 l=0.15
X32 a_1088_165# a_753_36# VPWR VPB sky130_fd_pr__pfet_01v8_hvt ad=0.17415 pd=1.38 as=0.30375 ps=2.37 w=0.81 l=0.15
X33 a_393_36# a_141_36# VGND VNB sky130_fd_pr__nfet_01v8 ad=0.16875 pd=1.65 as=0.16875 ps=1.65 w=0.45 l=0.15
X34 a_1941_36# a_141_36# a_1725_36# VNB sky130_fd_pr__special_nfet_01v8 ad=0.15593 pd=1.2 as=0.1674 ps=1.29 w=0.36 l=0.15
X35 a_1725_36# a_393_36# a_1088_165# VNB sky130_fd_pr__special_nfet_01v8 ad=0.1674 pd=1.29 as=0.13702 ps=1.2 w=0.36 l=0.15
C0 a_753_36# a_141_36# 0.26238f
C1 a_969_36# VGND 0.01733f
C2 a_645_36# VGND 0.07973f
C3 a_1088_165# a_1149_36# 0.00499f
C4 a_645_36# a_141_36# 0.1515f
C5 Q_N VPWR 0.22627f
C8 a_969_450# VPWR 0.31722f
C9 a_969_450# a_753_36# 0.03755f
C10 a_2949_36# a_2060_165# 0.0697f
C11 a_393_36# VPWR 0.16374f
C12 a_393_36# a_753_36# 0.18375f
C13 D VPB 0.11625f
C14 RESET_B VPB 0.26878f
C16 a_393_36# a_969_36# 0.00712f
C17 a_1725_36# VPWR 0.10827f
C18 a_2060_165# VPWR 0.35209f
C19 D VGND 0.03531f
C20 a_393_36# a_645_36# 0.07535f
C21 RESET_B VGND 0.064f
C22 D a_141_36# 0.07935f
C23 RESET_B a_141_36# 0.12282f
C24 a_2949_36# Q 0.01307f
C26 VPB VGND 0.04933f
C27 a_1088_165# VPWR 0.10986f
C28 a_1088_165# a_753_36# 0.22834f
C29 CLK VPWR 0.04196f
C30 VPB a_141_36# 0.47951f
C32 a_1088_165# a_969_36# 0.00254f
C34 a_969_450# RESET_B 0.08113f
C35 a_141_36# VGND 0.31442f
C36 Q VPWR 0.22627f
C37 a_393_36# D 0.09861f
C38 a_393_36# RESET_B 0.17237f
C39 VPB Q_N 0.00808f
C40 a_1941_450# VPWR 0.01954f
C41 a_969_450# VPB 0.02169f
C42 RESET_B a_1725_36# 0.16906f
C43 Q_N VGND 0.15357f
C44 a_753_36# a_1149_36# 0.00188f
C45 RESET_B a_2060_165# 0.18554f
C46 a_393_36# VPB 0.28962f
C48 a_969_450# a_141_36# 0.0791f
C49 a_1725_36# VPB 0.14421f
C50 a_393_36# VGND 0.54006f
C51 a_2060_165# VPB 0.37538f
C53 a_1088_165# RESET_B 0.14905f
C54 a_393_36# a_141_36# 1.12349f
C55 a_1725_36# VGND 0.09195f
C56 RESET_B a_1941_36# 0.00166f
C57 a_1725_36# a_141_36# 0.16186f
C58 a_2060_165# VGND 0.33059f
C59 a_2949_36# VPWR 0.27185f
C60 a_2060_165# a_141_36# 0.05568f
C61 a_1088_165# VPB 0.10846f
C62 RESET_B Q 0.00144f
C63 CLK VPB 0.09785f
C64 RESET_B a_1941_450# 0.00876f
C66 a_2229_36# VGND 0.01143f
C67 a_1088_165# VGND 0.21474f
C69 CLK VGND 0.04537f
C70 a_1088_165# a_141_36# 0.071f
C71 VPB Q 0.00889f
C72 a_1941_36# VGND 0.01995f
C74 a_753_36# VPWR 0.12161f
C75 CLK a_141_36# 0.09924f
C76 a_1941_36# a_141_36# 0.00331f
C77 a_969_36# a_753_36# 0.00965f
C78 a_393_36# a_1725_36# 0.12511f
C79 Q VGND 0.15357f
C80 a_645_36# VPWR 0.08042f
C81 a_393_36# a_2060_165# 0.02289f
C83 a_645_36# a_753_36# 0.04498f
C84 a_1088_165# a_969_450# 0.01004f
C85 a_2060_165# a_1725_36# 0.25953f
C87 a_1149_36# VGND 0.01143f
C89 a_1088_165# a_393_36# 0.27871f
C92 a_1088_165# a_1725_36# 0.04489f
C93 a_2060_165# a_2229_36# 0.00952f
C94 a_1725_36# a_1941_36# 0.00965f
C95 a_2949_36# VPB 0.1389f
C96 D VPWR 0.03564f
C97 a_2060_165# a_1941_36# 0.00277f
C98 RESET_B VPWR 0.58314f
C99 RESET_B a_753_36# 0.12175f
C100 a_393_36# a_1941_450# 0.00194f
C101 a_1725_36# Q 0.00104f
C102 a_2949_36# VGND 0.21597f
C103 a_2060_165# Q 0.13176f
C105 a_1725_36# a_1941_450# 0.01125f
C106 a_393_36# a_1149_36# 0.00304f
C107 D a_645_36# 0.06045f
C109 VPB VPWR 0.74883f
C110 VPB a_753_36# 0.12579f
C111 VGND VPWR 0.17818f
C112 a_753_36# VGND 0.0875f
C113 a_2949_36# Q_N 0.1198f
C114 a_645_36# VPB 0.02422f
C115 a_141_36# VPWR 0.47472f
C116 Q_N VNB 0.03639f
C117 Q VNB 0.01272f
C118 VGND VNB 2.17392f
C119 VPWR VNB 1.51072f
C120 RESET_B VNB 0.1956f
C121 D VNB 0.13204f
C122 CLK VNB 0.19841f
C123 VPB VNB 4.10573f
C124 a_969_450# VNB 0.0028f
C125 a_645_36# VNB 0.02294f
C126 a_2949_36# VNB 0.27373f
C127 a_1725_36# VNB 0.15274f
C128 a_2060_165# VNB 0.57432f
C129 a_753_36# VNB 0.16567f
C130 a_1088_165# VNB 0.17373f
C131 a_393_36# VNB 0.40194f
C132 a_141_36# VNB 0.58807f
.ends

.subckt sky130_efx_lvdig__dfrtp_1 CLK D RESET_B Q VGND VNB VPB VPWR
X0 Q a_2060_165# VGND VNB sky130_fd_pr__nfet_01v8 ad=0.23625 pd=2.01 as=0.23625 ps=2.01 w=0.63 l=0.15
X1 a_969_450# a_141_36# a_753_36# VPB sky130_fd_pr__pfet_01v8_hvt ad=0.16875 pd=1.2 as=0.20925 ps=1.38 w=0.45 l=0.15
X2 VPWR a_1088_165# a_969_450# VPB sky130_fd_pr__pfet_01v8_hvt ad=0.08775 pd=0.84 as=0.16875 ps=1.2 w=0.45 l=0.15
X3 a_141_36# CLK VPWR VPB sky130_fd_pr__pfet_01v8_hvt ad=0.23625 pd=2.01 as=0.23625 ps=2.01 w=0.63 l=0.15
X4 VPWR a_1725_36# a_2060_165# VPB sky130_fd_pr__pfet_01v8_hvt ad=0.16875 pd=1.65 as=0.08775 ps=0.84 w=0.45 l=0.15
X5 a_645_36# D VGND VNB sky130_fd_pr__nfet_01v8 ad=0.08258 pd=0.84 as=0.16875 ps=1.65 w=0.45 l=0.15
X6 a_753_36# a_141_36# a_645_36# VNB sky130_fd_pr__special_nfet_01v8 ad=0.1674 pd=1.29 as=0.08258 ps=0.84 w=0.36 l=0.15
X7 a_969_450# RESET_B VPWR VPB sky130_fd_pr__pfet_01v8_hvt ad=0.16875 pd=1.65 as=0.08775 ps=0.84 w=0.45 l=0.15
X8 Q a_2060_165# VPWR VPB sky130_fd_pr__pfet_01v8_hvt ad=0.405 pd=2.91 as=0.405 ps=2.91 w=1.08 l=0.15
X9 a_1941_450# a_393_36# a_1725_36# VPB sky130_fd_pr__pfet_01v8_hvt ad=0.16875 pd=1.2 as=0.20925 ps=1.38 w=0.45 l=0.15
X10 VGND a_2060_165# a_1941_36# VNB sky130_fd_pr__nfet_01v8 ad=0.08775 pd=0.84 as=0.15593 ps=1.2 w=0.45 l=0.15
X11 a_141_36# CLK VGND VNB sky130_fd_pr__nfet_01v8 ad=0.16875 pd=1.65 as=0.16875 ps=1.65 w=0.45 l=0.15
X12 a_1088_165# a_753_36# VGND VNB sky130_fd_pr__nfet_01v8 ad=0.13702 pd=1.2 as=0.23625 ps=2.01 w=0.63 l=0.15
X13 a_393_36# a_141_36# VPWR VPB sky130_fd_pr__pfet_01v8_hvt ad=0.23625 pd=2.01 as=0.23625 ps=2.01 w=0.63 l=0.15
X14 a_969_36# a_393_36# a_753_36# VNB sky130_fd_pr__special_nfet_01v8 ad=0.15593 pd=1.2 as=0.1674 ps=1.29 w=0.36 l=0.15
X15 a_1149_36# a_1088_165# a_969_36# VNB sky130_fd_pr__nfet_01v8 ad=0.08775 pd=0.84 as=0.15593 ps=1.2 w=0.45 l=0.15
X16 VGND RESET_B a_1149_36# VNB sky130_fd_pr__nfet_01v8 ad=0.16875 pd=1.65 as=0.08775 ps=0.84 w=0.45 l=0.15
X17 VPWR a_2060_165# a_1941_450# VPB sky130_fd_pr__pfet_01v8_hvt ad=0.08775 pd=0.84 as=0.16875 ps=1.2 w=0.45 l=0.15
X18 a_2060_165# a_1725_36# a_2229_36# VNB sky130_fd_pr__nfet_01v8 ad=0.16875 pd=1.65 as=0.08775 ps=0.84 w=0.45 l=0.15
X19 a_2229_36# RESET_B VGND VNB sky130_fd_pr__nfet_01v8 ad=0.08775 pd=0.84 as=0.08775 ps=0.84 w=0.45 l=0.15
X20 a_645_36# D VPWR VPB sky130_fd_pr__pfet_01v8_hvt ad=0.08775 pd=0.84 as=0.16875 ps=1.65 w=0.45 l=0.15
X21 a_2060_165# RESET_B VPWR VPB sky130_fd_pr__pfet_01v8_hvt ad=0.08775 pd=0.84 as=0.08775 ps=0.84 w=0.45 l=0.15
X22 a_1725_36# a_141_36# a_1088_165# VPB sky130_fd_pr__pfet_01v8_hvt ad=0.20925 pd=1.38 as=0.17415 ps=1.38 w=0.45 l=0.15
X23 a_753_36# a_393_36# a_645_36# VPB sky130_fd_pr__pfet_01v8_hvt ad=0.20925 pd=1.38 as=0.08775 ps=0.84 w=0.45 l=0.15
X24 a_1088_165# a_753_36# VPWR VPB sky130_fd_pr__pfet_01v8_hvt ad=0.17415 pd=1.38 as=0.30375 ps=2.37 w=0.81 l=0.15
X25 a_393_36# a_141_36# VGND VNB sky130_fd_pr__nfet_01v8 ad=0.16875 pd=1.65 as=0.16875 ps=1.65 w=0.45 l=0.15
X26 a_1941_36# a_141_36# a_1725_36# VNB sky130_fd_pr__special_nfet_01v8 ad=0.15593 pd=1.2 as=0.1674 ps=1.29 w=0.36 l=0.15
X27 a_1725_36# a_393_36# a_1088_165# VNB sky130_fd_pr__special_nfet_01v8 ad=0.1674 pd=1.29 as=0.13702 ps=1.2 w=0.36 l=0.15
C0 a_1725_36# a_141_36# 0.16186f
C1 a_2060_165# a_1941_36# 0.00277f
C2 a_393_36# a_1941_450# 0.00194f
C4 VGND Q 0.10221f
C5 a_141_36# D 0.07935f
C6 a_753_36# a_969_36# 0.00965f
C7 a_393_36# a_1725_36# 0.12511f
C8 VGND RESET_B 0.064f
C9 Q RESET_B 0.00136f
C10 a_1088_165# a_1725_36# 0.04489f
C11 a_1941_450# VPWR 0.01954f
C12 a_393_36# a_969_36# 0.00712f
C13 VGND a_141_36# 0.31434f
C15 a_1088_165# a_969_36# 0.00254f
C16 a_393_36# D 0.09861f
C17 a_2060_165# a_1725_36# 0.25607f
C18 RESET_B a_141_36# 0.12282f
C19 VPWR a_1725_36# 0.10768f
C20 a_753_36# VGND 0.0875f
C21 a_1725_36# VPB 0.14214f
C22 a_2060_165# a_2229_36# 0.00952f
C24 VGND a_1149_36# 0.01143f
C26 a_645_36# D 0.06045f
C27 a_393_36# VGND 0.54006f
C28 a_753_36# RESET_B 0.12175f
C29 a_1941_36# a_1725_36# 0.00965f
C30 a_1088_165# VGND 0.21474f
C31 VGND a_645_36# 0.07973f
C32 VPWR D 0.03564f
C33 VPB D 0.11625f
C34 a_393_36# RESET_B 0.17237f
C35 a_753_36# a_141_36# 0.26238f
C36 a_969_450# RESET_B 0.08113f
C37 a_1088_165# RESET_B 0.14905f
C38 VGND CLK 0.04537f
C40 a_2060_165# VGND 0.25144f
C41 a_2060_165# Q 0.07073f
C42 a_393_36# a_141_36# 1.12349f
C43 VGND VPWR 0.0767f
C44 VPWR Q 0.13857f
C45 VGND VPB 0.03136f
C46 Q VPB 0.01435f
C47 a_969_450# a_141_36# 0.0791f
C48 a_753_36# a_1149_36# 0.00188f
C49 a_1088_165# a_141_36# 0.071f
C50 a_1941_450# a_1725_36# 0.01125f
C51 a_645_36# a_141_36# 0.1515f
C52 a_2060_165# RESET_B 0.18456f
C53 a_753_36# a_393_36# 0.18375f
C54 VPWR RESET_B 0.58159f
C55 RESET_B VPB 0.26748f
C56 VGND a_1941_36# 0.01995f
C57 a_393_36# a_1149_36# 0.00304f
C58 a_753_36# a_969_450# 0.03755f
C59 a_753_36# a_1088_165# 0.22834f
C60 a_141_36# CLK 0.09924f
C61 a_2060_165# a_141_36# 0.05478f
C62 a_753_36# a_645_36# 0.04498f
C63 a_1088_165# a_1149_36# 0.00499f
C64 VPWR a_141_36# 0.47472f
C65 VPB a_141_36# 0.47938f
C66 RESET_B a_1941_36# 0.00166f
C69 a_1088_165# a_393_36# 0.27871f
C70 a_393_36# a_645_36# 0.07535f
C71 a_1088_165# a_969_450# 0.01004f
C72 a_753_36# VPWR 0.12161f
C73 a_1941_36# a_141_36# 0.00331f
C74 a_753_36# VPB 0.12579f
C77 a_2060_165# a_393_36# 0.02289f
C78 a_393_36# VPWR 0.16374f
C79 a_393_36# VPB 0.28962f
C81 VPWR a_969_450# 0.31722f
C82 a_1088_165# VPWR 0.10986f
C83 a_969_450# VPB 0.02169f
C84 a_1941_450# RESET_B 0.00876f
C85 a_1088_165# VPB 0.10846f
C86 VPWR a_645_36# 0.08042f
C87 a_645_36# VPB 0.02422f
C88 VGND a_1725_36# 0.09182f
C89 Q a_1725_36# 0.00104f
C90 VGND a_2229_36# 0.01143f
C91 VPWR CLK 0.04196f
C92 VGND a_969_36# 0.01733f
C93 VPB CLK 0.09785f
C94 a_2060_165# VPWR 0.26709f
C95 a_2060_165# VPB 0.18361f
C96 RESET_B a_1725_36# 0.16906f
C97 VPWR VPB 0.573f
C99 VGND D 0.03531f
C100 Q VNB 0.10703f
C101 VGND VNB 1.71773f
C102 VPWR VNB 1.19142f
C103 RESET_B VNB 0.2032f
C104 D VNB 0.13204f
C105 CLK VNB 0.19841f
C106 VPB VNB 3.25037f
C107 a_969_450# VNB 0.0028f
C108 a_645_36# VNB 0.02294f
C109 a_1725_36# VNB 0.15837f
C110 a_2060_165# VNB 0.30916f
C111 a_753_36# VNB 0.16567f
C112 a_1088_165# VNB 0.17373f
C113 a_393_36# VNB 0.40194f
C114 a_141_36# VNB 0.59072f
.ends

.subckt sky130_efx_lvdig__dfrtp_2 CLK D RESET_B Q VGND VNB VPB VPWR
X0 VGND a_2060_165# Q VNB sky130_fd_pr__nfet_01v8 ad=0.23625 pd=2.01 as=0.12285 ps=1.02 w=0.63 l=0.15
X1 Q a_2060_165# VGND VNB sky130_fd_pr__nfet_01v8 ad=0.12285 pd=1.02 as=0.23625 ps=2.01 w=0.63 l=0.15
X2 a_969_450# a_141_36# a_753_36# VPB sky130_fd_pr__pfet_01v8_hvt ad=0.16875 pd=1.2 as=0.20925 ps=1.38 w=0.45 l=0.15
X3 VPWR a_1088_165# a_969_450# VPB sky130_fd_pr__pfet_01v8_hvt ad=0.08775 pd=0.84 as=0.16875 ps=1.2 w=0.45 l=0.15
X4 a_141_36# CLK VPWR VPB sky130_fd_pr__pfet_01v8_hvt ad=0.23625 pd=2.01 as=0.23625 ps=2.01 w=0.63 l=0.15
X5 VPWR a_1725_36# a_2060_165# VPB sky130_fd_pr__pfet_01v8_hvt ad=0.16875 pd=1.65 as=0.08775 ps=0.84 w=0.45 l=0.15
X6 a_645_36# D VGND VNB sky130_fd_pr__nfet_01v8 ad=0.08258 pd=0.84 as=0.16875 ps=1.65 w=0.45 l=0.15
X7 a_753_36# a_141_36# a_645_36# VNB sky130_fd_pr__special_nfet_01v8 ad=0.1674 pd=1.29 as=0.08258 ps=0.84 w=0.36 l=0.15
X8 a_969_450# RESET_B VPWR VPB sky130_fd_pr__pfet_01v8_hvt ad=0.16875 pd=1.65 as=0.08775 ps=0.84 w=0.45 l=0.15
X9 Q a_2060_165# VPWR VPB sky130_fd_pr__pfet_01v8_hvt ad=0.2106 pd=1.47 as=0.405 ps=2.91 w=1.08 l=0.15
X10 a_1941_450# a_393_36# a_1725_36# VPB sky130_fd_pr__pfet_01v8_hvt ad=0.16875 pd=1.2 as=0.20925 ps=1.38 w=0.45 l=0.15
X11 VGND a_2060_165# a_1941_36# VNB sky130_fd_pr__nfet_01v8 ad=0.08775 pd=0.84 as=0.15593 ps=1.2 w=0.45 l=0.15
X12 VPWR a_2060_165# Q VPB sky130_fd_pr__pfet_01v8_hvt ad=0.405 pd=2.91 as=0.2106 ps=1.47 w=1.08 l=0.15
X13 a_141_36# CLK VGND VNB sky130_fd_pr__nfet_01v8 ad=0.16875 pd=1.65 as=0.16875 ps=1.65 w=0.45 l=0.15
X14 a_1088_165# a_753_36# VGND VNB sky130_fd_pr__nfet_01v8 ad=0.13702 pd=1.2 as=0.23625 ps=2.01 w=0.63 l=0.15
X15 a_393_36# a_141_36# VPWR VPB sky130_fd_pr__pfet_01v8_hvt ad=0.23625 pd=2.01 as=0.23625 ps=2.01 w=0.63 l=0.15
X16 a_969_36# a_393_36# a_753_36# VNB sky130_fd_pr__special_nfet_01v8 ad=0.15593 pd=1.2 as=0.1674 ps=1.29 w=0.36 l=0.15
X17 a_1149_36# a_1088_165# a_969_36# VNB sky130_fd_pr__nfet_01v8 ad=0.08775 pd=0.84 as=0.15593 ps=1.2 w=0.45 l=0.15
X18 VGND RESET_B a_1149_36# VNB sky130_fd_pr__nfet_01v8 ad=0.16875 pd=1.65 as=0.08775 ps=0.84 w=0.45 l=0.15
X19 VPWR a_2060_165# a_1941_450# VPB sky130_fd_pr__pfet_01v8_hvt ad=0.08775 pd=0.84 as=0.16875 ps=1.2 w=0.45 l=0.15
X20 a_2060_165# a_1725_36# a_2229_36# VNB sky130_fd_pr__nfet_01v8 ad=0.16875 pd=1.65 as=0.08775 ps=0.84 w=0.45 l=0.15
X21 a_2229_36# RESET_B VGND VNB sky130_fd_pr__nfet_01v8 ad=0.08775 pd=0.84 as=0.08775 ps=0.84 w=0.45 l=0.15
X22 a_645_36# D VPWR VPB sky130_fd_pr__pfet_01v8_hvt ad=0.08775 pd=0.84 as=0.16875 ps=1.65 w=0.45 l=0.15
X23 a_2060_165# RESET_B VPWR VPB sky130_fd_pr__pfet_01v8_hvt ad=0.08775 pd=0.84 as=0.08775 ps=0.84 w=0.45 l=0.15
X24 a_1725_36# a_141_36# a_1088_165# VPB sky130_fd_pr__pfet_01v8_hvt ad=0.20925 pd=1.38 as=0.17415 ps=1.38 w=0.45 l=0.15
X25 a_753_36# a_393_36# a_645_36# VPB sky130_fd_pr__pfet_01v8_hvt ad=0.20925 pd=1.38 as=0.08775 ps=0.84 w=0.45 l=0.15
X26 a_1088_165# a_753_36# VPWR VPB sky130_fd_pr__pfet_01v8_hvt ad=0.17415 pd=1.38 as=0.30375 ps=2.37 w=0.81 l=0.15
X27 a_393_36# a_141_36# VGND VNB sky130_fd_pr__nfet_01v8 ad=0.16875 pd=1.65 as=0.16875 ps=1.65 w=0.45 l=0.15
X28 a_1941_36# a_141_36# a_1725_36# VNB sky130_fd_pr__special_nfet_01v8 ad=0.15593 pd=1.2 as=0.1674 ps=1.29 w=0.36 l=0.15
X29 a_1725_36# a_393_36# a_1088_165# VNB sky130_fd_pr__special_nfet_01v8 ad=0.1674 pd=1.29 as=0.13702 ps=1.2 w=0.36 l=0.15
C0 a_1725_36# a_141_36# 0.16186f
C1 a_2060_165# a_1941_36# 0.00277f
C2 a_393_36# a_1941_450# 0.00194f
C4 VGND Q 0.15357f
C5 a_141_36# D 0.07935f
C6 a_753_36# a_969_36# 0.00965f
C7 a_393_36# a_1725_36# 0.12511f
C8 VGND RESET_B 0.064f
C9 Q RESET_B 0.00144f
C10 a_1088_165# a_1725_36# 0.04489f
C11 a_1941_450# VPWR 0.01954f
C12 a_393_36# a_969_36# 0.00712f
C13 VGND a_141_36# 0.31438f
C15 a_1088_165# a_969_36# 0.00254f
C16 a_393_36# D 0.09861f
C17 a_2060_165# a_1725_36# 0.25607f
C18 RESET_B a_141_36# 0.12282f
C19 VPWR a_1725_36# 0.10814f
C20 a_753_36# VGND 0.0875f
C21 a_1725_36# VPB 0.14291f
C22 a_2060_165# a_2229_36# 0.00952f
C24 VGND a_1149_36# 0.01143f
C26 a_645_36# D 0.06045f
C27 a_393_36# VGND 0.54006f
C28 a_753_36# RESET_B 0.12175f
C29 a_1941_36# a_1725_36# 0.00965f
C30 a_1088_165# VGND 0.21474f
C31 VGND a_645_36# 0.07973f
C32 VPWR D 0.03564f
C33 VPB D 0.11625f
C34 a_393_36# RESET_B 0.17237f
C35 a_753_36# a_141_36# 0.26238f
C36 a_969_450# RESET_B 0.08113f
C37 a_1088_165# RESET_B 0.14905f
C38 VGND CLK 0.04537f
C40 a_2060_165# VGND 0.27868f
C41 a_2060_165# Q 0.1198f
C42 a_393_36# a_141_36# 1.12349f
C43 VGND VPWR 0.0948f
C44 VPWR Q 0.22627f
C45 VGND VPB 0.02998f
C46 Q VPB 0.00762f
C47 a_969_450# a_141_36# 0.0791f
C48 a_753_36# a_1149_36# 0.00188f
C49 a_1088_165# a_141_36# 0.071f
C50 a_1941_450# a_1725_36# 0.01125f
C51 a_645_36# a_141_36# 0.1515f
C52 a_2060_165# RESET_B 0.18523f
C53 a_753_36# a_393_36# 0.18375f
C54 VPWR RESET_B 0.58244f
C55 RESET_B VPB 0.26648f
C56 VGND a_1941_36# 0.01995f
C57 a_393_36# a_1149_36# 0.00304f
C58 a_753_36# a_969_450# 0.03755f
C59 a_753_36# a_1088_165# 0.22834f
C60 a_141_36# CLK 0.09924f
C61 a_2060_165# a_141_36# 0.05502f
C62 a_753_36# a_645_36# 0.04498f
C63 a_1088_165# a_1149_36# 0.00499f
C64 VPWR a_141_36# 0.47472f
C65 VPB a_141_36# 0.47939f
C66 RESET_B a_1941_36# 0.00166f
C69 a_1088_165# a_393_36# 0.27871f
C70 a_393_36# a_645_36# 0.07535f
C71 a_1088_165# a_969_450# 0.01004f
C72 a_753_36# VPWR 0.12161f
C73 a_1941_36# a_141_36# 0.00331f
C74 a_753_36# VPB 0.12579f
C77 a_2060_165# a_393_36# 0.02289f
C78 a_393_36# VPWR 0.16374f
C79 a_393_36# VPB 0.28962f
C81 VPWR a_969_450# 0.31722f
C82 a_1088_165# VPWR 0.10986f
C83 a_969_450# VPB 0.02169f
C84 a_1941_450# RESET_B 0.00876f
C85 a_1088_165# VPB 0.10846f
C86 VPWR a_645_36# 0.08042f
C87 a_645_36# VPB 0.02422f
C88 VGND a_1725_36# 0.09195f
C89 Q a_1725_36# 0.00104f
C90 VGND a_2229_36# 0.01143f
C91 VPWR CLK 0.04196f
C92 VGND a_969_36# 0.01733f
C93 VPB CLK 0.09785f
C94 a_2060_165# VPWR 0.29791f
C95 a_2060_165# VPB 0.22801f
C96 RESET_B a_1725_36# 0.16906f
C97 VPWR VPB 0.58277f
C99 VGND D 0.03531f
C100 Q VNB 0.03684f
C101 VGND VNB 1.78139f
C102 VPWR VNB 1.25981f
C103 RESET_B VNB 0.20182f
C104 D VNB 0.13204f
C105 CLK VNB 0.19841f
C106 VPB VNB 3.3359f
C107 a_969_450# VNB 0.0028f
C108 a_645_36# VNB 0.02294f
C109 a_1725_36# VNB 0.1576f
C110 a_2060_165# VNB 0.39739f
C111 a_753_36# VNB 0.16567f
C112 a_1088_165# VNB 0.17373f
C113 a_393_36# VNB 0.40194f
C114 a_141_36# VNB 0.59034f
.ends

.subckt sky130_efx_lvdig__dfstp_1 CLK D SET_B Q VGND VNB VPB VPWR
X0 a_1137_171# a_789_36# VPWR VPB sky130_fd_pr__pfet_01v8_hvt ad=0.08775 pd=0.84 as=0.16875 ps=1.65 w=0.45 l=0.15
X1 a_2985_36# a_1977_36# VGND VNB sky130_fd_pr__nfet_01v8 ad=0.16875 pd=1.65 as=0.16875 ps=1.65 w=0.45 l=0.15
X2 a_141_36# CLK VPWR VPB sky130_fd_pr__pfet_01v8_hvt ad=0.23625 pd=2.01 as=0.23625 ps=2.01 w=0.63 l=0.15
X3 a_645_36# D VGND VNB sky130_fd_pr__nfet_01v8 ad=0.13702 pd=1.2 as=0.23625 ps=2.01 w=0.63 l=0.15
X4 a_789_36# a_393_36# a_645_36# VPB sky130_fd_pr__pfet_01v8_hvt ad=0.20925 pd=1.38 as=0.17415 ps=1.38 w=0.45 l=0.15
X5 VPWR SET_B a_1137_171# VPB sky130_fd_pr__pfet_01v8_hvt ad=0.16875 pd=1.65 as=0.08775 ps=0.84 w=0.45 l=0.15
X6 a_1869_36# a_789_36# VGND VNB sky130_fd_pr__nfet_01v8 ad=0.08775 pd=0.84 as=0.16875 ps=1.65 w=0.45 l=0.15
X7 a_1977_36# a_393_36# a_1869_36# VNB sky130_fd_pr__nfet_01v8 ad=0.20925 pd=1.38 as=0.08775 ps=0.84 w=0.45 l=0.15
X8 a_645_36# D VPWR VPB sky130_fd_pr__pfet_01v8_hvt ad=0.17415 pd=1.38 as=0.30375 ps=2.37 w=0.81 l=0.15
X9 a_2985_36# a_1977_36# VPWR VPB sky130_fd_pr__pfet_01v8_hvt ad=0.23625 pd=2.01 as=0.23625 ps=2.01 w=0.63 l=0.15
X10 VPWR a_1137_171# a_1005_450# VPB sky130_fd_pr__pfet_01v8_hvt ad=0.16875 pd=1.65 as=0.16875 ps=1.2 w=0.45 l=0.15
X11 a_1005_450# a_141_36# a_789_36# VPB sky130_fd_pr__pfet_01v8_hvt ad=0.16875 pd=1.2 as=0.20925 ps=1.38 w=0.45 l=0.15
X12 VPWR a_2325_171# a_2193_450# VPB sky130_fd_pr__pfet_01v8_hvt ad=0.08775 pd=0.84 as=0.16875 ps=1.2 w=0.45 l=0.15
X13 a_2193_36# a_141_36# a_1977_36# VNB sky130_fd_pr__nfet_01v8 ad=0.16875 pd=1.2 as=0.20925 ps=1.38 w=0.45 l=0.15
X14 a_1005_36# a_393_36# a_789_36# VNB sky130_fd_pr__special_nfet_01v8 ad=0.15593 pd=1.2 as=0.1674 ps=1.29 w=0.36 l=0.15
X15 VGND a_1137_171# a_1005_36# VNB sky130_fd_pr__nfet_01v8 ad=0.16875 pd=1.65 as=0.15593 ps=1.2 w=0.45 l=0.15
X16 a_1869_450# a_789_36# VPWR VPB sky130_fd_pr__pfet_01v8_hvt ad=0.08775 pd=0.84 as=0.16875 ps=1.65 w=0.45 l=0.15
X17 a_2193_450# a_393_36# a_1977_36# VPB sky130_fd_pr__pfet_01v8_hvt ad=0.16875 pd=1.2 as=0.20925 ps=1.38 w=0.45 l=0.15
X18 a_1977_36# SET_B VPWR VPB sky130_fd_pr__pfet_01v8_hvt ad=0.16875 pd=1.65 as=0.08775 ps=0.84 w=0.45 l=0.15
X19 a_789_36# a_141_36# a_645_36# VNB sky130_fd_pr__special_nfet_01v8 ad=0.1674 pd=1.29 as=0.13702 ps=1.2 w=0.36 l=0.15
X20 a_141_36# CLK VGND VNB sky130_fd_pr__nfet_01v8 ad=0.16875 pd=1.65 as=0.16875 ps=1.65 w=0.45 l=0.15
X21 a_2373_36# a_2325_171# a_2193_36# VNB sky130_fd_pr__nfet_01v8 ad=0.08775 pd=0.84 as=0.16875 ps=1.2 w=0.45 l=0.15
X22 VGND SET_B a_2373_36# VNB sky130_fd_pr__nfet_01v8 ad=0.16875 pd=1.65 as=0.08775 ps=0.84 w=0.45 l=0.15
X23 a_1977_36# a_141_36# a_1869_450# VPB sky130_fd_pr__pfet_01v8_hvt ad=0.20925 pd=1.38 as=0.08775 ps=0.84 w=0.45 l=0.15
X24 a_393_36# a_141_36# VPWR VPB sky130_fd_pr__pfet_01v8_hvt ad=0.23625 pd=2.01 as=0.23625 ps=2.01 w=0.63 l=0.15
X25 a_2325_171# a_1977_36# VPWR VPB sky130_fd_pr__pfet_01v8_hvt ad=0.30375 pd=2.37 as=0.30375 ps=2.37 w=0.81 l=0.15
X26 Q a_2985_36# VGND VNB sky130_fd_pr__nfet_01v8 ad=0.23625 pd=2.01 as=0.23625 ps=2.01 w=0.63 l=0.15
X27 a_1437_36# a_789_36# a_1137_171# VNB sky130_fd_pr__nfet_01v8 ad=0.08775 pd=0.84 as=0.16875 ps=1.65 w=0.45 l=0.15
X28 VGND SET_B a_1437_36# VNB sky130_fd_pr__nfet_01v8 ad=0.16875 pd=1.65 as=0.08775 ps=0.84 w=0.45 l=0.15
X29 Q a_2985_36# VPWR VPB sky130_fd_pr__pfet_01v8_hvt ad=0.405 pd=2.91 as=0.405 ps=2.91 w=1.08 l=0.15
X30 a_2325_171# a_1977_36# VGND VNB sky130_fd_pr__nfet_01v8 ad=0.2025 pd=1.83 as=0.2025 ps=1.83 w=0.54 l=0.15
X31 a_393_36# a_141_36# VGND VNB sky130_fd_pr__nfet_01v8 ad=0.16875 pd=1.65 as=0.16875 ps=1.65 w=0.45 l=0.15
C0 a_1977_36# a_2373_36# 0.00188f
C1 a_393_36# a_789_36# 0.25128f
C2 a_1005_450# VPWR 0.0225f
C3 D VPB 0.08736f
C4 a_645_36# VPWR 0.11347f
C5 VGND Q 0.10221f
C6 a_393_36# SET_B 0.18256f
C7 VGND a_2373_36# 0.01143f
C8 a_393_36# a_141_36# 1.24978f
C9 a_1977_36# VPB 0.30084f
C10 a_2325_171# VPWR 0.16682f
C11 a_1977_36# a_789_36# 0.00188f
C13 a_141_36# D 0.05442f
C14 a_1137_171# VPB 0.16003f
C15 a_2325_171# a_2985_36# 0.03531f
C16 a_789_36# a_1137_171# 0.31798f
C17 a_2985_36# VPWR 0.22976f
C18 SET_B a_2193_36# 0.00169f
C19 a_141_36# a_2193_36# 0.00422f
C20 VGND VPB 0.04941f
C21 a_393_36# a_1005_36# 0.00712f
C22 a_1977_36# SET_B 0.17698f
C23 a_393_36# a_645_36# 0.06208f
C24 a_789_36# VGND 0.16626f
C25 a_1977_36# a_141_36# 0.16395f
C27 a_1137_171# SET_B 0.05571f
C28 a_1137_171# a_141_36# 0.10794f
C29 CLK VPB 0.09785f
C30 a_645_36# D 0.05765f
C31 a_393_36# a_2325_171# 0.02269f
C32 SET_B VGND 0.06764f
C33 a_141_36# VGND 0.31627f
C34 a_393_36# VPWR 0.1838f
C35 SET_B a_1869_450# 0.00455f
C36 a_1437_36# a_789_36# 0.00294f
C41 a_141_36# CLK 0.09923f
C42 D VPWR 0.0516f
C43 a_1005_36# a_1137_171# 0.00182f
C44 a_2325_171# a_2193_36# 0.00158f
C45 a_1005_36# VGND 0.01995f
C46 Q VPB 0.01435f
C47 a_645_36# VGND 0.09765f
C48 a_1977_36# a_2325_171# 0.25889f
C49 a_1977_36# VPWR 0.31101f
C50 a_1977_36# a_2985_36# 0.067f
C51 a_1137_171# VPWR 0.21437f
C52 a_2193_450# SET_B 0.00876f
C53 a_2325_171# VGND 0.23586f
C54 VGND VPWR 0.12695f
C57 a_393_36# D 0.06896f
C58 SET_B a_2373_36# 0.00142f
C59 a_1869_450# VPWR 0.01083f
C60 a_2985_36# VGND 0.18408f
C61 a_789_36# VPB 0.24553f
C62 CLK VPWR 0.04196f
C63 a_393_36# a_1977_36# 0.12536f
C64 a_393_36# a_1137_171# 0.1153f
C66 SET_B VPB 0.31464f
C67 a_141_36# VPB 0.47373f
C68 a_789_36# SET_B 0.2062f
C69 a_789_36# a_141_36# 0.33311f
C70 a_393_36# VGND 0.64998f
C71 a_1977_36# a_2193_36# 0.01122f
C73 a_2193_450# VPWR 0.01954f
C74 VGND D 0.04181f
C76 Q VPWR 0.13857f
C77 a_2325_171# a_2373_36# 0.00509f
C78 a_141_36# SET_B 0.09697f
C79 a_789_36# a_1005_450# 0.01115f
C81 a_645_36# VPB 0.01874f
C82 a_2985_36# Q 0.07073f
C83 VGND a_2193_36# 0.01833f
C84 a_1005_36# a_789_36# 0.01032f
C85 a_789_36# a_645_36# 0.04067f
C86 a_393_36# a_1437_36# 0.00304f
C87 a_393_36# a_1869_36# 0.00323f
C88 a_1977_36# VGND 0.15355f
C89 a_1977_36# a_1869_450# 0.00277f
C91 a_141_36# a_1005_450# 0.0071f
C92 a_1137_171# VGND 0.14853f
C93 a_2325_171# VPB 0.10947f
C94 VPWR VPB 0.74953f
C96 a_141_36# a_645_36# 0.11337f
C97 a_393_36# a_2193_450# 0.00194f
C98 a_789_36# VPWR 0.13891f
C99 a_2985_36# VPB 0.09198f
C102 a_1977_36# a_1869_36# 0.00267f
C103 VGND CLK 0.04537f
C104 a_2325_171# SET_B 0.12029f
C105 a_141_36# a_2325_171# 0.04768f
C106 a_1437_36# a_1137_171# 0.00469f
C107 SET_B VPWR 0.58001f
C108 a_141_36# VPWR 0.58649f
C109 a_2985_36# SET_B 0.00107f
C111 a_1977_36# a_2193_450# 0.01125f
C112 a_1437_36# VGND 0.01236f
C113 a_1869_36# VGND 0.01236f
C114 a_393_36# VPB 0.31051f
C116 Q VNB 0.10703f
C117 VGND VNB 2.12866f
C118 VPWR VNB 1.44523f
C119 SET_B VNB 0.23004f
C120 D VNB 0.12037f
C121 CLK VNB 0.19841f
C122 VPB VNB 4.02019f
C123 a_645_36# VNB 0.02229f
C124 a_2985_36# VNB 0.18599f
C125 a_1977_36# VNB 0.36389f
C126 a_2325_171# VNB 0.16072f
C127 a_789_36# VNB 0.31694f
C128 a_1137_171# VNB 0.16766f
C129 a_393_36# VNB 0.42112f
C130 a_141_36# VNB 0.59336f
.ends

.subckt sky130_efx_lvdig__dfstp_2 CLK D SET_B Q VGND VNB VPB VPWR
X0 a_1137_171# a_789_36# VPWR VPB sky130_fd_pr__pfet_01v8_hvt ad=0.08775 pd=0.84 as=0.16875 ps=1.65 w=0.45 l=0.15
X1 nmos_n3f5_f1_l150_0.D0 a_1977_36# VGND VNB sky130_fd_pr__nfet_01v8 ad=0.23625 pd=2.01 as=0.23625 ps=2.01 w=0.63 l=0.15
X2 a_141_36# CLK VPWR VPB sky130_fd_pr__pfet_01v8_hvt ad=0.23625 pd=2.01 as=0.23625 ps=2.01 w=0.63 l=0.15
X3 a_645_36# D VGND VNB sky130_fd_pr__nfet_01v8 ad=0.13702 pd=1.2 as=0.23625 ps=2.01 w=0.63 l=0.15
X4 a_789_36# a_393_36# a_645_36# VPB sky130_fd_pr__pfet_01v8_hvt ad=0.20925 pd=1.38 as=0.17415 ps=1.38 w=0.45 l=0.15
X5 VPWR SET_B a_1137_171# VPB sky130_fd_pr__pfet_01v8_hvt ad=0.16875 pd=1.65 as=0.08775 ps=0.84 w=0.45 l=0.15
X6 a_1869_36# a_789_36# VGND VNB sky130_fd_pr__nfet_01v8 ad=0.08775 pd=0.84 as=0.16875 ps=1.65 w=0.45 l=0.15
X7 a_1977_36# a_393_36# a_1869_36# VNB sky130_fd_pr__nfet_01v8 ad=0.20925 pd=1.38 as=0.08775 ps=0.84 w=0.45 l=0.15
X8 a_645_36# D VPWR VPB sky130_fd_pr__pfet_01v8_hvt ad=0.17415 pd=1.38 as=0.30375 ps=2.37 w=0.81 l=0.15
X9 nmos_n3f5_f1_l150_0.D0 a_1977_36# VPWR VPB sky130_fd_pr__pfet_01v8_hvt ad=0.405 pd=2.91 as=0.405 ps=2.91 w=1.08 l=0.15
X10 VPWR a_1137_171# a_1005_450# VPB sky130_fd_pr__pfet_01v8_hvt ad=0.16875 pd=1.65 as=0.16875 ps=1.2 w=0.45 l=0.15
X11 a_1005_450# a_141_36# a_789_36# VPB sky130_fd_pr__pfet_01v8_hvt ad=0.16875 pd=1.2 as=0.20925 ps=1.38 w=0.45 l=0.15
X12 VPWR a_2325_171# a_2193_450# VPB sky130_fd_pr__pfet_01v8_hvt ad=0.08775 pd=0.84 as=0.16875 ps=1.2 w=0.45 l=0.15
X13 a_2193_36# a_141_36# a_1977_36# VNB sky130_fd_pr__nfet_01v8 ad=0.16875 pd=1.2 as=0.20925 ps=1.38 w=0.45 l=0.15
X14 a_1005_36# a_393_36# a_789_36# VNB sky130_fd_pr__special_nfet_01v8 ad=0.15593 pd=1.2 as=0.1674 ps=1.29 w=0.36 l=0.15
X15 VGND a_1137_171# a_1005_36# VNB sky130_fd_pr__nfet_01v8 ad=0.16875 pd=1.65 as=0.15593 ps=1.2 w=0.45 l=0.15
X16 a_1869_450# a_789_36# VPWR VPB sky130_fd_pr__pfet_01v8_hvt ad=0.08775 pd=0.84 as=0.16875 ps=1.65 w=0.45 l=0.15
X17 a_2193_450# a_393_36# a_1977_36# VPB sky130_fd_pr__pfet_01v8_hvt ad=0.16875 pd=1.2 as=0.20925 ps=1.38 w=0.45 l=0.15
X18 a_1977_36# SET_B VPWR VPB sky130_fd_pr__pfet_01v8_hvt ad=0.16875 pd=1.65 as=0.08775 ps=0.84 w=0.45 l=0.15
X19 a_789_36# a_141_36# a_645_36# VNB sky130_fd_pr__special_nfet_01v8 ad=0.1674 pd=1.29 as=0.13702 ps=1.2 w=0.36 l=0.15
X20 a_141_36# CLK VGND VNB sky130_fd_pr__nfet_01v8 ad=0.16875 pd=1.65 as=0.16875 ps=1.65 w=0.45 l=0.15
X21 a_2373_36# a_2325_171# a_2193_36# VNB sky130_fd_pr__nfet_01v8 ad=0.08775 pd=0.84 as=0.16875 ps=1.2 w=0.45 l=0.15
X22 VGND SET_B a_2373_36# VNB sky130_fd_pr__nfet_01v8 ad=0.16875 pd=1.65 as=0.08775 ps=0.84 w=0.45 l=0.15
X23 a_1977_36# a_141_36# a_1869_450# VPB sky130_fd_pr__pfet_01v8_hvt ad=0.20925 pd=1.38 as=0.08775 ps=0.84 w=0.45 l=0.15
X24 a_393_36# a_141_36# VPWR VPB sky130_fd_pr__pfet_01v8_hvt ad=0.23625 pd=2.01 as=0.23625 ps=2.01 w=0.63 l=0.15
X25 a_2325_171# a_1977_36# VPWR VPB sky130_fd_pr__pfet_01v8_hvt ad=0.30375 pd=2.37 as=0.30375 ps=2.37 w=0.81 l=0.15
X26 Q nmos_n3f5_f1_l150_0.D0 VGND VNB sky130_fd_pr__nfet_01v8 ad=0.12285 pd=1.02 as=0.23625 ps=2.01 w=0.63 l=0.15
X27 VGND nmos_n3f5_f1_l150_0.D0 Q VNB sky130_fd_pr__nfet_01v8 ad=0.23625 pd=2.01 as=0.12285 ps=1.02 w=0.63 l=0.15
X28 a_1437_36# a_789_36# a_1137_171# VNB sky130_fd_pr__nfet_01v8 ad=0.08775 pd=0.84 as=0.16875 ps=1.65 w=0.45 l=0.15
X29 VGND SET_B a_1437_36# VNB sky130_fd_pr__nfet_01v8 ad=0.16875 pd=1.65 as=0.08775 ps=0.84 w=0.45 l=0.15
X30 Q nmos_n3f5_f1_l150_0.D0 VPWR VPB sky130_fd_pr__pfet_01v8_hvt ad=0.2106 pd=1.47 as=0.405 ps=2.91 w=1.08 l=0.15
X31 a_2325_171# a_1977_36# VGND VNB sky130_fd_pr__nfet_01v8 ad=0.2025 pd=1.83 as=0.2025 ps=1.83 w=0.54 l=0.15
X32 a_393_36# a_141_36# VGND VNB sky130_fd_pr__nfet_01v8 ad=0.16875 pd=1.65 as=0.16875 ps=1.65 w=0.45 l=0.15
X33 VPWR nmos_n3f5_f1_l150_0.D0 Q VPB sky130_fd_pr__pfet_01v8_hvt ad=0.405 pd=2.91 as=0.2106 ps=1.47 w=1.08 l=0.15
C1 a_1977_36# a_2193_36# 0.01122f
C3 a_141_36# VPWR 0.58649f
C4 a_1005_36# VGND 0.01995f
C7 a_2325_171# nmos_n3f5_f1_l150_0.D0 0.01986f
C9 a_393_36# VPB 0.31051f
C10 SET_B VPWR 0.58108f
C11 a_1977_36# a_2325_171# 0.25568f
C12 a_645_36# VPWR 0.11347f
C13 a_393_36# a_1437_36# 0.00304f
C14 Q VGND 0.15357f
C15 a_2325_171# a_2193_36# 0.00158f
C16 VGND VPWR 0.15021f
C17 a_789_36# a_393_36# 0.25128f
C18 CLK VPB 0.09785f
C19 VGND a_1869_36# 0.01236f
C20 a_393_36# a_141_36# 1.24978f
C21 a_2193_450# VPWR 0.01954f
C22 SET_B a_2373_36# 0.00142f
C23 a_393_36# SET_B 0.18256f
C24 nmos_n3f5_f1_l150_0.D0 VPB 0.12483f
C25 a_393_36# a_645_36# 0.06208f
C26 a_141_36# CLK 0.09923f
C27 VGND a_2373_36# 0.01143f
C28 a_1005_450# VPWR 0.0225f
C29 a_1977_36# VPB 0.25526f
C30 a_393_36# VGND 0.64998f
C31 Q VPWR 0.22627f
C35 a_2193_450# a_393_36# 0.00194f
C36 a_393_36# a_1005_36# 0.00712f
C37 a_789_36# a_1977_36# 0.00188f
C39 a_1137_171# VPB 0.16003f
C40 VGND CLK 0.04537f
C41 VPB D 0.08736f
C42 a_141_36# a_1977_36# 0.16395f
C43 a_1137_171# a_1437_36# 0.00469f
C44 SET_B nmos_n3f5_f1_l150_0.D0 0.00143f
C45 a_2325_171# VPB 0.10661f
C46 a_1869_450# SET_B 0.00455f
C47 a_1977_36# SET_B 0.17513f
C49 a_789_36# a_1137_171# 0.31798f
C50 a_141_36# a_2193_36# 0.00422f
C51 a_393_36# VPWR 0.1838f
C52 VGND nmos_n3f5_f1_l150_0.D0 0.22602f
C53 a_141_36# a_1137_171# 0.10794f
C54 a_393_36# a_1869_36# 0.00323f
C55 a_141_36# D 0.05442f
C56 SET_B a_2193_36# 0.00169f
C58 a_1977_36# VGND 0.15768f
C59 a_141_36# a_2325_171# 0.04768f
C60 a_1137_171# SET_B 0.05571f
C62 CLK VPWR 0.04196f
C63 VGND a_2193_36# 0.01833f
C64 a_2193_450# a_1977_36# 0.01125f
C65 a_645_36# D 0.05765f
C66 a_2325_171# SET_B 0.12029f
C67 a_1137_171# VGND 0.14853f
C68 VGND D 0.04181f
C69 Q nmos_n3f5_f1_l150_0.D0 0.1198f
C70 a_2325_171# VGND 0.24504f
C71 nmos_n3f5_f1_l150_0.D0 VPWR 0.29706f
C72 a_1005_36# a_1137_171# 0.00182f
C74 a_1869_450# VPWR 0.01083f
C75 a_1977_36# VPWR 0.32078f
C76 a_789_36# VPB 0.24553f
C77 a_1977_36# a_1869_36# 0.00267f
C79 a_141_36# VPB 0.47374f
C81 a_789_36# a_1437_36# 0.00294f
C82 a_1137_171# VPWR 0.21437f
C83 SET_B VPB 0.31395f
C84 VPWR D 0.0516f
C85 a_645_36# VPB 0.01874f
C87 a_789_36# a_141_36# 0.33311f
C88 a_1977_36# a_2373_36# 0.00188f
C89 a_2325_171# VPWR 0.18977f
C91 a_393_36# a_1977_36# 0.12536f
C92 VGND VPB 0.04497f
C93 a_789_36# SET_B 0.2062f
C94 a_789_36# a_645_36# 0.04067f
C95 VGND a_1437_36# 0.01236f
C96 a_141_36# SET_B 0.09697f
C97 a_141_36# a_645_36# 0.11337f
C98 a_789_36# VGND 0.16626f
C99 a_393_36# a_1137_171# 0.1153f
C100 a_393_36# D 0.06896f
C101 a_2325_171# a_2373_36# 0.00509f
C102 a_141_36# VGND 0.31631f
C104 a_393_36# a_2325_171# 0.02269f
C105 a_789_36# a_1005_36# 0.01032f
C106 Q VPB 0.00762f
C107 VGND SET_B 0.06773f
C108 VPWR VPB 0.75738f
C109 a_1977_36# nmos_n3f5_f1_l150_0.D0 0.06155f
C110 VGND a_645_36# 0.09765f
C111 a_1869_450# a_1977_36# 0.00277f
C112 a_789_36# a_1005_450# 0.01115f
C113 a_2193_450# SET_B 0.00876f
C114 a_141_36# a_1005_450# 0.0071f
C115 a_789_36# VPWR 0.13891f
C116 Q VNB 0.03684f
C117 VGND VNB 2.19062f
C118 VPWR VNB 1.51109f
C119 SET_B VNB 0.23064f
C120 D VNB 0.12037f
C121 CLK VNB 0.19841f
C122 VPB VNB 4.10573f
C123 a_645_36# VNB 0.02229f
C124 nmos_n3f5_f1_l150_0.D0 VNB 0.26959f
C125 a_1977_36# VNB 0.34185f
C126 a_2325_171# VNB 0.15957f
C127 a_789_36# VNB 0.31694f
C128 a_1137_171# VNB 0.16766f
C129 a_393_36# VNB 0.42111f
C130 a_141_36# VNB 0.59311f
.ends

.subckt sky130_efx_lvdig__dfxbp_2 CLK D Q Q_N VGND VNB VPB VPWR
X0 VGND a_1736_165# a_1617_36# VNB sky130_fd_pr__nfet_01v8 ad=0.1134 pd=1.02 as=0.15593 ps=1.2 w=0.45 l=0.15
X1 a_1736_165# a_1401_36# VGND VNB sky130_fd_pr__nfet_01v8 ad=0.23625 pd=2.01 as=0.1134 ps=1.02 w=0.63 l=0.15
X2 a_969_450# a_141_36# a_753_36# VPB sky130_fd_pr__pfet_01v8_hvt ad=0.16875 pd=1.2 as=0.20925 ps=1.38 w=0.45 l=0.15
X3 VPWR a_1088_165# a_969_450# VPB sky130_fd_pr__pfet_01v8_hvt ad=0.12622 pd=1.11 as=0.16875 ps=1.2 w=0.45 l=0.15
X4 Q_N a_2517_36# VPWR VPB sky130_fd_pr__pfet_01v8_hvt ad=0.2106 pd=1.47 as=0.405 ps=2.91 w=1.08 l=0.15
X5 a_141_36# CLK VPWR VPB sky130_fd_pr__pfet_01v8_hvt ad=0.23625 pd=2.01 as=0.23625 ps=2.01 w=0.63 l=0.15
X6 a_645_36# D VGND VNB sky130_fd_pr__nfet_01v8 ad=0.08258 pd=0.84 as=0.16875 ps=1.65 w=0.45 l=0.15
X7 a_753_36# a_141_36# a_645_36# VNB sky130_fd_pr__special_nfet_01v8 ad=0.1674 pd=1.29 as=0.08258 ps=0.84 w=0.36 l=0.15
X8 Q_N a_2517_36# VGND VNB sky130_fd_pr__nfet_01v8 ad=0.12285 pd=1.02 as=0.23625 ps=2.01 w=0.63 l=0.15
X9 VGND a_2517_36# Q_N VNB sky130_fd_pr__nfet_01v8 ad=0.23625 pd=2.01 as=0.12285 ps=1.02 w=0.63 l=0.15
X10 VPWR a_2517_36# Q_N VPB sky130_fd_pr__pfet_01v8_hvt ad=0.405 pd=2.91 as=0.2106 ps=1.47 w=1.08 l=0.15
X11 a_1088_165# a_753_36# VPWR VPB sky130_fd_pr__pfet_01v8_hvt ad=0.16267 pd=1.29 as=0.12622 ps=1.11 w=0.72 l=0.15
X12 a_1736_165# a_1401_36# VPWR VPB sky130_fd_pr__pfet_01v8_hvt ad=0.405 pd=2.91 as=0.17752 ps=1.47 w=1.08 l=0.15
X13 a_2517_36# a_1736_165# VPWR VPB sky130_fd_pr__pfet_01v8_hvt ad=0.23625 pd=2.01 as=0.23625 ps=2.01 w=0.63 l=0.15
X14 a_1401_36# a_393_36# a_1088_165# VNB sky130_fd_pr__special_nfet_01v8 ad=0.1674 pd=1.29 as=0.13702 ps=1.2 w=0.36 l=0.15
X15 a_1401_36# a_141_36# a_1088_165# VPB sky130_fd_pr__pfet_01v8_hvt ad=0.20925 pd=1.38 as=0.16267 ps=1.29 w=0.45 l=0.15
X16 a_141_36# CLK VGND VNB sky130_fd_pr__nfet_01v8 ad=0.16875 pd=1.65 as=0.16875 ps=1.65 w=0.45 l=0.15
X17 Q a_1736_165# VGND VNB sky130_fd_pr__nfet_01v8 ad=0.12285 pd=1.02 as=0.23625 ps=2.01 w=0.63 l=0.15
X18 VGND a_1736_165# Q VNB sky130_fd_pr__nfet_01v8 ad=0.23625 pd=2.01 as=0.12285 ps=1.02 w=0.63 l=0.15
X19 a_393_36# a_141_36# VPWR VPB sky130_fd_pr__pfet_01v8_hvt ad=0.23625 pd=2.01 as=0.23625 ps=2.01 w=0.63 l=0.15
X20 a_969_36# a_393_36# a_753_36# VNB sky130_fd_pr__special_nfet_01v8 ad=0.15593 pd=1.2 as=0.1674 ps=1.29 w=0.36 l=0.15
X21 VGND a_1088_165# a_969_36# VNB sky130_fd_pr__nfet_01v8 ad=0.1134 pd=1.02 as=0.15593 ps=1.2 w=0.45 l=0.15
X22 a_1088_165# a_753_36# VGND VNB sky130_fd_pr__nfet_01v8 ad=0.13702 pd=1.2 as=0.1134 ps=1.02 w=0.63 l=0.15
X23 VPWR a_1736_165# a_1617_450# VPB sky130_fd_pr__pfet_01v8_hvt ad=0.17752 pd=1.47 as=0.16875 ps=1.2 w=0.45 l=0.15
X24 a_1617_450# a_393_36# a_1401_36# VPB sky130_fd_pr__pfet_01v8_hvt ad=0.16875 pd=1.2 as=0.20925 ps=1.38 w=0.45 l=0.15
X25 a_645_36# D VPWR VPB sky130_fd_pr__pfet_01v8_hvt ad=0.08775 pd=0.84 as=0.16875 ps=1.65 w=0.45 l=0.15
X26 Q a_1736_165# VPWR VPB sky130_fd_pr__pfet_01v8_hvt ad=0.2106 pd=1.47 as=0.405 ps=2.91 w=1.08 l=0.15
X27 a_753_36# a_393_36# a_645_36# VPB sky130_fd_pr__pfet_01v8_hvt ad=0.20925 pd=1.38 as=0.08775 ps=0.84 w=0.45 l=0.15
X28 a_393_36# a_141_36# VGND VNB sky130_fd_pr__nfet_01v8 ad=0.16875 pd=1.65 as=0.16875 ps=1.65 w=0.45 l=0.15
X29 a_2517_36# a_1736_165# VGND VNB sky130_fd_pr__nfet_01v8 ad=0.16875 pd=1.65 as=0.16875 ps=1.65 w=0.45 l=0.15
X30 VPWR a_1736_165# Q VPB sky130_fd_pr__pfet_01v8_hvt ad=0.405 pd=2.91 as=0.2106 ps=1.47 w=1.08 l=0.15
X31 a_1617_36# a_141_36# a_1401_36# VNB sky130_fd_pr__special_nfet_01v8 ad=0.15593 pd=1.2 as=0.1674 ps=1.29 w=0.36 l=0.15
C1 a_141_36# a_1088_165# 0.09882f
C2 CLK VGND 0.04537f
C3 a_1736_165# a_141_36# 0.05641f
C4 VPWR Q 0.22627f
C5 VPWR a_393_36# 0.23676f
C6 a_645_36# VPWR 0.08042f
C7 VGND VPWR 0.19171f
C8 a_1401_36# a_1617_36# 0.00965f
C10 VPB a_141_36# 0.46609f
C11 D VPB 0.11625f
C13 a_753_36# a_969_450# 0.01125f
C14 CLK VPWR 0.04196f
C15 a_753_36# a_141_36# 0.21485f
C16 a_2517_36# Q_N 0.1198f
C17 a_1617_36# VGND 0.01995f
C18 a_1401_36# a_141_36# 0.16214f
C19 VPB Q_N 0.00808f
C21 a_141_36# a_393_36# 0.91413f
C22 a_645_36# a_141_36# 0.15126f
C23 D a_393_36# 0.09861f
C24 a_645_36# D 0.06045f
C25 VGND a_141_36# 0.31443f
C26 a_1617_36# VPWR 0.0012f
C27 D VGND 0.03533f
C28 CLK a_141_36# 0.09922f
C30 a_969_450# VPWR 0.0225f
C31 VGND Q_N 0.15357f
C32 VPWR a_141_36# 0.53956f
C33 D VPWR 0.03564f
C34 a_2517_36# a_1736_165# 0.06974f
C35 VPB a_1088_165# 0.11761f
C36 a_1736_165# VPB 0.38042f
C37 a_753_36# a_1088_165# 0.2195f
C38 a_969_36# a_1088_165# 0.00294f
C39 a_2517_36# VPB 0.1389f
C40 VPWR Q_N 0.22627f
C41 a_1401_36# a_1088_165# 0.04489f
C42 a_1401_36# a_1736_165# 0.22982f
C43 a_1617_36# a_141_36# 0.00331f
C44 a_753_36# VPB 0.10487f
C45 a_393_36# a_1088_165# 0.23777f
C46 a_1736_165# Q 0.13235f
C47 a_1736_165# a_393_36# 0.03107f
C48 a_1401_36# VPB 0.08098f
C49 VGND a_1088_165# 0.1446f
C50 a_1736_165# VGND 0.33199f
C51 a_969_450# a_141_36# 0.00743f
C52 a_753_36# a_969_36# 0.00965f
C53 D a_141_36# 0.07887f
C54 a_2517_36# Q 0.01307f
C56 VPB Q 0.00889f
C57 a_2517_36# VGND 0.21597f
C58 VPB a_393_36# 0.2897f
C59 a_645_36# VPB 0.02422f
C60 a_1401_36# a_1617_450# 0.01125f
C61 VPB VGND 0.04665f
C62 VPWR a_1088_165# 0.10157f
C63 a_753_36# a_393_36# 0.18653f
C64 a_645_36# a_753_36# 0.04498f
C65 a_1736_165# VPWR 0.32899f
C67 a_753_36# VGND 0.08895f
C68 a_969_36# a_393_36# 0.00712f
C69 a_1401_36# a_393_36# 0.13691f
C70 a_1617_450# a_393_36# 0.00381f
C71 a_969_36# VGND 0.01995f
C72 VPB CLK 0.09785f
C73 a_1401_36# VGND 0.09505f
C74 a_2517_36# VPWR 0.27185f
C75 a_1617_450# VGND 0.00122f
C76 VPB VPWR 0.66289f
C78 a_645_36# a_393_36# 0.07535f
C79 a_753_36# VPWR 0.11659f
C80 a_1617_36# a_1736_165# 0.00305f
C81 VGND Q 0.15357f
C82 VGND a_393_36# 0.44778f
C83 a_645_36# VGND 0.07973f
C84 a_1401_36# VPWR 0.12438f
C85 a_1617_450# VPWR 0.0225f
C86 Q_N VNB 0.03639f
C87 Q VNB 0.01272f
C88 VGND VNB 1.91424f
C89 VPWR VNB 1.34543f
C90 D VNB 0.13204f
C91 CLK VNB 0.19841f
C92 VPB VNB 3.59251f
C93 a_645_36# VNB 0.02294f
C94 a_2517_36# VNB 0.27373f
C95 a_1401_36# VNB 0.12934f
C96 a_1736_165# VNB 0.56549f
C97 a_753_36# VNB 0.12466f
C98 a_1088_165# VNB 0.13891f
C99 a_393_36# VNB 0.38818f
C100 a_141_36# VNB 0.58182f
.ends

.subckt sky130_efx_lvdig__dfxtp_2 CLK D Q VGND VNB VPB VPWR
X0 VGND a_1736_165# a_1617_36# VNB sky130_fd_pr__nfet_01v8 ad=0.1134 pd=1.02 as=0.15593 ps=1.2 w=0.45 l=0.15
X1 a_1736_165# a_1401_36# VGND VNB sky130_fd_pr__nfet_01v8 ad=0.23625 pd=2.01 as=0.1134 ps=1.02 w=0.63 l=0.15
X2 a_969_450# a_141_36# a_753_36# VPB sky130_fd_pr__pfet_01v8_hvt ad=0.16875 pd=1.2 as=0.20925 ps=1.38 w=0.45 l=0.15
X3 VPWR a_1088_165# a_969_450# VPB sky130_fd_pr__pfet_01v8_hvt ad=0.12622 pd=1.11 as=0.16875 ps=1.2 w=0.45 l=0.15
X4 a_141_36# CLK VPWR VPB sky130_fd_pr__pfet_01v8_hvt ad=0.23625 pd=2.01 as=0.23625 ps=2.01 w=0.63 l=0.15
X5 a_645_36# D VGND VNB sky130_fd_pr__nfet_01v8 ad=0.08258 pd=0.84 as=0.16875 ps=1.65 w=0.45 l=0.15
X6 a_753_36# a_141_36# a_645_36# VNB sky130_fd_pr__special_nfet_01v8 ad=0.1674 pd=1.29 as=0.08258 ps=0.84 w=0.36 l=0.15
X7 a_1088_165# a_753_36# VPWR VPB sky130_fd_pr__pfet_01v8_hvt ad=0.16267 pd=1.29 as=0.12622 ps=1.11 w=0.72 l=0.15
X8 a_1736_165# a_1401_36# VPWR VPB sky130_fd_pr__pfet_01v8_hvt ad=0.405 pd=2.91 as=0.17752 ps=1.47 w=1.08 l=0.15
X9 a_1401_36# a_393_36# a_1088_165# VNB sky130_fd_pr__special_nfet_01v8 ad=0.1674 pd=1.29 as=0.13702 ps=1.2 w=0.36 l=0.15
X10 a_1401_36# a_141_36# a_1088_165# VPB sky130_fd_pr__pfet_01v8_hvt ad=0.20925 pd=1.38 as=0.16267 ps=1.29 w=0.45 l=0.15
X11 a_141_36# CLK VGND VNB sky130_fd_pr__nfet_01v8 ad=0.16875 pd=1.65 as=0.16875 ps=1.65 w=0.45 l=0.15
X12 Q a_1736_165# VGND VNB sky130_fd_pr__nfet_01v8 ad=0.12285 pd=1.02 as=0.23625 ps=2.01 w=0.63 l=0.15
X13 VGND a_1736_165# Q VNB sky130_fd_pr__nfet_01v8 ad=0.23625 pd=2.01 as=0.12285 ps=1.02 w=0.63 l=0.15
X14 a_393_36# a_141_36# VPWR VPB sky130_fd_pr__pfet_01v8_hvt ad=0.23625 pd=2.01 as=0.23625 ps=2.01 w=0.63 l=0.15
X15 a_969_36# a_393_36# a_753_36# VNB sky130_fd_pr__special_nfet_01v8 ad=0.15593 pd=1.2 as=0.1674 ps=1.29 w=0.36 l=0.15
X16 VGND a_1088_165# a_969_36# VNB sky130_fd_pr__nfet_01v8 ad=0.1134 pd=1.02 as=0.15593 ps=1.2 w=0.45 l=0.15
X17 a_1088_165# a_753_36# VGND VNB sky130_fd_pr__nfet_01v8 ad=0.13702 pd=1.2 as=0.1134 ps=1.02 w=0.63 l=0.15
X18 VPWR a_1736_165# a_1617_450# VPB sky130_fd_pr__pfet_01v8_hvt ad=0.17752 pd=1.47 as=0.16875 ps=1.2 w=0.45 l=0.15
X19 a_1617_450# a_393_36# a_1401_36# VPB sky130_fd_pr__pfet_01v8_hvt ad=0.16875 pd=1.2 as=0.20925 ps=1.38 w=0.45 l=0.15
X20 a_645_36# D VPWR VPB sky130_fd_pr__pfet_01v8_hvt ad=0.08775 pd=0.84 as=0.16875 ps=1.65 w=0.45 l=0.15
X21 Q a_1736_165# VPWR VPB sky130_fd_pr__pfet_01v8_hvt ad=0.2106 pd=1.47 as=0.405 ps=2.91 w=1.08 l=0.15
X22 a_753_36# a_393_36# a_645_36# VPB sky130_fd_pr__pfet_01v8_hvt ad=0.20925 pd=1.38 as=0.08775 ps=0.84 w=0.45 l=0.15
X23 a_393_36# a_141_36# VGND VNB sky130_fd_pr__nfet_01v8 ad=0.16875 pd=1.65 as=0.16875 ps=1.65 w=0.45 l=0.15
X24 VPWR a_1736_165# Q VPB sky130_fd_pr__pfet_01v8_hvt ad=0.405 pd=2.91 as=0.2106 ps=1.47 w=1.08 l=0.15
X25 a_1617_36# a_141_36# a_1401_36# VNB sky130_fd_pr__special_nfet_01v8 ad=0.15593 pd=1.2 as=0.1674 ps=1.29 w=0.36 l=0.15
C0 VGND a_393_36# 0.44778f
C1 a_969_36# VGND 0.01995f
C2 CLK VPWR 0.04196f
C3 a_141_36# a_1088_165# 0.09882f
C4 VGND a_1401_36# 0.09505f
C5 a_645_36# a_141_36# 0.15126f
C6 a_645_36# D 0.06045f
C7 CLK VPB 0.09785f
C8 a_1617_36# a_1736_165# 0.00305f
C9 VPWR a_1617_36# 0.0012f
C10 a_1736_165# a_141_36# 0.05557f
C11 Q a_1736_165# 0.12039f
C12 VPWR a_141_36# 0.53956f
C13 Q VPWR 0.22627f
C14 VPWR D 0.03564f
C15 a_753_36# a_141_36# 0.21485f
C17 VPB a_141_36# 0.46569f
C18 Q VPB 0.00762f
C19 a_969_450# a_141_36# 0.00743f
C20 D VPB 0.11625f
C21 CLK VGND 0.04537f
C22 a_141_36# a_393_36# 0.91413f
C23 a_1617_36# a_1401_36# 0.00965f
C25 a_1401_36# a_141_36# 0.16214f
C26 D a_393_36# 0.09861f
C27 VGND a_1617_36# 0.01995f
C28 VGND a_141_36# 0.31438f
C29 Q VGND 0.15357f
C30 D VGND 0.03533f
C31 VPWR a_1088_165# 0.10157f
C32 a_645_36# VPWR 0.08042f
C33 a_753_36# a_1088_165# 0.2195f
C34 a_753_36# a_645_36# 0.04498f
C35 VPB a_1088_165# 0.11761f
C36 a_1617_450# VPWR 0.0225f
C37 a_645_36# VPB 0.02422f
C38 VPWR a_1736_165# 0.27472f
C39 CLK a_141_36# 0.09922f
C40 a_753_36# VPWR 0.11659f
C41 a_969_36# a_1088_165# 0.00294f
C42 a_393_36# a_1088_165# 0.23777f
C43 VPB a_1736_165# 0.23171f
C44 VPWR VPB 0.49683f
C45 a_645_36# a_393_36# 0.07535f
C46 a_969_450# VPWR 0.0225f
C47 a_1401_36# a_1088_165# 0.04489f
C48 a_1617_36# a_141_36# 0.00331f
C49 a_753_36# VPB 0.10487f
C50 a_969_450# a_753_36# 0.01125f
C52 a_1617_450# a_393_36# 0.00381f
C53 a_1736_165# a_393_36# 0.03099f
C54 D a_141_36# 0.07887f
C55 VGND a_1088_165# 0.1446f
C56 VPWR a_393_36# 0.23665f
C57 a_1617_450# a_1401_36# 0.01125f
C58 a_645_36# VGND 0.07973f
C59 a_1401_36# a_1736_165# 0.22982f
C60 VPWR a_1401_36# 0.12438f
C61 a_753_36# a_393_36# 0.18653f
C62 a_969_36# a_753_36# 0.00965f
C63 a_1617_450# VGND 0.00122f
C64 VPB a_393_36# 0.28897f
C65 VGND a_1736_165# 0.28008f
C66 VPWR VGND 0.10833f
C67 VPB a_1401_36# 0.08098f
C68 a_753_36# VGND 0.08895f
C69 a_969_36# a_393_36# 0.00712f
C70 VPB VGND 0.02729f
C71 a_1401_36# a_393_36# 0.13691f
C72 Q VNB 0.03684f
C73 VGND VNB 1.52171f
C74 VPWR VNB 1.09452f
C75 D VNB 0.13204f
C76 CLK VNB 0.19841f
C77 VPB VNB 2.82269f
C78 a_645_36# VNB 0.02294f
C79 a_1401_36# VNB 0.12934f
C80 a_1736_165# VNB 0.39235f
C81 a_753_36# VNB 0.12466f
C82 a_1088_165# VNB 0.13891f
C83 a_393_36# VNB 0.38979f
C84 a_141_36# VNB 0.58502f
.ends

.subckt sky130_efx_lvdig__dlygate4sd3_1 A X VGND VNB VPB VPWR
X0 X a_788_36# VGND VNB sky130_fd_pr__nfet_01v8 ad=0.23625 pd=2.01 as=0.23625 ps=2.01 w=0.63 l=0.15
X1 a_464_36# a_141_36# VPWR VPB sky130_fd_pr__pfet_01v8_hvt ad=0.171 pd=1.66 as=0.171 ps=1.66 w=0.45 l=0.5
X2 a_788_36# a_464_36# VGND VNB sky130_fd_pr__nfet_01v8 ad=0.171 pd=1.66 as=0.171 ps=1.66 w=0.45 l=0.5
X3 a_788_36# a_464_36# VPWR VPB sky130_fd_pr__pfet_01v8_hvt ad=0.171 pd=1.66 as=0.171 ps=1.66 w=0.45 l=0.5
X4 a_141_36# A VPWR VPB sky130_fd_pr__pfet_01v8_hvt ad=0.16875 pd=1.65 as=0.16875 ps=1.65 w=0.45 l=0.15
X5 X a_788_36# VPWR VPB sky130_fd_pr__pfet_01v8_hvt ad=0.405 pd=2.91 as=0.405 ps=2.91 w=1.08 l=0.15
X6 a_141_36# A VGND VNB sky130_fd_pr__nfet_01v8 ad=0.16875 pd=1.65 as=0.16875 ps=1.65 w=0.45 l=0.15
X7 a_464_36# a_141_36# VGND VNB sky130_fd_pr__nfet_01v8 ad=0.171 pd=1.66 as=0.171 ps=1.66 w=0.45 l=0.5
C0 VPWR a_464_36# 0.18366f
C1 VGND a_788_36# 0.16497f
C2 VPB a_141_36# 0.21435f
C3 X a_464_36# 0.00104f
C4 VGND VPB 0.02434f
C5 X VPWR 0.13857f
C6 a_141_36# A 0.1005f
C7 a_141_36# a_464_36# 0.14675f
C8 VGND A 0.04538f
C9 VGND a_464_36# 0.19303f
C10 VPWR a_141_36# 0.20077f
C11 VPB a_788_36# 0.09327f
C12 VGND VPWR 0.11363f
C13 VGND X 0.10221f
C14 a_464_36# a_788_36# 0.13523f
C15 VPB A 0.11464f
C16 VPB a_464_36# 0.21799f
C17 VPWR a_788_36# 0.19608f
C18 VGND a_141_36# 0.21139f
C19 VPB VPWR 0.26331f
C20 X a_788_36# 0.07073f
C21 VPB X 0.01018f
C22 VPWR A 0.03739f
C23 VGND VNB 0.79796f
C24 X VNB 0.1112f
C25 VPWR VNB 0.57068f
C26 A VNB 0.2029f
C27 VPB VNB 1.36858f
C28 a_788_36# VNB 0.18678f
C29 a_464_36# VNB 0.25839f
C30 a_141_36# VNB 0.28533f
.ends

.subckt sky130_efx_lvdig__edfxbp_1 CLK D DE Q Q_N VGND VNB VPB VPWR
X0 a_936_288# a_2697_36# VGND VNB sky130_fd_pr__nfet_01v8 ad=0.16875 pd=1.65 as=0.16875 ps=1.65 w=0.45 l=0.15
X1 a_249_36# D a_144_36# VNB sky130_fd_pr__nfet_01v8 ad=0.08775 pd=0.84 as=0.16875 ps=1.65 w=0.45 l=0.15
X2 VGND DE a_249_36# VNB sky130_fd_pr__nfet_01v8 ad=0.16875 pd=1.65 as=0.08775 ps=0.84 w=0.45 l=0.15
X3 a_2697_36# a_1509_36# a_2553_36# VNB sky130_fd_pr__special_nfet_01v8 ad=0.1674 pd=1.29 as=0.11542 ps=1.02 w=0.36 l=0.15
X4 a_2913_36# a_1257_36# a_2697_36# VNB sky130_fd_pr__special_nfet_01v8 ad=0.15593 pd=1.2 as=0.1674 ps=1.29 w=0.36 l=0.15
X5 Q_N a_936_288# VPWR VPB sky130_fd_pr__pfet_01v8_hvt ad=0.405 pd=2.91 as=0.405 ps=2.91 w=1.08 l=0.15
X6 a_861_36# a_324_288# VGND VNB sky130_fd_pr__nfet_01v8 ad=0.08775 pd=0.84 as=0.16875 ps=1.65 w=0.45 l=0.15
X7 a_1977_36# a_1509_36# a_1761_36# VNB sky130_fd_pr__special_nfet_01v8 ad=0.15593 pd=1.2 as=0.1674 ps=1.29 w=0.36 l=0.15
X8 a_1509_36# a_1257_36# VPWR VPB sky130_fd_pr__pfet_01v8_hvt ad=0.23625 pd=2.01 as=0.23625 ps=2.01 w=0.63 l=0.15
X9 VPWR a_2096_165# a_1977_450# VPB sky130_fd_pr__pfet_01v8_hvt ad=0.12622 pd=1.11 as=0.16875 ps=1.2 w=0.45 l=0.15
X10 Q_N a_936_288# VGND VNB sky130_fd_pr__nfet_01v8 ad=0.23625 pd=2.01 as=0.23625 ps=2.01 w=0.63 l=0.15
X11 a_249_414# D a_144_36# VPB sky130_fd_pr__pfet_01v8_hvt ad=0.12285 pd=1.02 as=0.23625 ps=2.01 w=0.63 l=0.15
X12 a_2553_450# a_2096_165# VPWR VPB sky130_fd_pr__pfet_01v8_hvt ad=0.12825 pd=1.02 as=0.16875 ps=1.65 w=0.45 l=0.15
X13 VGND DE a_324_288# VNB sky130_fd_pr__nfet_01v8 ad=0.16875 pd=1.65 as=0.16875 ps=1.65 w=0.45 l=0.15
X14 VPWR a_324_288# a_249_414# VPB sky130_fd_pr__pfet_01v8_hvt ad=0.23625 pd=2.01 as=0.12285 ps=1.02 w=0.63 l=0.15
X15 a_1761_36# a_1509_36# a_144_36# VPB sky130_fd_pr__pfet_01v8_hvt ad=0.20925 pd=1.38 as=0.16875 ps=1.65 w=0.45 l=0.15
X16 a_936_288# a_2697_36# VPWR VPB sky130_fd_pr__pfet_01v8_hvt ad=0.23625 pd=2.01 as=0.23625 ps=2.01 w=0.63 l=0.15
X17 VGND a_936_288# a_2913_36# VNB sky130_fd_pr__nfet_01v8 ad=0.16875 pd=1.65 as=0.15593 ps=1.2 w=0.45 l=0.15
X18 a_2096_165# a_1761_36# VPWR VPB sky130_fd_pr__pfet_01v8_hvt ad=0.3996 pd=2.55 as=0.12622 ps=1.11 w=0.72 l=0.15
X19 a_861_414# DE VPWR VPB sky130_fd_pr__pfet_01v8_hvt ad=0.12285 pd=1.02 as=0.23625 ps=2.01 w=0.63 l=0.15
X20 VPWR a_936_288# a_2913_450# VPB sky130_fd_pr__pfet_01v8_hvt ad=0.16875 pd=1.65 as=0.16875 ps=1.2 w=0.45 l=0.15
X21 VGND a_2096_165# a_1977_36# VNB sky130_fd_pr__nfet_01v8 ad=0.1134 pd=1.02 as=0.15593 ps=1.2 w=0.45 l=0.15
X22 a_2096_165# a_1761_36# VGND VNB sky130_fd_pr__nfet_01v8 ad=0.34965 pd=2.37 as=0.1134 ps=1.02 w=0.63 l=0.15
X23 a_1977_450# a_1257_36# a_1761_36# VPB sky130_fd_pr__pfet_01v8_hvt ad=0.16875 pd=1.2 as=0.20925 ps=1.38 w=0.45 l=0.15
X24 a_144_36# a_936_288# a_861_36# VNB sky130_fd_pr__nfet_01v8 ad=0.16875 pd=1.65 as=0.08775 ps=0.84 w=0.45 l=0.15
X25 a_1257_36# CLK VGND VNB sky130_fd_pr__nfet_01v8 ad=0.16875 pd=1.65 as=0.16875 ps=1.65 w=0.45 l=0.15
X26 Q a_2697_36# VGND VNB sky130_fd_pr__nfet_01v8 ad=0.23625 pd=2.01 as=0.23625 ps=2.01 w=0.63 l=0.15
X27 a_144_36# a_936_288# a_861_414# VPB sky130_fd_pr__pfet_01v8_hvt ad=0.23625 pd=2.01 as=0.12285 ps=1.02 w=0.63 l=0.15
X28 a_2553_36# a_2096_165# VGND VNB sky130_fd_pr__nfet_01v8 ad=0.11542 pd=1.02 as=0.16875 ps=1.65 w=0.45 l=0.15
X29 a_2697_36# a_1257_36# a_2553_450# VPB sky130_fd_pr__pfet_01v8_hvt ad=0.20925 pd=1.38 as=0.12825 ps=1.02 w=0.45 l=0.15
X30 a_1761_36# a_1257_36# a_144_36# VNB sky130_fd_pr__special_nfet_01v8 ad=0.1674 pd=1.29 as=0.135 ps=1.47 w=0.36 l=0.15
X31 a_1257_36# CLK VPWR VPB sky130_fd_pr__pfet_01v8_hvt ad=0.23625 pd=2.01 as=0.23625 ps=2.01 w=0.63 l=0.15
X32 VPWR DE a_324_288# VPB sky130_fd_pr__pfet_01v8_hvt ad=0.23625 pd=2.01 as=0.23625 ps=2.01 w=0.63 l=0.15
X33 Q a_2697_36# VPWR VPB sky130_fd_pr__pfet_01v8_hvt ad=0.405 pd=2.91 as=0.405 ps=2.91 w=1.08 l=0.15
X34 a_2913_450# a_1509_36# a_2697_36# VPB sky130_fd_pr__pfet_01v8_hvt ad=0.16875 pd=1.2 as=0.20925 ps=1.38 w=0.45 l=0.15
X35 a_1509_36# a_1257_36# VGND VNB sky130_fd_pr__nfet_01v8 ad=0.16875 pd=1.65 as=0.16875 ps=1.65 w=0.45 l=0.15
C1 a_1509_36# a_2913_450# 0.00194f
C2 a_936_288# a_2553_450# 0.00666f
C3 a_144_36# a_324_288# 0.11492f
C4 CLK a_1257_36# 0.09905f
C7 CLK VGND 0.03978f
C8 a_1257_36# a_2096_165# 0.1444f
C9 VGND a_2096_165# 0.21283f
C10 a_144_36# a_1257_36# 0.26704f
C11 a_1509_36# a_1257_36# 1.09117f
C12 a_144_36# VGND 1.36087f
C13 a_1509_36# VGND 0.41384f
C14 a_1761_36# VPB 0.1135f
C16 VPWR Q 0.15781f
C17 DE D 0.02996f
C18 D VPB 0.09247f
C20 a_324_288# VGND 0.20484f
C21 a_1257_36# a_2913_36# 0.00331f
C23 VPWR CLK 0.03739f
C24 VGND a_2913_36# 0.02103f
C25 VPWR a_2096_165# 0.15219f
C26 a_1257_36# VGND 0.26305f
C27 a_936_288# Q 0.07807f
C28 a_144_36# VPWR 0.38882f
C29 VPWR a_1509_36# 0.13399f
C30 a_2096_165# a_1977_36# 0.00294f
C31 a_144_36# a_1977_36# 0.00159f
C32 a_2697_36# VPB 0.23403f
C33 a_1509_36# a_1977_36# 0.00712f
C34 DE VPB 0.23954f
C35 VPWR a_2913_450# 0.01687f
C36 a_2697_36# a_2553_450# 0.0037f
C37 a_936_288# CLK 0.03532f
C39 a_936_288# a_2096_165# 0.05601f
C40 VPWR a_324_288# 0.21529f
C41 Q_N VGND 0.10221f
C42 a_936_288# a_144_36# 0.25946f
C43 a_936_288# a_1509_36# 0.24867f
C44 VPWR a_1257_36# 0.22074f
C45 VPWR VGND 0.07322f
C46 a_936_288# a_2913_450# 0.01451f
C47 VGND a_1977_36# 0.01995f
C48 a_2096_165# a_1761_36# 0.24064f
C49 a_936_288# a_324_288# 0.04645f
C50 a_1257_36# a_1977_450# 0.00194f
C51 a_144_36# a_1761_36# 0.04862f
C52 a_936_288# a_2913_36# 0.00166f
C53 a_1509_36# a_1761_36# 0.16151f
C54 Q_N VPWR 0.13857f
C55 a_936_288# a_1257_36# 0.56753f
C56 a_144_36# D 0.07622f
C57 a_144_36# a_861_36# 0.00958f
C58 a_936_288# VGND 0.30367f
C60 a_2697_36# a_2553_36# 0.00322f
C61 a_2697_36# Q 0.0949f
C62 Q VPB 0.02034f
C63 a_249_414# a_144_36# 0.00844f
C64 a_144_36# a_861_414# 0.0044f
C65 a_324_288# D 0.04295f
C67 a_936_288# Q_N 0.07201f
C68 a_1257_36# a_1761_36# 0.1829f
C69 a_2697_36# a_2096_165# 0.00517f
C70 VGND a_1761_36# 0.09007f
C71 VPWR a_1977_450# 0.01954f
C72 CLK VPB 0.10634f
C75 a_2697_36# a_1509_36# 0.12554f
C76 a_2096_165# VPB 0.24528f
C77 a_144_36# DE 0.03773f
C78 a_936_288# VPWR 1.88459f
C79 VGND a_861_36# 0.00929f
C80 VGND D 0.01622f
C83 a_144_36# VPB 0.13243f
C84 a_1509_36# VPB 0.31027f
C85 a_2697_36# a_2913_450# 0.00773f
C89 a_936_288# a_1977_450# 0.00876f
C90 DE a_324_288# 0.26955f
C91 a_2697_36# a_2913_36# 0.0111f
C92 VPWR a_1761_36# 0.10756f
C93 a_324_288# VPB 0.15411f
C94 a_2697_36# a_1257_36# 0.16334f
C95 DE a_1257_36# 0.00177f
C96 a_2697_36# VGND 0.19932f
C97 a_1761_36# a_1977_36# 0.00965f
C99 VPWR D 0.02183f
C100 a_144_36# a_249_36# 0.00958f
C101 DE VGND 0.05794f
C102 a_1257_36# VPB 0.46213f
C103 VGND VPB 0.04115f
C104 a_1761_36# a_1977_450# 0.01125f
C106 a_249_414# VPWR 0.01672f
C107 a_861_414# VPWR 0.01047f
C108 a_936_288# a_1761_36# 0.05033f
C112 a_936_288# a_861_36# 0.00184f
C114 Q_N VPB 0.01018f
C115 a_1509_36# a_2553_36# 0.00413f
C117 VPWR a_2697_36# 0.17664f
C118 VPWR DE 0.10418f
C119 VGND a_249_36# 0.01023f
C120 VPWR VPB 0.82238f
C122 a_936_288# a_861_414# 0.01122f
C123 a_144_36# CLK 0.04734f
C124 VPWR a_2553_450# 0.01533f
C127 a_1509_36# a_2096_165# 0.19905f
C128 a_144_36# a_1509_36# 0.30067f
C129 Q a_1257_36# 0.00348f
C130 a_936_288# a_2697_36# 0.23938f
C131 VGND a_2553_36# 0.01602f
C132 Q VGND 0.12234f
C133 a_936_288# DE 0.05327f
C134 a_936_288# VPB 0.43177f
C135 Q_N VNB 0.1112f
C136 Q VNB 0.01963f
C137 VGND VNB 2.41959f
C138 VPWR VNB 1.65955f
C139 CLK VNB 0.15114f
C140 DE VNB 0.35579f
C141 D VNB 0.17704f
C142 VPB VNB 4.70448f
C143 a_144_36# VNB 0.27525f
C144 a_2697_36# VNB 0.36018f
C145 a_1761_36# VNB 0.13301f
C146 a_2096_165# VNB 0.28484f
C147 a_1509_36# VNB 0.40491f
C148 a_1257_36# VNB 0.57249f
C149 a_936_288# VNB 0.46168f
C150 a_324_288# VNB 0.19908f
.ends

.subckt sky130_efx_lvdig__edfxtp_1 CLK D DE Q VGND VNB VPB VPWR
X0 a_936_288# a_2697_36# VGND VNB sky130_fd_pr__nfet_01v8 ad=0.16875 pd=1.65 as=0.16875 ps=1.65 w=0.45 l=0.15
X1 a_249_36# D a_144_36# VNB sky130_fd_pr__nfet_01v8 ad=0.08775 pd=0.84 as=0.16875 ps=1.65 w=0.45 l=0.15
X2 VGND DE a_249_36# VNB sky130_fd_pr__nfet_01v8 ad=0.16875 pd=1.65 as=0.08775 ps=0.84 w=0.45 l=0.15
X3 a_2697_36# a_1509_36# a_2553_36# VNB sky130_fd_pr__special_nfet_01v8 ad=0.1674 pd=1.29 as=0.11542 ps=1.02 w=0.36 l=0.15
X4 a_2913_36# a_1257_36# a_2697_36# VNB sky130_fd_pr__special_nfet_01v8 ad=0.15593 pd=1.2 as=0.1674 ps=1.29 w=0.36 l=0.15
X5 a_861_36# a_324_288# VGND VNB sky130_fd_pr__nfet_01v8 ad=0.08775 pd=0.84 as=0.16875 ps=1.65 w=0.45 l=0.15
X6 a_1977_36# a_1509_36# a_1761_36# VNB sky130_fd_pr__special_nfet_01v8 ad=0.15593 pd=1.2 as=0.1674 ps=1.29 w=0.36 l=0.15
X7 a_1509_36# a_1257_36# VPWR VPB sky130_fd_pr__pfet_01v8_hvt ad=0.23625 pd=2.01 as=0.23625 ps=2.01 w=0.63 l=0.15
X8 VPWR a_2096_165# a_1977_450# VPB sky130_fd_pr__pfet_01v8_hvt ad=0.12622 pd=1.11 as=0.16875 ps=1.2 w=0.45 l=0.15
X9 a_249_414# D a_144_36# VPB sky130_fd_pr__pfet_01v8_hvt ad=0.12285 pd=1.02 as=0.23625 ps=2.01 w=0.63 l=0.15
X10 a_2553_450# a_2096_165# VPWR VPB sky130_fd_pr__pfet_01v8_hvt ad=0.12825 pd=1.02 as=0.16875 ps=1.65 w=0.45 l=0.15
X11 VGND DE a_324_288# VNB sky130_fd_pr__nfet_01v8 ad=0.16875 pd=1.65 as=0.16875 ps=1.65 w=0.45 l=0.15
X12 VPWR a_324_288# a_249_414# VPB sky130_fd_pr__pfet_01v8_hvt ad=0.23625 pd=2.01 as=0.12285 ps=1.02 w=0.63 l=0.15
X13 a_1761_36# a_1509_36# a_144_36# VPB sky130_fd_pr__pfet_01v8_hvt ad=0.20925 pd=1.38 as=0.16875 ps=1.65 w=0.45 l=0.15
X14 a_936_288# a_2697_36# VPWR VPB sky130_fd_pr__pfet_01v8_hvt ad=0.23625 pd=2.01 as=0.23625 ps=2.01 w=0.63 l=0.15
X15 VGND a_936_288# a_2913_36# VNB sky130_fd_pr__nfet_01v8 ad=0.16875 pd=1.65 as=0.15593 ps=1.2 w=0.45 l=0.15
X16 a_2096_165# a_1761_36# VPWR VPB sky130_fd_pr__pfet_01v8_hvt ad=0.3996 pd=2.55 as=0.12622 ps=1.11 w=0.72 l=0.15
X17 a_861_414# DE VPWR VPB sky130_fd_pr__pfet_01v8_hvt ad=0.12285 pd=1.02 as=0.23625 ps=2.01 w=0.63 l=0.15
X18 VPWR a_936_288# a_2913_450# VPB sky130_fd_pr__pfet_01v8_hvt ad=0.16875 pd=1.65 as=0.16875 ps=1.2 w=0.45 l=0.15
X19 VGND a_2096_165# a_1977_36# VNB sky130_fd_pr__nfet_01v8 ad=0.1134 pd=1.02 as=0.15593 ps=1.2 w=0.45 l=0.15
X20 a_2096_165# a_1761_36# VGND VNB sky130_fd_pr__nfet_01v8 ad=0.34965 pd=2.37 as=0.1134 ps=1.02 w=0.63 l=0.15
X21 a_1977_450# a_1257_36# a_1761_36# VPB sky130_fd_pr__pfet_01v8_hvt ad=0.16875 pd=1.2 as=0.20925 ps=1.38 w=0.45 l=0.15
X22 a_144_36# a_936_288# a_861_36# VNB sky130_fd_pr__nfet_01v8 ad=0.16875 pd=1.65 as=0.08775 ps=0.84 w=0.45 l=0.15
X23 a_1257_36# CLK VGND VNB sky130_fd_pr__nfet_01v8 ad=0.16875 pd=1.65 as=0.16875 ps=1.65 w=0.45 l=0.15
X24 Q a_2697_36# VGND VNB sky130_fd_pr__nfet_01v8 ad=0.23625 pd=2.01 as=0.23625 ps=2.01 w=0.63 l=0.15
X25 a_144_36# a_936_288# a_861_414# VPB sky130_fd_pr__pfet_01v8_hvt ad=0.23625 pd=2.01 as=0.12285 ps=1.02 w=0.63 l=0.15
X26 a_2553_36# a_2096_165# VGND VNB sky130_fd_pr__nfet_01v8 ad=0.11542 pd=1.02 as=0.16875 ps=1.65 w=0.45 l=0.15
X27 a_2697_36# a_1257_36# a_2553_450# VPB sky130_fd_pr__pfet_01v8_hvt ad=0.20925 pd=1.38 as=0.12825 ps=1.02 w=0.45 l=0.15
X28 a_1761_36# a_1257_36# a_144_36# VNB sky130_fd_pr__special_nfet_01v8 ad=0.1674 pd=1.29 as=0.135 ps=1.47 w=0.36 l=0.15
X29 a_1257_36# CLK VPWR VPB sky130_fd_pr__pfet_01v8_hvt ad=0.23625 pd=2.01 as=0.23625 ps=2.01 w=0.63 l=0.15
X30 VPWR DE a_324_288# VPB sky130_fd_pr__pfet_01v8_hvt ad=0.23625 pd=2.01 as=0.23625 ps=2.01 w=0.63 l=0.15
X31 Q a_2697_36# VPWR VPB sky130_fd_pr__pfet_01v8_hvt ad=0.405 pd=2.91 as=0.405 ps=2.91 w=1.08 l=0.15
X32 a_2913_450# a_1509_36# a_2697_36# VPB sky130_fd_pr__pfet_01v8_hvt ad=0.16875 pd=1.2 as=0.20925 ps=1.38 w=0.45 l=0.15
X33 a_1509_36# a_1257_36# VGND VNB sky130_fd_pr__nfet_01v8 ad=0.16875 pd=1.65 as=0.16875 ps=1.65 w=0.45 l=0.15
C0 VGND a_861_36# 0.00929f
C1 a_936_288# a_1761_36# 0.05033f
C2 a_324_288# VGND 0.20484f
C4 VPWR a_1509_36# 0.13388f
C5 a_936_288# a_2096_165# 0.05601f
C6 a_144_36# VPB 0.13243f
C7 VPWR Q 0.15781f
C8 a_1509_36# a_1761_36# 0.16151f
C9 CLK VPB 0.10634f
C11 VPB D 0.09247f
C12 a_2096_165# a_1509_36# 0.19905f
C13 a_144_36# a_1977_36# 0.00159f
C14 a_144_36# DE 0.03773f
C15 VGND a_2913_36# 0.02103f
C16 a_2697_36# a_2913_450# 0.00773f
C17 DE D 0.02996f
C19 a_861_414# a_144_36# 0.0044f
C20 a_936_288# a_1509_36# 0.2486f
C21 a_936_288# Q 0.07807f
C22 VGND VPWR 0.05335f
C23 VGND a_1761_36# 0.09007f
C25 a_1257_36# a_2913_36# 0.00331f
C26 a_324_288# VPB 0.15411f
C29 VGND a_2096_165# 0.21283f
C30 CLK a_144_36# 0.04734f
C31 VPWR a_2553_450# 0.01533f
C32 a_144_36# D 0.07622f
C34 a_324_288# DE 0.26955f
C35 VGND a_249_36# 0.01023f
C36 a_1257_36# VPWR 0.22074f
C38 a_1257_36# a_1761_36# 0.1829f
C39 VGND a_936_288# 0.20733f
C40 a_2913_36# a_2697_36# 0.0111f
C41 a_1257_36# a_2096_165# 0.1444f
C42 VGND a_1509_36# 0.41384f
C43 VGND Q 0.12234f
C44 VPWR VPB 0.77303f
C45 a_144_36# a_861_36# 0.00958f
C46 a_936_288# a_2553_450# 0.00666f
C47 a_1509_36# a_2553_36# 0.00413f
C48 VPB a_1761_36# 0.1135f
C49 VPWR a_2697_36# 0.17437f
C50 a_324_288# a_144_36# 0.11492f
C51 a_2096_165# VPB 0.24528f
C52 a_1257_36# a_936_288# 0.56717f
C54 VPWR DE 0.10418f
C55 a_324_288# D 0.04295f
C56 a_2096_165# a_2697_36# 0.00517f
C57 a_1977_36# a_1761_36# 0.00965f
C58 a_1257_36# a_1509_36# 1.09117f
C59 a_1257_36# Q 0.00348f
C60 a_2096_165# a_1977_36# 0.00294f
C62 a_861_414# VPWR 0.01047f
C63 a_1977_450# VPWR 0.01954f
C64 a_936_288# VPB 0.36672f
C65 a_1977_450# a_1761_36# 0.01125f
C66 a_936_288# a_2697_36# 0.21796f
C67 VGND a_2553_36# 0.01602f
C68 a_1509_36# VPB 0.31018f
C69 Q VPB 0.02034f
C70 a_936_288# DE 0.05327f
C72 VPWR a_144_36# 0.38882f
C73 a_1509_36# a_2697_36# 0.12554f
C74 VPWR CLK 0.03739f
C75 a_144_36# a_1761_36# 0.04862f
C76 Q a_2697_36# 0.0949f
C78 VPWR D 0.02183f
C79 a_1509_36# a_1977_36# 0.00712f
C81 a_249_414# a_144_36# 0.00844f
C83 VPWR a_2913_450# 0.01687f
C84 a_1257_36# VGND 0.26302f
C85 a_861_414# a_936_288# 0.01122f
C86 a_1977_450# a_936_288# 0.00876f
C87 a_144_36# a_249_36# 0.00958f
C88 a_144_36# a_936_288# 0.25946f
C89 VGND VPB 0.04035f
C90 CLK a_936_288# 0.03532f
C92 VGND a_2697_36# 0.1978f
C94 a_144_36# a_1509_36# 0.30067f
C95 a_324_288# VPWR 0.21529f
C96 a_936_288# a_2913_450# 0.01451f
C98 VGND a_1977_36# 0.01995f
C99 a_2697_36# a_2553_36# 0.00322f
C100 VGND DE 0.05794f
C102 a_1509_36# a_2913_450# 0.00194f
C103 a_2697_36# a_2553_450# 0.0037f
C104 a_1257_36# VPB 0.46208f
C106 a_1257_36# a_2697_36# 0.16334f
C107 a_936_288# a_861_36# 0.00184f
C108 a_1257_36# DE 0.00177f
C109 a_324_288# a_936_288# 0.04645f
C110 VGND a_144_36# 1.36087f
C111 VGND CLK 0.03978f
C112 VPB a_2697_36# 0.22689f
C114 VPWR a_1761_36# 0.10756f
C115 VGND D 0.01622f
C117 a_1257_36# a_1977_450# 0.00194f
C118 a_249_414# VPWR 0.01672f
C119 DE VPB 0.23954f
C120 VPWR a_2096_165# 0.15219f
C121 a_936_288# a_2913_36# 0.00166f
C122 a_2096_165# a_1761_36# 0.24064f
C124 a_1257_36# a_144_36# 0.26704f
C125 a_1257_36# CLK 0.09905f
C126 VPWR a_936_288# 1.7537f
C128 Q VNB 0.01963f
C129 VGND VNB 2.29314f
C130 VPWR VNB 1.57992f
C131 CLK VNB 0.15114f
C132 DE VNB 0.35579f
C133 D VNB 0.17704f
C134 VPB VNB 4.44787f
C135 a_144_36# VNB 0.27525f
C136 a_2697_36# VNB 0.38598f
C137 a_1761_36# VNB 0.13301f
C138 a_2096_165# VNB 0.28484f
C139 a_1509_36# VNB 0.40556f
C140 a_1257_36# VNB 0.57375f
C141 a_936_288# VNB 0.38901f
C142 a_324_288# VNB 0.19908f
.ends

.subckt sky130_efx_lvdig__ha_1 A B COUT SUM VGND VNB VPB VPWR
X0 a_108_216# B VPWR VPB sky130_fd_pr__pfet_01v8_hvt ad=0.08775 pd=0.84 as=0.16875 ps=1.65 w=0.45 l=0.15
X1 a_717_450# a_108_216# VPWR VPB sky130_fd_pr__pfet_01v8_hvt ad=0.16875 pd=1.65 as=0.16875 ps=1.65 w=0.45 l=0.15
X2 VPWR a_108_216# COUT VPB sky130_fd_pr__pfet_01v8_hvt ad=0.405 pd=2.91 as=0.405 ps=2.91 w=1.08 l=0.15
X3 VPWR A a_108_216# VPB sky130_fd_pr__pfet_01v8_hvt ad=0.08775 pd=0.84 as=0.08775 ps=0.84 w=0.45 l=0.15
X4 SUM a_717_450# VPWR VPB sky130_fd_pr__pfet_01v8_hvt ad=0.405 pd=2.91 as=0.405 ps=2.91 w=1.08 l=0.15
X5 a_609_450# A VPWR VPB sky130_fd_pr__pfet_01v8_hvt ad=0.08775 pd=0.84 as=0.08775 ps=0.84 w=0.45 l=0.15
X6 VGND B a_609_36# VNB sky130_fd_pr__nfet_01v8 ad=0.16875 pd=1.65 as=0.08775 ps=0.84 w=0.45 l=0.15
X7 a_717_450# B a_609_450# VPB sky130_fd_pr__pfet_01v8_hvt ad=0.16875 pd=1.65 as=0.08775 ps=0.84 w=0.45 l=0.15
X8 a_609_36# A VGND VNB sky130_fd_pr__nfet_01v8 ad=0.08775 pd=0.84 as=0.08775 ps=0.84 w=0.45 l=0.15
X9 SUM a_717_450# VGND VNB sky130_fd_pr__nfet_01v8 ad=0.23625 pd=2.01 as=0.23625 ps=2.01 w=0.63 l=0.15
X10 VGND a_108_216# COUT VNB sky130_fd_pr__nfet_01v8 ad=0.23625 pd=2.01 as=0.23625 ps=2.01 w=0.63 l=0.15
X11 a_717_450# a_108_216# a_609_36# VNB sky130_fd_pr__nfet_01v8 ad=0.16875 pd=1.65 as=0.16875 ps=1.65 w=0.45 l=0.15
X12 a_393_36# B a_108_216# VNB sky130_fd_pr__nfet_01v8 ad=0.08775 pd=0.84 as=0.16875 ps=1.65 w=0.45 l=0.15
X13 VGND A a_393_36# VNB sky130_fd_pr__nfet_01v8 ad=0.08775 pd=0.84 as=0.08775 ps=0.84 w=0.45 l=0.15
C0 VGND a_393_36# 0.0054f
C2 a_393_36# a_108_216# 0.01094f
C3 SUM a_717_450# 0.11842f
C5 a_609_36# a_717_450# 0.06858f
C6 a_609_450# a_717_450# 0.00469f
C7 VGND a_717_450# 0.14883f
C8 VGND SUM 0.10221f
C9 a_609_450# a_609_36# 0.00132f
C10 A a_717_450# 0.01603f
C11 B a_717_450# 0.06243f
C12 VGND a_609_36# 0.21068f
C13 a_108_216# a_717_450# 0.18125f
C14 VGND COUT 0.10221f
C15 SUM a_108_216# 0.00317f
C16 VPB a_717_450# 0.14007f
C17 VPWR a_717_450# 0.30654f
C18 a_609_36# A 0.01013f
C19 VPB SUM 0.01417f
C20 SUM VPWR 0.08434f
C21 a_609_36# B 0.07025f
C23 B COUT 0.00292f
C24 a_609_36# a_108_216# 0.14741f
C25 COUT a_108_216# 0.11243f
C26 VPB a_609_36# 0.00557f
C27 a_609_36# VPWR 0.00726f
C28 a_609_450# B 0.00213f
C29 VPB COUT 0.01121f
C30 VPWR COUT 0.08657f
C31 VGND A 0.04842f
C32 VGND B 0.05631f
C33 a_609_450# VPWR 0.01236f
C34 VGND a_108_216# 0.51417f
C35 B A 0.19992f
C36 VGND VPB 0.01609f
C37 VGND VPWR 0.07429f
C38 A a_108_216# 0.08372f
C39 B a_108_216# 0.48466f
C40 VPB A 0.16404f
C41 A VPWR 0.07432f
C42 VPB B 0.2208f
C43 B VPWR 0.11728f
C44 VPB a_108_216# 0.23347f
C45 VPWR a_108_216# 0.26769f
C46 VPB VPWR 0.28343f
C47 VGND VNB 0.90436f
C48 SUM VNB 0.10703f
C49 VPWR VNB 0.63825f
C50 COUT VNB 0.11242f
C51 A VNB 0.18026f
C52 B VNB 0.29018f
C53 VPB VNB 1.62518f
C54 a_609_36# VNB 0.03762f
C55 a_717_450# VNB 0.18881f
C56 a_108_216# VNB 0.40202f
.ends

.subckt sky130_efx_lvdig__inv_1 A Y VGND VNB VPB VPWR
X0 Y A VPWR VPB sky130_fd_pr__pfet_01v8_hvt ad=0.405 pd=2.91 as=0.405 ps=2.91 w=1.08 l=0.15
X1 Y A VGND VNB sky130_fd_pr__nfet_01v8 ad=0.23625 pd=2.01 as=0.23625 ps=2.01 w=0.63 l=0.15
C0 VGND A 0.05415f
C1 Y VPB 0.01427f
C2 VPWR VPB 0.06715f
C3 Y VPWR 0.13749f
C4 A VPB 0.05348f
C5 Y A 0.04374f
C6 VGND VPB 0.01012f
C7 VGND Y 0.10009f
C8 VPWR A 0.06489f
C9 VGND VPWR 0.03199f
C10 VGND VNB 0.29936f
C11 Y VNB 0.1195f
C12 VPWR VNB 0.25752f
C13 A VNB 0.18799f
C14 VPB VNB 0.34214f
.ends

.subckt sky130_efx_lvdig__inv_2 A Y VGND VNB VPB VPWR
X0 VGND A Y VNB sky130_fd_pr__nfet_01v8 ad=0.23625 pd=2.01 as=0.12285 ps=1.02 w=0.63 l=0.15
X1 Y A VPWR VPB sky130_fd_pr__pfet_01v8_hvt ad=0.2106 pd=1.47 as=0.405 ps=2.91 w=1.08 l=0.15
X2 VPWR A Y VPB sky130_fd_pr__pfet_01v8_hvt ad=0.405 pd=2.91 as=0.2106 ps=1.47 w=1.08 l=0.15
X3 Y A VGND VNB sky130_fd_pr__nfet_01v8 ad=0.12285 pd=1.02 as=0.23625 ps=2.01 w=0.63 l=0.15
C0 VGND A 0.08139f
C1 Y VPB 0.00717f
C2 VPWR VPB 0.0766f
C3 Y VPWR 0.22627f
C4 A VPB 0.09788f
C5 Y A 0.10877f
C6 VGND VPB 0.00844f
C7 VGND Y 0.15357f
C8 VPWR A 0.09572f
C9 VGND VPWR 0.05009f
C10 VGND VNB 0.3618f
C11 Y VNB 0.04877f
C12 VPWR VNB 0.32499f
C13 A VNB 0.27502f
C14 VPB VNB 0.42768f
.ends

.subckt sky130_efx_lvdig__inv_4 A Y VGND VNB VPB VPWR
X0 VGND A Y VNB sky130_fd_pr__nfet_01v8 ad=0.12285 pd=1.02 as=0.12285 ps=1.02 w=0.63 l=0.15
X1 Y A VGND VNB sky130_fd_pr__nfet_01v8 ad=0.12285 pd=1.02 as=0.12285 ps=1.02 w=0.63 l=0.15
X2 VGND A Y VNB sky130_fd_pr__nfet_01v8 ad=0.23625 pd=2.01 as=0.12285 ps=1.02 w=0.63 l=0.15
X3 Y A VPWR VPB sky130_fd_pr__pfet_01v8_hvt ad=0.2106 pd=1.47 as=0.405 ps=2.91 w=1.08 l=0.15
X4 VPWR A Y VPB sky130_fd_pr__pfet_01v8_hvt ad=0.2106 pd=1.47 as=0.2106 ps=1.47 w=1.08 l=0.15
X5 Y A VPWR VPB sky130_fd_pr__pfet_01v8_hvt ad=0.2106 pd=1.47 as=0.2106 ps=1.47 w=1.08 l=0.15
X6 VPWR A Y VPB sky130_fd_pr__pfet_01v8_hvt ad=0.405 pd=2.91 as=0.2106 ps=1.47 w=1.08 l=0.15
X7 Y A VGND VNB sky130_fd_pr__nfet_01v8 ad=0.12285 pd=1.02 as=0.23625 ps=2.01 w=0.63 l=0.15
C0 VGND A 0.13357f
C1 Y VPB 0.01503f
C2 VPWR VPB 0.11025f
C3 Y VPWR 0.48984f
C4 A VPB 0.19009f
C5 Y A 0.23208f
C6 VGND VPB 0.00912f
C7 VGND Y 0.34107f
C8 VPWR A 0.15818f
C9 VGND VPWR 0.07001f
C10 VGND VNB 0.47787f
C11 Y VNB 0.05991f
C12 VPWR VNB 0.40517f
C13 A VNB 0.44808f
C14 VPB VNB 0.68429f
.ends

.subckt sky130_efx_lvdig__mux2_1 A0 A1 S X VGND VNB VPB VPWR
X0 a_861_450# a_324_180# VPWR VPB sky130_fd_pr__pfet_01v8_hvt ad=0.08775 pd=0.84 as=0.16875 ps=1.65 w=0.45 l=0.15
X1 a_249_36# A0 a_144_36# VNB sky130_fd_pr__nfet_01v8 ad=0.08775 pd=0.84 as=0.16875 ps=1.65 w=0.45 l=0.15
X2 VGND a_324_180# a_249_36# VNB sky130_fd_pr__nfet_01v8 ad=0.16875 pd=1.65 as=0.08775 ps=0.84 w=0.45 l=0.15
X3 a_144_36# A1 a_861_450# VPB sky130_fd_pr__pfet_01v8_hvt ad=0.16875 pd=1.65 as=0.08775 ps=0.84 w=0.45 l=0.15
X4 a_861_36# S VGND VNB sky130_fd_pr__nfet_01v8 ad=0.08775 pd=0.84 as=0.16875 ps=1.65 w=0.45 l=0.15
X5 VPWR S a_324_180# VPB sky130_fd_pr__pfet_01v8_hvt ad=0.16875 pd=1.65 as=0.16875 ps=1.65 w=0.45 l=0.15
X6 VGND S a_324_180# VNB sky130_fd_pr__nfet_01v8 ad=0.16875 pd=1.65 as=0.16875 ps=1.65 w=0.45 l=0.15
X7 a_144_36# A1 a_861_36# VNB sky130_fd_pr__nfet_01v8 ad=0.16875 pd=1.65 as=0.08775 ps=0.84 w=0.45 l=0.15
X8 X a_144_36# VGND VNB sky130_fd_pr__nfet_01v8 ad=0.23625 pd=2.01 as=0.23625 ps=2.01 w=0.63 l=0.15
X9 a_249_450# A0 a_144_36# VPB sky130_fd_pr__pfet_01v8_hvt ad=0.08775 pd=0.84 as=0.16875 ps=1.65 w=0.45 l=0.15
X10 VPWR S a_249_450# VPB sky130_fd_pr__pfet_01v8_hvt ad=0.16875 pd=1.65 as=0.08775 ps=0.84 w=0.45 l=0.15
X11 X a_144_36# VPWR VPB sky130_fd_pr__pfet_01v8_hvt ad=0.405 pd=2.91 as=0.405 ps=2.91 w=1.08 l=0.15
C0 VPWR a_324_180# 0.21947f
C1 VGND a_324_180# 0.16966f
C2 S a_324_180# 0.24193f
C3 A0 a_324_180# 0.04316f
C4 VPB a_324_180# 0.17742f
C6 a_324_180# a_144_36# 0.10482f
C7 A1 a_324_180# 0.04911f
C8 VGND a_861_36# 0.01079f
C9 VPWR a_249_450# 0.01236f
C12 VGND VPWR 0.04137f
C13 VPWR S 0.0684f
C14 VGND a_249_36# 0.01079f
C15 a_861_450# VPWR 0.01236f
C16 VGND S 0.08055f
C17 a_861_36# a_144_36# 0.00928f
C18 X VPWR 0.13857f
C20 VPWR A0 0.02312f
C21 VPWR VPB 0.29762f
C22 VGND X 0.10221f
C23 a_144_36# a_249_450# 0.00602f
C24 VPWR a_144_36# 0.49056f
C25 VGND A0 0.01596f
C26 VPWR A1 0.02569f
C27 A0 S 0.04299f
C28 VGND VPB 0.0141f
C29 VPB S 0.28386f
C30 a_249_36# a_144_36# 0.00928f
C31 VGND a_144_36# 0.91995f
C32 S a_144_36# 0.04485f
C33 VGND A1 0.01693f
C34 A1 S 0.03776f
C35 a_861_450# a_144_36# 0.00602f
C36 X VPB 0.00972f
C37 X a_144_36# 0.07501f
C38 VPB A0 0.13097f
C39 X A1 0.00107f
C40 A0 a_144_36# 0.07713f
C41 VPB a_144_36# 0.17077f
C42 VPB A1 0.1359f
C43 A1 a_144_36# 0.10684f
C44 VGND VNB 0.88905f
C45 X VNB 0.11052f
C46 VPWR VNB 0.65006f
C47 A1 VNB 0.12997f
C48 S VNB 0.34046f
C49 A0 VNB 0.1521f
C50 VPB VNB 1.62518f
C51 a_144_36# VNB 0.40928f
C52 a_324_180# VNB 0.19368f
.ends

.subckt sky130_efx_lvdig__mux2_2 A0 A1 S X VGND VNB VPB VPWR
X0 a_249_36# A0 a_144_36# VNB sky130_fd_pr__nfet_01v8 ad=0.08775 pd=0.84 as=0.16875 ps=1.65 w=0.45 l=0.15
X1 VGND a_324_180# a_249_36# VNB sky130_fd_pr__nfet_01v8 ad=0.16875 pd=1.65 as=0.08775 ps=0.84 w=0.45 l=0.15
X2 a_861_36# S VGND VNB sky130_fd_pr__nfet_01v8 ad=0.08775 pd=0.84 as=0.16875 ps=1.65 w=0.45 l=0.15
X3 a_249_414# A0 a_144_36# VPB sky130_fd_pr__pfet_01v8_hvt ad=0.12285 pd=1.02 as=0.23625 ps=2.01 w=0.63 l=0.15
X4 VGND S a_324_180# VNB sky130_fd_pr__nfet_01v8 ad=0.16875 pd=1.65 as=0.16875 ps=1.65 w=0.45 l=0.15
X5 VPWR S a_249_414# VPB sky130_fd_pr__pfet_01v8_hvt ad=0.23625 pd=2.01 as=0.12285 ps=1.02 w=0.63 l=0.15
X6 a_861_414# a_324_180# VPWR VPB sky130_fd_pr__pfet_01v8_hvt ad=0.12285 pd=1.02 as=0.23625 ps=2.01 w=0.63 l=0.15
X7 a_144_36# A1 a_861_36# VNB sky130_fd_pr__nfet_01v8 ad=0.16875 pd=1.65 as=0.08775 ps=0.84 w=0.45 l=0.15
X8 X a_144_36# VGND VNB sky130_fd_pr__nfet_01v8 ad=0.12285 pd=1.02 as=0.23625 ps=2.01 w=0.63 l=0.15
X9 VGND a_144_36# X VNB sky130_fd_pr__nfet_01v8 ad=0.23625 pd=2.01 as=0.12285 ps=1.02 w=0.63 l=0.15
X10 a_144_36# A1 a_861_414# VPB sky130_fd_pr__pfet_01v8_hvt ad=0.23625 pd=2.01 as=0.12285 ps=1.02 w=0.63 l=0.15
X11 X a_144_36# VPWR VPB sky130_fd_pr__pfet_01v8_hvt ad=0.2106 pd=1.47 as=0.405 ps=2.91 w=1.08 l=0.15
X12 VPWR S a_324_180# VPB sky130_fd_pr__pfet_01v8_hvt ad=0.23625 pd=2.01 as=0.23625 ps=2.01 w=0.63 l=0.15
X13 VPWR a_144_36# X VPB sky130_fd_pr__pfet_01v8_hvt ad=0.405 pd=2.91 as=0.2106 ps=1.47 w=1.08 l=0.15
C0 A1 a_324_180# 0.04899f
C1 A0 a_324_180# 0.04295f
C2 VPWR a_324_180# 0.24287f
C3 VPB a_324_180# 0.1575f
C4 a_324_180# a_144_36# 0.10461f
C5 VGND a_324_180# 0.17239f
C6 S a_324_180# 0.25536f
C9 VPWR a_249_414# 0.01672f
C10 a_249_36# a_144_36# 0.00928f
C11 VGND a_249_36# 0.01079f
C12 VPWR A1 0.02507f
C13 A1 VPB 0.11122f
C14 X VPWR 0.22627f
C16 a_144_36# a_249_414# 0.00854f
C17 VPWR A0 0.02289f
C18 A1 a_144_36# 0.11129f
C19 VGND A1 0.01719f
C20 X VPB 0.00762f
C21 A1 S 0.03126f
C22 VPB A0 0.11271f
C23 VPWR a_861_414# 0.01672f
C24 X a_144_36# 0.12414f
C25 X VGND 0.15357f
C26 A0 a_144_36# 0.08097f
C27 VGND A0 0.0161f
C28 S A0 0.03278f
C29 VPWR VPB 0.32944f
C30 a_861_414# a_144_36# 0.00854f
C32 VPWR a_144_36# 0.53883f
C33 VGND VPWR 0.06841f
C35 VPWR S 0.0757f
C36 VPB a_144_36# 0.20497f
C37 VGND VPB 0.01628f
C38 VPB S 0.24252f
C39 VGND a_144_36# 0.94853f
C40 a_861_36# a_144_36# 0.00928f
C41 S a_144_36# 0.04673f
C42 VGND a_861_36# 0.01079f
C43 VGND S 0.08444f
C44 VGND VNB 1.00266f
C45 X VNB 0.0357f
C46 VPWR VNB 0.74598f
C47 A1 VNB 0.135f
C48 S VNB 0.34704f
C49 A0 VNB 0.15445f
C50 VPB VNB 1.79626f
C51 a_144_36# VNB 0.49155f
C52 a_324_180# VNB 0.19891f
.ends

.subckt sky130_efx_lvdig__nand2_1 A B Y VGND VNB VPB VPWR
X0 Y A a_141_36# VNB sky130_fd_pr__nfet_01v8 ad=0.23625 pd=2.01 as=0.12285 ps=1.02 w=0.63 l=0.15
X1 Y B VPWR VPB sky130_fd_pr__pfet_01v8_hvt ad=0.2106 pd=1.47 as=0.405 ps=2.91 w=1.08 l=0.15
X2 VPWR A Y VPB sky130_fd_pr__pfet_01v8_hvt ad=0.405 pd=2.91 as=0.2106 ps=1.47 w=1.08 l=0.15
X3 a_141_36# B VGND VNB sky130_fd_pr__nfet_01v8 ad=0.12285 pd=1.02 as=0.23625 ps=2.01 w=0.63 l=0.15
C0 VGND a_141_36# 0.00564f
C1 B VGND 0.05368f
C2 VPWR A 0.06439f
C3 A VPB 0.04956f
C4 A Y 0.09776f
C5 B A 0.04923f
C6 VPWR VPB 0.0766f
C7 VPWR Y 0.2293f
C8 A VGND 0.01532f
C10 VPWR B 0.06512f
C11 VPWR VGND 0.0379f
C12 VPB Y 0.00728f
C13 B VPB 0.04956f
C14 a_141_36# Y 0.0135f
C15 B Y 0.05877f
C16 VPB VGND 0.00741f
C17 VGND Y 0.13562f
C18 VGND VNB 0.33047f
C19 Y VNB 0.06907f
C20 VPWR VNB 0.32006f
C21 A VNB 0.15402f
C22 B VNB 0.15402f
C23 VPB VNB 0.42768f
.ends

.subckt sky130_efx_lvdig__nand2_2 A B Y VGND VNB VPB VPWR
X0 nmos_n3f5_f2_l150_ftf_0.S0 A Y VNB sky130_fd_pr__nfet_01v8 ad=0.12285 pd=1.02 as=0.12285 ps=1.02 w=0.63 l=0.15
X1 VGND B nmos_n3f5_f2_l150_ftf_0.S0 VNB sky130_fd_pr__nfet_01v8 ad=0.12285 pd=1.02 as=0.12285 ps=1.02 w=0.63 l=0.15
X2 nmos_n3f5_f2_l150_ftf_0.S0 B VGND VNB sky130_fd_pr__nfet_01v8 ad=0.23625 pd=2.01 as=0.12285 ps=1.02 w=0.63 l=0.15
X3 Y A VPWR VPB sky130_fd_pr__pfet_01v8_hvt ad=0.2106 pd=1.47 as=0.405 ps=2.91 w=1.08 l=0.15
X4 VPWR A Y VPB sky130_fd_pr__pfet_01v8_hvt ad=0.2106 pd=1.47 as=0.2106 ps=1.47 w=1.08 l=0.15
X5 Y B VPWR VPB sky130_fd_pr__pfet_01v8_hvt ad=0.2106 pd=1.47 as=0.2106 ps=1.47 w=1.08 l=0.15
X6 VPWR B Y VPB sky130_fd_pr__pfet_01v8_hvt ad=0.405 pd=2.91 as=0.2106 ps=1.47 w=1.08 l=0.15
X7 Y A nmos_n3f5_f2_l150_ftf_0.S0 VNB sky130_fd_pr__nfet_01v8 ad=0.12285 pd=1.02 as=0.23625 ps=2.01 w=0.63 l=0.15
C0 VGND VPB 0.00852f
C1 A nmos_n3f5_f2_l150_ftf_0.S0 0.06286f
C2 VGND nmos_n3f5_f2_l150_ftf_0.S0 0.34001f
C3 A VGND 0.02073f
C4 VPWR B 0.05053f
C5 B Y 0.08086f
C6 B VPB 0.07872f
C7 B nmos_n3f5_f2_l150_ftf_0.S0 0.0738f
C8 A B 0.05091f
C9 VPWR Y 0.39958f
C10 B VGND 0.04214f
C11 VPWR VPB 0.10954f
C12 VPWR nmos_n3f5_f2_l150_ftf_0.S0 0.01965f
C13 VPWR A 0.08545f
C14 VPWR VGND 0.05488f
C15 VPB Y 0.01252f
C16 nmos_n3f5_f2_l150_ftf_0.S0 Y 0.11846f
C17 A Y 0.11743f
C18 A VPB 0.09566f
C19 nmos_n3f5_f2_l150_ftf_0.S0 VPB 0.00238f
C20 VGND Y 0.0163f
C21 VGND VNB 0.41368f
C22 Y VNB 0.03355f
C23 VPWR VNB 0.40718f
C24 B VNB 0.20441f
C25 A VNB 0.24055f
C26 VPB VNB 0.68429f
C27 nmos_n3f5_f2_l150_ftf_0.S0 VNB 0.08298f
.ends

.subckt sky130_efx_lvdig__nor2_1 A B Y VGND VNB VPB VPWR
X0 VGND B Y VNB sky130_fd_pr__nfet_01v8 ad=0.23625 pd=2.01 as=0.12285 ps=1.02 w=0.63 l=0.15
X1 a_141_324# A VPWR VPB sky130_fd_pr__pfet_01v8_hvt ad=0.2106 pd=1.47 as=0.405 ps=2.91 w=1.08 l=0.15
X2 Y B a_141_324# VPB sky130_fd_pr__pfet_01v8_hvt ad=0.405 pd=2.91 as=0.2106 ps=1.47 w=1.08 l=0.15
X3 Y A VGND VNB sky130_fd_pr__nfet_01v8 ad=0.12285 pd=1.02 as=0.23625 ps=2.01 w=0.63 l=0.15
C0 VGND a_141_324# 0.00181f
C1 A VGND 0.05438f
C2 VPWR B 0.01923f
C3 B VPB 0.04956f
C4 B Y 0.10712f
C5 A B 0.04923f
C6 VPWR VPB 0.07137f
C7 VPWR Y 0.11971f
C8 B VGND 0.05324f
C9 VPWR a_141_324# 0.01908f
C10 VPWR A 0.06442f
C11 VPWR VGND 0.03692f
C12 VPB Y 0.0132f
C13 A VPB 0.04956f
C14 a_141_324# Y 0.02225f
C15 A Y 0.056f
C16 VPB VGND 0.00746f
C17 VGND Y 0.15726f
C18 VGND VNB 0.35825f
C19 Y VNB 0.08057f
C20 VPWR VNB 0.2816f
C21 B VNB 0.15402f
C22 A VNB 0.15402f
C23 VPB VNB 0.42768f
.ends

.subckt sky130_efx_lvdig__nor2_2 A B Y VGND VNB VPB VPWR
X0 VGND A Y VNB sky130_fd_pr__nfet_01v8 ad=0.12285 pd=1.02 as=0.12285 ps=1.02 w=0.63 l=0.15
X1 Y B VGND VNB sky130_fd_pr__nfet_01v8 ad=0.12285 pd=1.02 as=0.12285 ps=1.02 w=0.63 l=0.15
X2 VGND B Y VNB sky130_fd_pr__nfet_01v8 ad=0.23625 pd=2.01 as=0.12285 ps=1.02 w=0.63 l=0.15
X3 VPWR A pmos_n6_f2_l150_hvt_ftf_1.S0 VPB sky130_fd_pr__pfet_01v8_hvt ad=0.2106 pd=1.47 as=0.405 ps=2.91 w=1.08 l=0.15
X4 pmos_n6_f2_l150_hvt_ftf_1.S0 A VPWR VPB sky130_fd_pr__pfet_01v8_hvt ad=0.2106 pd=1.47 as=0.2106 ps=1.47 w=1.08 l=0.15
X5 Y B pmos_n6_f2_l150_hvt_ftf_1.S0 VPB sky130_fd_pr__pfet_01v8_hvt ad=0.2106 pd=1.47 as=0.2106 ps=1.47 w=1.08 l=0.15
X6 pmos_n6_f2_l150_hvt_ftf_1.S0 B Y VPB sky130_fd_pr__pfet_01v8_hvt ad=0.405 pd=2.91 as=0.2106 ps=1.47 w=1.08 l=0.15
X7 Y A VGND VNB sky130_fd_pr__nfet_01v8 ad=0.12285 pd=1.02 as=0.23625 ps=2.01 w=0.63 l=0.15
C0 A pmos_n6_f2_l150_hvt_ftf_1.S0 0.09023f
C1 VGND pmos_n6_f2_l150_hvt_ftf_1.S0 0.01251f
C2 A VGND 0.07602f
C3 VPWR B 0.02298f
C4 B VPB 0.09566f
C5 B Y 0.11153f
C6 B pmos_n6_f2_l150_hvt_ftf_1.S0 0.07521f
C7 A B 0.04992f
C8 VPWR VPB 0.09882f
C9 VPWR Y 0.01004f
C10 B VGND 0.07508f
C11 VPWR A 0.04408f
C12 VPWR pmos_n6_f2_l150_hvt_ftf_1.S0 0.33744f
C13 VPWR VGND 0.05283f
C14 VPB Y 0.00946f
C15 VPB pmos_n6_f2_l150_hvt_ftf_1.S0 0.018f
C16 A VPB 0.09566f
C17 pmos_n6_f2_l150_hvt_ftf_1.S0 Y 0.15971f
C18 A Y 0.04979f
C19 VPB VGND 0.0087f
C20 VGND Y 0.30993f
C21 VGND VNB 0.47467f
C22 Y VNB 0.04389f
C23 VPWR VNB 0.3265f
C24 B VNB 0.24055f
C25 A VNB 0.24227f
C26 VPB VNB 0.68429f
C27 pmos_n6_f2_l150_hvt_ftf_1.S0 VNB 0.08526f
.ends

.subckt sky130_efx_lvdig__nor3_2 A B C Y VGND VNB VPB VPWR
X0 a_357_324# C Y VPB sky130_fd_pr__pfet_01v8_hvt ad=0.405 pd=2.91 as=0.2106 ps=1.47 w=1.08 l=0.15
X1 VGND A Y VNB sky130_fd_pr__nfet_01v8 ad=0.12285 pd=1.02 as=0.12285 ps=1.02 w=0.63 l=0.15
X2 Y B VGND VNB sky130_fd_pr__nfet_01v8 ad=0.12285 pd=1.02 as=0.12285 ps=1.02 w=0.63 l=0.15
X3 VGND B Y VNB sky130_fd_pr__nfet_01v8 ad=0.23625 pd=2.01 as=0.12285 ps=1.02 w=0.63 l=0.15
X4 VPWR A a_36_324# VPB sky130_fd_pr__pfet_01v8_hvt ad=0.2106 pd=1.47 as=0.405 ps=2.91 w=1.08 l=0.15
X5 a_36_324# A VPWR VPB sky130_fd_pr__pfet_01v8_hvt ad=0.2106 pd=1.47 as=0.2106 ps=1.47 w=1.08 l=0.15
X6 Y C VGND VNB sky130_fd_pr__nfet_01v8 ad=0.12285 pd=1.02 as=0.23625 ps=2.01 w=0.63 l=0.15
X7 VGND C Y VNB sky130_fd_pr__nfet_01v8 ad=0.23625 pd=2.01 as=0.12285 ps=1.02 w=0.63 l=0.15
X8 a_357_324# B a_36_324# VPB sky130_fd_pr__pfet_01v8_hvt ad=0.2106 pd=1.47 as=0.2106 ps=1.47 w=1.08 l=0.15
X9 a_36_324# B a_357_324# VPB sky130_fd_pr__pfet_01v8_hvt ad=0.405 pd=2.91 as=0.2106 ps=1.47 w=1.08 l=0.15
X10 Y A VGND VNB sky130_fd_pr__nfet_01v8 ad=0.12285 pd=1.02 as=0.23625 ps=2.01 w=0.63 l=0.15
X11 Y C a_357_324# VPB sky130_fd_pr__pfet_01v8_hvt ad=0.2106 pd=1.47 as=0.405 ps=2.91 w=1.08 l=0.15
C0 B a_36_324# 0.06816f
C1 Y a_357_324# 0.10499f
C2 VPB a_357_324# 0.02917f
C3 Y VPWR 0.01136f
C4 VPWR VPB 0.1562f
C5 C B 0.02972f
C6 VPWR A 0.04408f
C7 VGND Y 0.51634f
C8 VGND VPB 0.01395f
C9 a_36_324# a_357_324# 0.12949f
C10 B a_357_324# 0.0152f
C11 VPWR a_36_324# 0.22083f
C12 VPWR B 0.02578f
C13 VGND A 0.07602f
C14 Y VPB 0.01613f
C15 C a_357_324# 0.07661f
C16 VPWR C 0.02297f
C17 VGND a_36_324# 0.01116f
C18 VGND B 0.04313f
C19 Y A 0.03702f
C20 VPB A 0.09566f
C21 VPWR a_357_324# 0.32531f
C22 Y a_36_324# 0.04815f
C23 VGND C 0.05182f
C24 VPB a_36_324# 0.01675f
C25 Y B 0.07329f
C26 VPB B 0.08255f
C27 VGND a_357_324# 0.01828f
C28 Y C 0.13793f
C29 a_36_324# A 0.09023f
C30 VPB C 0.10171f
C31 B A 0.06097f
C32 VGND VPWR 0.08309f
C33 VGND VNB 0.68519f
C34 Y VNB 0.0776f
C35 VPWR VNB 0.47176f
C36 C VNB 0.24172f
C37 B VNB 0.17263f
C38 A VNB 0.24227f
C39 VPB VNB 1.11197f
C40 a_357_324# VNB 0.04635f
C41 a_36_324# VNB 0.04836f
.ends

.subckt sky130_efx_lvdig__o21a_1 A1 A2 B1 X VGND VNB VPB VPWR
X0 VGND A2 nmos_n3f5_f1_l150_0.S0 VNB sky130_fd_pr__nfet_01v8 ad=0.23625 pd=2.01 as=0.12285 ps=1.02 w=0.63 l=0.15
X1 a_141_324# A1 VPWR VPB sky130_fd_pr__pfet_01v8_hvt ad=0.2106 pd=1.47 as=0.405 ps=2.91 w=1.08 l=0.15
X2 X pmos_n6_f2_l150_hvt_fnf_0.D0 VGND VNB sky130_fd_pr__nfet_01v8 ad=0.23625 pd=2.01 as=0.23625 ps=2.01 w=0.63 l=0.15
X3 pmos_n6_f2_l150_hvt_fnf_0.D0 A2 a_141_324# VPB sky130_fd_pr__pfet_01v8_hvt ad=0.405 pd=2.91 as=0.2106 ps=1.47 w=1.08 l=0.15
X4 X pmos_n6_f2_l150_hvt_fnf_0.D0 VPWR VPB sky130_fd_pr__pfet_01v8_hvt ad=0.405 pd=2.91 as=0.405 ps=2.91 w=1.08 l=0.15
X5 nmos_n3f5_f1_l150_0.S0 A1 VGND VNB sky130_fd_pr__nfet_01v8 ad=0.12285 pd=1.02 as=0.23625 ps=2.01 w=0.63 l=0.15
X6 pmos_n6_f2_l150_hvt_fnf_0.D0 B1 VPWR VPB sky130_fd_pr__pfet_01v8_hvt ad=0.405 pd=2.91 as=0.405 ps=2.91 w=1.08 l=0.15
X7 pmos_n6_f2_l150_hvt_fnf_0.D0 B1 nmos_n3f5_f1_l150_0.S0 VNB sky130_fd_pr__nfet_01v8 ad=0.23625 pd=2.01 as=0.23625 ps=2.01 w=0.63 l=0.15
C0 X pmos_n6_f2_l150_hvt_fnf_0.D0 0.11842f
C1 VPB nmos_n3f5_f1_l150_0.S0 0.00258f
C2 X VPB 0.00999f
C3 VPB pmos_n6_f2_l150_hvt_fnf_0.D0 0.10556f
C4 VGND A1 0.05438f
C5 A1 nmos_n3f5_f1_l150_0.S0 0.00736f
C6 B1 A2 0.04604f
C7 A1 pmos_n6_f2_l150_hvt_fnf_0.D0 0.00444f
C8 A1 VPB 0.04956f
C9 VGND a_141_324# 0.00295f
C10 a_141_324# nmos_n3f5_f1_l150_0.S0 0.00457f
C11 A2 VGND 0.02541f
C12 VPWR B1 0.02458f
C13 A2 nmos_n3f5_f1_l150_0.S0 0.05235f
C14 pmos_n6_f2_l150_hvt_fnf_0.D0 a_141_324# 0.01126f
C15 A2 pmos_n6_f2_l150_hvt_fnf_0.D0 0.04374f
C16 A2 VPB 0.05339f
C17 VPWR VGND 0.08217f
C18 VPWR nmos_n3f5_f1_l150_0.S0 0.00947f
C19 X VPWR 0.08434f
C20 A2 A1 0.06327f
C21 VPWR pmos_n6_f2_l150_hvt_fnf_0.D0 0.32806f
C22 VPWR VPB 0.17532f
C23 B1 VGND 0.02114f
C24 B1 nmos_n3f5_f1_l150_0.S0 0.04085f
C25 B1 pmos_n6_f2_l150_hvt_fnf_0.D0 0.12614f
C26 VPWR A1 0.06465f
C27 B1 VPB 0.05944f
C28 VGND nmos_n3f5_f1_l150_0.S0 0.24914f
C29 X VGND 0.10221f
C30 VPWR a_141_324# 0.02624f
C31 VGND pmos_n6_f2_l150_hvt_fnf_0.D0 0.15197f
C32 pmos_n6_f2_l150_hvt_fnf_0.D0 nmos_n3f5_f1_l150_0.S0 0.06892f
C33 VGND VPB 0.01359f
C34 VPWR A2 0.02397f
C35 VGND VNB 0.63495f
C36 X VNB 0.1112f
C37 VPWR VNB 0.48274f
C38 B1 VNB 0.12615f
C39 A2 VNB 0.1166f
C40 A1 VNB 0.15633f
C41 VPB VNB 1.02643f
C42 nmos_n3f5_f1_l150_0.S0 VNB 0.03094f
C43 pmos_n6_f2_l150_hvt_fnf_0.D0 VNB 0.19265f
.ends

.subckt sky130_efx_lvdig__or2_1 A B X VGND VNB VPB VPWR
X0 VGND B a_141_36# VNB sky130_fd_pr__nfet_01v8 ad=0.16875 pd=1.65 as=0.08775 ps=0.84 w=0.45 l=0.15
X1 a_141_450# A VPWR VPB sky130_fd_pr__pfet_01v8_hvt ad=0.08775 pd=0.84 as=0.16875 ps=1.65 w=0.45 l=0.15
X2 a_141_36# A VGND VNB sky130_fd_pr__nfet_01v8 ad=0.08775 pd=0.84 as=0.16875 ps=1.65 w=0.45 l=0.15
X3 a_141_36# B a_141_450# VPB sky130_fd_pr__pfet_01v8_hvt ad=0.16875 pd=1.65 as=0.08775 ps=0.84 w=0.45 l=0.15
X4 X a_141_36# VPWR VPB sky130_fd_pr__pfet_01v8_hvt ad=0.405 pd=2.91 as=0.405 ps=2.91 w=1.08 l=0.15
X5 X a_141_36# VGND VNB sky130_fd_pr__nfet_01v8 ad=0.23625 pd=2.01 as=0.23625 ps=2.01 w=0.63 l=0.15
C0 VGND VPB 0.01592f
C1 VPWR a_141_36# 0.17439f
C2 X B 0.00138f
C3 VGND A 0.04458f
C4 X a_141_36# 0.11616f
C5 X VPWR 0.08434f
C6 VGND B 0.04521f
C7 a_141_36# a_141_450# 0.00873f
C8 VPWR a_141_450# 0.01236f
C9 A VPB 0.09793f
C10 VGND a_141_36# 0.19483f
C11 VGND VPWR 0.06339f
C12 VPB B 0.10842f
C13 VGND X 0.10221f
C14 VPB a_141_36# 0.1102f
C15 A B 0.08246f
C16 VPB VPWR 0.14188f
C18 A a_141_36# 0.06118f
C19 A VPWR 0.03612f
C20 VPB X 0.01417f
C21 a_141_36# B 0.16838f
C22 VPWR B 0.01943f
C23 VGND VNB 0.51208f
C24 X VNB 0.10825f
C25 VPWR VNB 0.37843f
C26 B VNB 0.13839f
C27 A VNB 0.18798f
C28 VPB VNB 0.76982f
C29 a_141_36# VNB 0.21154f
.ends

.subckt sky130_efx_lvdig__or2_2 A B X VGND VNB VPB VPWR
X0 VGND B a_141_36# VNB sky130_fd_pr__nfet_01v8 ad=0.16875 pd=1.65 as=0.08775 ps=0.84 w=0.45 l=0.15
X1 VGND a_141_36# X VNB sky130_fd_pr__nfet_01v8 ad=0.23625 pd=2.01 as=0.12285 ps=1.02 w=0.63 l=0.15
X2 a_141_450# A VPWR VPB sky130_fd_pr__pfet_01v8_hvt ad=0.08775 pd=0.84 as=0.16875 ps=1.65 w=0.45 l=0.15
X3 a_141_36# A VGND VNB sky130_fd_pr__nfet_01v8 ad=0.08775 pd=0.84 as=0.16875 ps=1.65 w=0.45 l=0.15
X4 a_141_36# B a_141_450# VPB sky130_fd_pr__pfet_01v8_hvt ad=0.16875 pd=1.65 as=0.08775 ps=0.84 w=0.45 l=0.15
X5 X a_141_36# VPWR VPB sky130_fd_pr__pfet_01v8_hvt ad=0.2106 pd=1.47 as=0.405 ps=2.91 w=1.08 l=0.15
X6 VPWR a_141_36# X VPB sky130_fd_pr__pfet_01v8_hvt ad=0.405 pd=2.91 as=0.2106 ps=1.47 w=1.08 l=0.15
X7 X a_141_36# VGND VNB sky130_fd_pr__nfet_01v8 ad=0.12285 pd=1.02 as=0.23625 ps=2.01 w=0.63 l=0.15
C0 VGND VPB 0.01454f
C1 VPWR a_141_36# 0.20521f
C2 X B 0.00138f
C3 VGND A 0.04458f
C4 X a_141_36# 0.16523f
C5 X VPWR 0.17204f
C6 VGND B 0.04534f
C7 a_141_36# a_141_450# 0.00873f
C8 VPWR a_141_450# 0.01236f
C9 VGND a_141_36# 0.22207f
C10 A VPB 0.09793f
C11 VGND VPWR 0.0815f
C12 VGND X 0.15357f
C13 VPB B 0.10919f
C14 A B 0.08246f
C15 a_141_36# VPB 0.1546f
C16 VPWR VPB 0.15165f
C18 A a_141_36# 0.06118f
C19 A VPWR 0.03612f
C20 X VPB 0.00744f
C21 a_141_36# B 0.16838f
C22 VPWR B 0.01988f
C23 VGND VNB 0.57574f
C24 X VNB 0.03806f
C25 VPWR VNB 0.44681f
C26 B VNB 0.13762f
C27 A VNB 0.18798f
C28 VPB VNB 0.85536f
C29 a_141_36# VNB 0.29977f
.ends

.subckt sky130_efx_lvdig__or2_4 A B X VGND VNB VPB VPWR
X0 VPWR pmos_n6_f2_l150_hvt_fnf_0.D0 X VPB sky130_fd_pr__pfet_01v8_hvt ad=0.405 pd=2.91 as=0.2106 ps=1.47 w=1.08 l=0.15
X1 VGND B pmos_n6_f2_l150_hvt_fnf_0.D0 VNB sky130_fd_pr__nfet_01v8 ad=0.23625 pd=2.01 as=0.12285 ps=1.02 w=0.63 l=0.15
X2 a_141_324# A VPWR VPB sky130_fd_pr__pfet_01v8_hvt ad=0.2106 pd=1.47 as=0.405 ps=2.91 w=1.08 l=0.15
X3 pmos_n6_f2_l150_hvt_fnf_0.D0 B a_141_324# VPB sky130_fd_pr__pfet_01v8_hvt ad=0.405 pd=2.91 as=0.2106 ps=1.47 w=1.08 l=0.15
X4 X pmos_n6_f2_l150_hvt_fnf_0.D0 VGND VNB sky130_fd_pr__nfet_01v8 ad=0.12285 pd=1.02 as=0.12285 ps=1.02 w=0.63 l=0.15
X5 VGND pmos_n6_f2_l150_hvt_fnf_0.D0 X VNB sky130_fd_pr__nfet_01v8 ad=0.23625 pd=2.01 as=0.12285 ps=1.02 w=0.63 l=0.15
X6 VGND pmos_n6_f2_l150_hvt_fnf_0.D0 X VNB sky130_fd_pr__nfet_01v8 ad=0.12285 pd=1.02 as=0.12285 ps=1.02 w=0.63 l=0.15
X7 pmos_n6_f2_l150_hvt_fnf_0.D0 A VGND VNB sky130_fd_pr__nfet_01v8 ad=0.12285 pd=1.02 as=0.23625 ps=2.01 w=0.63 l=0.15
X8 X pmos_n6_f2_l150_hvt_fnf_0.D0 VPWR VPB sky130_fd_pr__pfet_01v8_hvt ad=0.2106 pd=1.47 as=0.405 ps=2.91 w=1.08 l=0.15
X9 VPWR pmos_n6_f2_l150_hvt_fnf_0.D0 X VPB sky130_fd_pr__pfet_01v8_hvt ad=0.2106 pd=1.47 as=0.2106 ps=1.47 w=1.08 l=0.15
X10 X pmos_n6_f2_l150_hvt_fnf_0.D0 VGND VNB sky130_fd_pr__nfet_01v8 ad=0.12285 pd=1.02 as=0.23625 ps=2.01 w=0.63 l=0.15
X11 X pmos_n6_f2_l150_hvt_fnf_0.D0 VPWR VPB sky130_fd_pr__pfet_01v8_hvt ad=0.2106 pd=1.47 as=0.2106 ps=1.47 w=1.08 l=0.15
C0 VGND VPB 0.01259f
C1 VPWR pmos_n6_f2_l150_hvt_fnf_0.D0 0.30487f
C3 VGND A 0.05438f
C4 X pmos_n6_f2_l150_hvt_fnf_0.D0 0.28854f
C5 X VPWR 0.43561f
C6 VGND B 0.05399f
C7 pmos_n6_f2_l150_hvt_fnf_0.D0 a_141_324# 0.02225f
C8 VPWR a_141_324# 0.01908f
C9 VGND pmos_n6_f2_l150_hvt_fnf_0.D0 0.29912f
C10 A VPB 0.04956f
C11 VGND VPWR 0.1033f
C12 VGND X 0.34107f
C13 VPB B 0.05339f
C14 A B 0.04923f
C15 pmos_n6_f2_l150_hvt_fnf_0.D0 VPB 0.22386f
C16 VPWR VPB 0.17778f
C17 VGND a_141_324# 0.00181f
C18 A pmos_n6_f2_l150_hvt_fnf_0.D0 0.056f
C19 A VPWR 0.06465f
C20 X VPB 0.0153f
C21 pmos_n6_f2_l150_hvt_fnf_0.D0 B 0.15417f
C22 VPWR B 0.02048f
C23 VGND VNB 0.69339f
C24 X VNB 0.0492f
C25 VPWR VNB 0.54692f
C26 B VNB 0.11489f
C27 A VNB 0.15402f
C28 VPB VNB 1.11197f
C29 pmos_n6_f2_l150_hvt_fnf_0.D0 VNB 0.4455f
.ends

.subckt sky130_efx_lvdig__or3_1 A B C X VGND VNB VPB VPWR
X0 a_393_450# B a_141_450# VPB sky130_fd_pr__pfet_01v8_hvt ad=0.08775 pd=0.84 as=0.16875 ps=1.65 w=0.45 l=0.15
X1 a_141_36# C a_393_450# VPB sky130_fd_pr__pfet_01v8_hvt ad=0.16875 pd=1.65 as=0.08775 ps=0.84 w=0.45 l=0.15
X2 X a_141_36# VGND VNB sky130_fd_pr__nfet_01v8 ad=0.23625 pd=2.01 as=0.23625 ps=2.01 w=0.63 l=0.15
X3 X a_141_36# VPWR VPB sky130_fd_pr__pfet_01v8_hvt ad=0.405 pd=2.91 as=0.405 ps=2.91 w=1.08 l=0.15
X4 a_141_450# A VPWR VPB sky130_fd_pr__pfet_01v8_hvt ad=0.16875 pd=1.65 as=0.16875 ps=1.65 w=0.45 l=0.15
X5 a_141_36# A VGND VNB sky130_fd_pr__nfet_01v8 ad=0.16875 pd=1.65 as=0.16875 ps=1.65 w=0.45 l=0.15
X6 a_141_36# B VGND VNB sky130_fd_pr__nfet_01v8 ad=0.08775 pd=0.84 as=0.16875 ps=1.65 w=0.45 l=0.15
X7 VGND C a_141_36# VNB sky130_fd_pr__nfet_01v8 ad=0.16875 pd=1.65 as=0.08775 ps=0.84 w=0.45 l=0.15
C0 VPB a_141_450# 0.01582f
C1 a_141_36# a_393_450# 0.00889f
C2 X VPB 0.00999f
C3 C a_141_36# 0.16849f
C4 VGND A 0.04537f
C5 A a_141_450# 0.00406f
C6 C B 0.08246f
C7 A VPB 0.11458f
C8 VPWR a_393_450# 0.00767f
C9 VGND a_141_36# 0.31427f
C10 a_141_36# a_141_450# 0.0769f
C11 X a_141_36# 0.11616f
C12 B VGND 0.04407f
C13 VPWR C 0.0171f
C14 B a_141_450# 0.0051f
C15 VPB a_141_36# 0.1412f
C16 B VPB 0.10467f
C17 VPWR VGND 0.07949f
C18 A a_141_36# 0.0614f
C19 VPWR a_141_450# 0.1634f
C20 X VPWR 0.08434f
C21 B A 0.03135f
C23 a_141_450# a_393_450# 0.00469f
C24 VPWR VPB 0.17424f
C25 C VGND 0.04521f
C26 C a_141_450# 0.00175f
C27 X C 0.00138f
C28 B a_141_36# 0.13689f
C29 VPWR A 0.03682f
C30 C VPB 0.10794f
C31 VGND a_141_450# 0.00147f
C32 X VGND 0.10221f
C33 VPWR a_141_36# 0.17598f
C34 VGND VPB 0.01688f
C35 VPWR B 0.01679f
C36 VGND VNB 0.64288f
C37 X VNB 0.11242f
C38 VPWR VNB 0.46429f
C39 C VNB 0.13888f
C40 B VNB 0.135f
C41 A VNB 0.20286f
C42 VPB VNB 1.02643f
C44 a_141_36# VNB 0.24705f
.ends
