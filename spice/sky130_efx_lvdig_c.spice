* Copyright (c) 2026 Eric Fogleman
* SPDX-License-Identifier: Apache-2.0
* Derived from SkyWater sky130_fd_sc_hd (Apache-2.0); see NOTICE
*
* sky130_efx_lvdig standard cells: layout-extracted netlist with parasitic
* capacitance, one .subckt per cell from the layouts in mag/ (generated by
* `make libspice` / `PEX=c`; don't edit): every non-zero node-to-node and
* node-to-substrate capacitance (ext2spice cthresh 0; the substrate node is
* VNB), no resistance.
* Magic on a flattened copy of each cell (every device has its own
* source/drain area and perimeter). Internal nets have Magic's coordinate
* names (a_<x>_<y>#). Ports are in the same order as cdl/sky130_efx_lvdig.cdl
* (the schematic netlist), so the netlists can be swapped in a testbench.
*
* Cell topologies and device sizes are derived from SkyWater's sky130_fd_sc_hd
* (Apache-2.0; see NOTICE). Layouts are independent.
*
* Not interchangeable with the PDK's sky130_fd_sc_hd netlists:
*  - device widths are on the efx lambda grid (L = 0.18 um; e.g. 0.42 -> 0.45,
*    0.65 -> 0.63, 1.00 -> 1.08), conb_1's resistors W 0.45 x L 0.54
*  - ports: logic pins, then VGND VNB VPB VPWR (hd: power pins in between),
*    so instantiate by the .subckt lines below, not by hd's pin order
* Devices are sky130_fd_pr models; include the PDK model library first, e.g.
*   .lib $PDK_ROOT/sky130A/libs.tech/ngspice/sky130.lib.spice tt

.subckt sky130_efx_lvdig__a21o_1 A1 A2 B1 X VGND VNB VPB VPWR
X0 nmos_n3f5_f2_l150_fnf_0.D0 A1 a_141_36# VNB sky130_fd_pr__nfet_01v8 ad=0.23625 pd=2.01 as=0.12285 ps=1.02 w=0.63 l=0.15
X1 VPWR A2 pmos_n6_f2_l150_hvt_ftf_0.S0 VPB sky130_fd_pr__pfet_01v8_hvt ad=0.2106 pd=1.47 as=0.405 ps=2.91 w=1.08 l=0.15
X2 X nmos_n3f5_f2_l150_fnf_0.D0 VGND VNB sky130_fd_pr__nfet_01v8 ad=0.23625 pd=2.01 as=0.23625 ps=2.01 w=0.63 l=0.15
X3 pmos_n6_f2_l150_hvt_ftf_0.S0 A1 VPWR VPB sky130_fd_pr__pfet_01v8_hvt ad=0.405 pd=2.91 as=0.2106 ps=1.47 w=1.08 l=0.15
X4 X nmos_n3f5_f2_l150_fnf_0.D0 VPWR VPB sky130_fd_pr__pfet_01v8_hvt ad=0.405 pd=2.91 as=0.405 ps=2.91 w=1.08 l=0.15
X5 a_141_36# A2 VGND VNB sky130_fd_pr__nfet_01v8 ad=0.12285 pd=1.02 as=0.23625 ps=2.01 w=0.63 l=0.15
X6 pmos_n6_f2_l150_hvt_ftf_0.S0 B1 nmos_n3f5_f2_l150_fnf_0.D0 VPB sky130_fd_pr__pfet_01v8_hvt ad=0.405 pd=2.91 as=0.405 ps=2.91 w=1.08 l=0.15
X7 VGND B1 nmos_n3f5_f2_l150_fnf_0.D0 VNB sky130_fd_pr__nfet_01v8 ad=0.23625 pd=2.01 as=0.23625 ps=2.01 w=0.63 l=0.15
C0 VPWR nmos_n3f5_f2_l150_fnf_0.D0 0.08205f
C1 VPWR VPB 0.16185f
C2 B1 VGND 0.054f
C4 A1 pmos_n6_f2_l150_hvt_ftf_0.S0 0.05856f
C5 B1 nmos_n3f5_f2_l150_fnf_0.D0 0.14331f
C6 VPWR A2 0.02169f
C7 B1 VPB 0.05944f
C8 VGND a_141_36# 0.01672f
C9 X VGND 0.10221f
C10 VPWR pmos_n6_f2_l150_hvt_ftf_0.S0 0.37233f
C11 VGND nmos_n3f5_f2_l150_fnf_0.D0 0.27376f
C12 nmos_n3f5_f2_l150_fnf_0.D0 a_141_36# 0.00657f
C13 VGND VPB 0.01447f
C14 VPWR A1 0.02241f
C15 X nmos_n3f5_f2_l150_fnf_0.D0 0.10826f
C16 X VPB 0.01078f
C17 VPB nmos_n3f5_f2_l150_fnf_0.D0 0.08619f
C18 B1 pmos_n6_f2_l150_hvt_ftf_0.S0 0.0115f
C19 VGND A2 0.05267f
C20 B1 A1 0.01968f
C21 A2 nmos_n3f5_f2_l150_fnf_0.D0 0.00301f
C22 A2 VPB 0.04956f
C23 VGND pmos_n6_f2_l150_hvt_ftf_0.S0 0.01831f
C24 pmos_n6_f2_l150_hvt_ftf_0.S0 a_141_36# 0.00307f
C25 X pmos_n6_f2_l150_hvt_ftf_0.S0 0.00575f
C26 A1 VGND 0.02239f
C27 VPWR B1 0.01315f
C28 nmos_n3f5_f2_l150_fnf_0.D0 pmos_n6_f2_l150_hvt_ftf_0.S0 0.09534f
C29 VPB pmos_n6_f2_l150_hvt_ftf_0.S0 0.03277f
C30 A1 nmos_n3f5_f2_l150_fnf_0.D0 0.05417f
C31 A1 VPB 0.05339f
C32 VPWR VGND 0.07871f
C33 A2 pmos_n6_f2_l150_hvt_ftf_0.S0 0.05856f
C34 VPWR a_141_36# 0.00143f
C35 X VPWR 0.08434f
C36 A1 A2 0.06327f
C37 VGND VNB 0.63677f
C38 X VNB 0.11242f
C39 VPWR VNB 0.44437f
C40 B1 VNB 0.12675f
C41 A1 VNB 0.1215f
C42 A2 VNB 0.15633f
C43 VPB VNB 1.02643f
C44 pmos_n6_f2_l150_hvt_ftf_0.S0 VNB 0.0481f
C45 nmos_n3f5_f2_l150_fnf_0.D0 VNB 0.20412f
.ends

.subckt sky130_efx_lvdig__a22o_1 A1 A2 B1 B2 X VGND VNB VPB VPWR
X0 nmos_n3f5_f2_l150_fnf_1.S0 A1 a_141_36# VNB sky130_fd_pr__nfet_01v8 ad=0.23625 pd=2.01 as=0.12285 ps=1.02 w=0.63 l=0.15
X1 X nmos_n3f5_f2_l150_fnf_1.S0 VGND VNB sky130_fd_pr__nfet_01v8 ad=0.23625 pd=2.01 as=0.23625 ps=2.01 w=0.63 l=0.15
X2 a_141_324# A2 VPWR VPB sky130_fd_pr__pfet_01v8_hvt ad=0.2106 pd=1.47 as=0.405 ps=2.91 w=1.08 l=0.15
X3 VPWR A1 a_141_324# VPB sky130_fd_pr__pfet_01v8_hvt ad=0.405 pd=2.91 as=0.2106 ps=1.47 w=1.08 l=0.15
X4 VGND B2 a_501_36# VNB sky130_fd_pr__nfet_01v8 ad=0.23625 pd=2.01 as=0.12285 ps=1.02 w=0.63 l=0.15
X5 X nmos_n3f5_f2_l150_fnf_1.S0 VPWR VPB sky130_fd_pr__pfet_01v8_hvt ad=0.405 pd=2.91 as=0.405 ps=2.91 w=1.08 l=0.15
X6 a_141_36# A2 VGND VNB sky130_fd_pr__nfet_01v8 ad=0.12285 pd=1.02 as=0.23625 ps=2.01 w=0.63 l=0.15
X7 nmos_n3f5_f2_l150_fnf_1.S0 B1 a_141_324# VPB sky130_fd_pr__pfet_01v8_hvt ad=0.2106 pd=1.47 as=0.405 ps=2.91 w=1.08 l=0.15
X8 a_141_324# B2 nmos_n3f5_f2_l150_fnf_1.S0 VPB sky130_fd_pr__pfet_01v8_hvt ad=0.405 pd=2.91 as=0.2106 ps=1.47 w=1.08 l=0.15
X9 a_501_36# B1 nmos_n3f5_f2_l150_fnf_1.S0 VNB sky130_fd_pr__nfet_01v8 ad=0.12285 pd=1.02 as=0.23625 ps=2.01 w=0.63 l=0.15
C0 VGND B1 0.01843f
C1 A2 nmos_n3f5_f2_l150_fnf_1.S0 0.00276f
C2 VGND a_141_36# 0.01672f
C3 VPB B2 0.05339f
C4 A1 VGND 0.02228f
C5 VGND X 0.10221f
C6 B2 VPWR 0.01229f
C7 VPB B1 0.05339f
C8 B1 VPWR 0.013f
C9 nmos_n3f5_f2_l150_fnf_1.S0 a_501_36# 0.01365f
C10 VGND nmos_n3f5_f2_l150_fnf_1.S0 0.28348f
C11 VPWR a_141_36# 0.00147f
C12 A1 VPB 0.05339f
C13 VPB X 0.01417f
C14 A1 VPWR 0.02379f
C15 X VPWR 0.08434f
C16 VPB nmos_n3f5_f2_l150_fnf_1.S0 0.08336f
C17 VPWR nmos_n3f5_f2_l150_fnf_1.S0 0.08292f
C18 B1 B2 0.04923f
C20 A1 B1 0.04604f
C22 B2 nmos_n3f5_f2_l150_fnf_1.S0 0.14147f
C23 A2 a_141_324# 0.00973f
C24 B1 nmos_n3f5_f2_l150_fnf_1.S0 0.09117f
C25 nmos_n3f5_f2_l150_fnf_1.S0 a_141_36# 0.00657f
C26 A1 nmos_n3f5_f2_l150_fnf_1.S0 0.0319f
C27 X nmos_n3f5_f2_l150_fnf_1.S0 0.10829f
C29 VGND a_141_324# 0.01586f
C30 VPB a_141_324# 0.03116f
C31 VPWR a_141_324# 0.43308f
C32 B2 a_141_324# 0.01189f
C33 B1 a_141_324# 0.05315f
C34 VGND A2 0.05375f
C35 a_141_324# a_141_36# 0.00295f
C36 A1 a_141_324# 0.056f
C37 X a_141_324# 0.00612f
C38 A2 VPB 0.04956f
C39 A2 VPWR 0.06512f
C40 VGND a_501_36# 0.01034f
C41 nmos_n3f5_f2_l150_fnf_1.S0 a_141_324# 0.11281f
C42 VGND VPB 0.01785f
C44 VGND VPWR 0.09518f
C45 VPB VPWR 0.20187f
C46 A1 A2 0.06327f
C47 VGND B2 0.0531f
C48 VGND VNB 0.72048f
C49 X VNB 0.10825f
C50 VPWR VNB 0.5411f
C51 B2 VNB 0.11489f
C52 B1 VNB 0.11489f
C53 A1 VNB 0.1172f
C54 A2 VNB 0.15633f
C55 VPB VNB 1.1975f
C56 a_141_324# VNB 0.00964f
C57 nmos_n3f5_f2_l150_fnf_1.S0 VNB 0.20223f
.ends

.subckt sky130_efx_lvdig__and2_1 A B X VGND VNB VPB VPWR
X0 a_141_450# A a_141_36# VNB sky130_fd_pr__nfet_01v8 ad=0.16875 pd=1.65 as=0.08775 ps=0.84 w=0.45 l=0.15
X1 a_141_450# B VPWR VPB sky130_fd_pr__pfet_01v8_hvt ad=0.08775 pd=0.84 as=0.16875 ps=1.65 w=0.45 l=0.15
X2 a_141_36# B VGND VNB sky130_fd_pr__nfet_01v8 ad=0.08775 pd=0.84 as=0.16875 ps=1.65 w=0.45 l=0.15
X3 VPWR A a_141_450# VPB sky130_fd_pr__pfet_01v8_hvt ad=0.16875 pd=1.65 as=0.08775 ps=0.84 w=0.45 l=0.15
X4 X a_141_450# VPWR VPB sky130_fd_pr__pfet_01v8_hvt ad=0.405 pd=2.91 as=0.405 ps=2.91 w=1.08 l=0.15
X5 X a_141_450# VGND VNB sky130_fd_pr__nfet_01v8 ad=0.23625 pd=2.01 as=0.23625 ps=2.01 w=0.63 l=0.15
C0 VPB a_141_450# 0.10665f
C1 B A 0.08246f
C2 VPB VPWR 0.14391f
C3 VGND a_141_36# 0.01015f
C4 B a_141_450# 0.06559f
C5 B VPWR 0.0366f
C6 VPB X 0.01538f
C7 a_141_450# A 0.19739f
C8 VPWR A 0.02484f
C9 VGND VPB 0.01587f
C10 VPWR a_141_450# 0.22713f
C11 X A 0.00172f
C12 VGND B 0.04411f
C13 X a_141_450# 0.11164f
C14 X VPWR 0.08657f
C15 VGND A 0.0195f
C16 a_141_450# a_141_36# 0.00967f
C18 B VPB 0.09793f
C19 VGND a_141_450# 0.18928f
C20 VGND VPWR 0.06339f
C21 VPB A 0.10842f
C22 VGND X 0.10221f
C23 VGND VNB 0.50841f
C24 X VNB 0.10825f
C25 VPWR VNB 0.37608f
C26 A VNB 0.13782f
C27 B VNB 0.18798f
C28 VPB VNB 0.76982f
C29 a_141_450# VNB 0.22095f
.ends

.subckt sky130_efx_lvdig__and2_2 A B X VGND VNB VPB VPWR
X0 a_141_450# A a_141_36# VNB sky130_fd_pr__nfet_01v8 ad=0.16875 pd=1.65 as=0.08775 ps=0.84 w=0.45 l=0.15
X1 VGND a_141_450# X VNB sky130_fd_pr__nfet_01v8 ad=0.23625 pd=2.01 as=0.12285 ps=1.02 w=0.63 l=0.15
X2 a_141_450# B VPWR VPB sky130_fd_pr__pfet_01v8_hvt ad=0.08775 pd=0.84 as=0.16875 ps=1.65 w=0.45 l=0.15
X3 a_141_36# B VGND VNB sky130_fd_pr__nfet_01v8 ad=0.08775 pd=0.84 as=0.16875 ps=1.65 w=0.45 l=0.15
X4 VPWR A a_141_450# VPB sky130_fd_pr__pfet_01v8_hvt ad=0.16875 pd=1.65 as=0.08775 ps=0.84 w=0.45 l=0.15
X5 X a_141_450# VPWR VPB sky130_fd_pr__pfet_01v8_hvt ad=0.2106 pd=1.47 as=0.405 ps=2.91 w=1.08 l=0.15
X6 VPWR a_141_450# X VPB sky130_fd_pr__pfet_01v8_hvt ad=0.405 pd=2.91 as=0.2106 ps=1.47 w=1.08 l=0.15
X7 X a_141_450# VGND VNB sky130_fd_pr__nfet_01v8 ad=0.12285 pd=1.02 as=0.23625 ps=2.01 w=0.63 l=0.15
C0 B A 0.08246f
C1 a_141_450# VPB 0.15106f
C2 VPWR VPB 0.15368f
C3 VGND a_141_36# 0.01015f
C4 B a_141_450# 0.06559f
C5 B VPWR 0.0366f
C6 X VPB 0.00865f
C7 a_141_450# A 0.19739f
C8 VPWR A 0.0253f
C9 VGND VPB 0.01449f
C10 VPWR a_141_450# 0.25795f
C11 X A 0.00172f
C12 VGND B 0.04411f
C13 X a_141_450# 0.16072f
C14 X VPWR 0.17427f
C15 VGND A 0.01963f
C16 a_141_450# a_141_36# 0.00967f
C18 VGND a_141_450# 0.21652f
C19 B VPB 0.09793f
C20 VGND VPWR 0.0815f
C21 VGND X 0.15357f
C22 VPB A 0.10919f
C23 VGND VNB 0.57207f
C24 X VNB 0.03806f
C25 VPWR VNB 0.44447f
C26 A VNB 0.13705f
C27 B VNB 0.18798f
C28 VPB VNB 0.85536f
C29 a_141_450# VNB 0.30918f
.ends

.subckt sky130_efx_lvdig__and2_4 A B X VGND VNB VPB VPWR
X0 VPWR nmos_n3f5_f2_l150_fnf_0.D0 X VPB sky130_fd_pr__pfet_01v8_hvt ad=0.405 pd=2.91 as=0.2106 ps=1.47 w=1.08 l=0.15
X1 nmos_n3f5_f2_l150_fnf_0.D0 A a_141_36# VNB sky130_fd_pr__nfet_01v8 ad=0.23625 pd=2.01 as=0.12285 ps=1.02 w=0.63 l=0.15
X2 nmos_n3f5_f2_l150_fnf_0.D0 B VPWR VPB sky130_fd_pr__pfet_01v8_hvt ad=0.2106 pd=1.47 as=0.405 ps=2.91 w=1.08 l=0.15
X3 VPWR A nmos_n3f5_f2_l150_fnf_0.D0 VPB sky130_fd_pr__pfet_01v8_hvt ad=0.405 pd=2.91 as=0.2106 ps=1.47 w=1.08 l=0.15
X4 X nmos_n3f5_f2_l150_fnf_0.D0 VGND VNB sky130_fd_pr__nfet_01v8 ad=0.12285 pd=1.02 as=0.12285 ps=1.02 w=0.63 l=0.15
X5 VGND nmos_n3f5_f2_l150_fnf_0.D0 X VNB sky130_fd_pr__nfet_01v8 ad=0.23625 pd=2.01 as=0.12285 ps=1.02 w=0.63 l=0.15
X6 VGND nmos_n3f5_f2_l150_fnf_0.D0 X VNB sky130_fd_pr__nfet_01v8 ad=0.12285 pd=1.02 as=0.12285 ps=1.02 w=0.63 l=0.15
X7 a_141_36# B VGND VNB sky130_fd_pr__nfet_01v8 ad=0.12285 pd=1.02 as=0.23625 ps=2.01 w=0.63 l=0.15
X8 X nmos_n3f5_f2_l150_fnf_0.D0 VPWR VPB sky130_fd_pr__pfet_01v8_hvt ad=0.2106 pd=1.47 as=0.405 ps=2.91 w=1.08 l=0.15
X9 VPWR nmos_n3f5_f2_l150_fnf_0.D0 X VPB sky130_fd_pr__pfet_01v8_hvt ad=0.2106 pd=1.47 as=0.2106 ps=1.47 w=1.08 l=0.15
X10 X nmos_n3f5_f2_l150_fnf_0.D0 VGND VNB sky130_fd_pr__nfet_01v8 ad=0.12285 pd=1.02 as=0.23625 ps=2.01 w=0.63 l=0.15
X11 X nmos_n3f5_f2_l150_fnf_0.D0 VPWR VPB sky130_fd_pr__pfet_01v8_hvt ad=0.2106 pd=1.47 as=0.2106 ps=1.47 w=1.08 l=0.15
C0 B A 0.04923f
C1 nmos_n3f5_f2_l150_fnf_0.D0 VPB 0.2201f
C2 VPWR VPB 0.17877f
C3 VGND a_141_36# 0.01034f
C4 B nmos_n3f5_f2_l150_fnf_0.D0 0.05785f
C5 B VPWR 0.06512f
C6 X VPB 0.0153f
C7 nmos_n3f5_f2_l150_fnf_0.D0 A 0.18781f
C8 VPWR A 0.02376f
C9 VGND VPB 0.01254f
C10 VPWR nmos_n3f5_f2_l150_fnf_0.D0 0.37571f
C12 VGND B 0.0539f
C13 X nmos_n3f5_f2_l150_fnf_0.D0 0.28553f
C14 X VPWR 0.43734f
C15 VGND A 0.01875f
C16 nmos_n3f5_f2_l150_fnf_0.D0 a_141_36# 0.01356f
C18 VGND nmos_n3f5_f2_l150_fnf_0.D0 0.2867f
C19 B VPB 0.04956f
C20 VGND VPWR 0.1038f
C21 VGND X 0.34107f
C22 VPB A 0.05339f
C23 VGND VNB 0.69156f
C24 X VNB 0.0492f
C25 VPWR VNB 0.54373f
C26 A VNB 0.11489f
C27 B VNB 0.15402f
C28 VPB VNB 1.11197f
C29 nmos_n3f5_f2_l150_fnf_0.D0 VNB 0.4529f
.ends

.subckt sky130_efx_lvdig__and3_1 A B C X VGND VNB VPB VPWR
X0 a_141_450# B VPWR VPB sky130_fd_pr__pfet_01v8_hvt ad=0.08775 pd=0.84 as=0.16875 ps=1.65 w=0.45 l=0.15
X1 VPWR A a_141_450# VPB sky130_fd_pr__pfet_01v8_hvt ad=0.16875 pd=1.65 as=0.08775 ps=0.84 w=0.45 l=0.15
X2 X a_141_450# VGND VNB sky130_fd_pr__nfet_01v8 ad=0.23625 pd=2.01 as=0.23625 ps=2.01 w=0.63 l=0.15
X3 X a_141_450# VPWR VPB sky130_fd_pr__pfet_01v8_hvt ad=0.405 pd=2.91 as=0.405 ps=2.91 w=1.08 l=0.15
X4 a_141_450# C VPWR VPB sky130_fd_pr__pfet_01v8_hvt ad=0.16875 pd=1.65 as=0.16875 ps=1.65 w=0.45 l=0.15
X5 a_141_36# C VGND VNB sky130_fd_pr__nfet_01v8 ad=0.16875 pd=1.65 as=0.16875 ps=1.65 w=0.45 l=0.15
X6 a_393_36# B a_141_36# VNB sky130_fd_pr__nfet_01v8 ad=0.08775 pd=0.84 as=0.16875 ps=1.65 w=0.45 l=0.15
X7 a_141_450# A a_393_36# VNB sky130_fd_pr__nfet_01v8 ad=0.16875 pd=1.65 as=0.08775 ps=0.84 w=0.45 l=0.15
C0 a_141_36# a_393_36# 0.00379f
C1 VPWR VPB 0.18804f
C2 A VGND 0.01753f
C3 A a_141_36# 0.0014f
C4 X A 0.00172f
C5 B a_141_450# 0.11896f
C6 VPWR C 0.03739f
C7 A VPB 0.10794f
C8 VGND a_141_36# 0.1634f
C9 X VGND 0.10221f
C10 VPWR a_141_450# 0.37677f
C11 VGND VPB 0.01692f
C12 VPWR B 0.02487f
C13 VPB a_141_36# 0.00167f
C14 a_141_450# a_393_36# 0.00974f
C15 X VPB 0.01121f
C16 A a_141_450# 0.19749f
C17 VGND C 0.0448f
C18 C a_141_36# 0.00406f
C19 A B 0.08246f
C20 C VPB 0.11458f
C22 VGND a_141_450# 0.17733f
C23 a_141_450# a_141_36# 0.03382f
C24 X a_141_450# 0.11164f
C25 B VGND 0.01946f
C26 VPWR A 0.02484f
C27 B a_141_36# 0.02154f
C28 VPB a_141_450# 0.14783f
C29 B VPB 0.10467f
C30 VPWR VGND 0.07949f
C31 C a_141_450# 0.01937f
C32 VPWR a_141_36# 0.00147f
C33 X VPWR 0.08657f
C34 B C 0.0414f
C35 VGND a_393_36# 0.00635f
C36 VGND VNB 0.62894f
C37 X VNB 0.11242f
C38 VPWR VNB 0.46137f
C39 A VNB 0.13831f
C40 B VNB 0.13713f
C41 C VNB 0.20711f
C42 VPB VNB 1.02643f
C43 a_141_36# VNB 0.02322f
C44 a_141_450# VNB 0.22971f
.ends

.subckt sky130_efx_lvdig__and4_2 A B C D X VGND VNB VPB VPWR
X0 a_249_36# C a_141_36# VNB sky130_fd_pr__nfet_01v8 ad=0.16875 pd=1.65 as=0.08775 ps=0.84 w=0.45 l=0.15
X1 X a_141_450# VGND VNB sky130_fd_pr__nfet_01v8 ad=0.12285 pd=1.02 as=0.23625 ps=2.01 w=0.63 l=0.15
X2 a_141_450# B VPWR VPB sky130_fd_pr__pfet_01v8_hvt ad=0.08775 pd=0.84 as=0.16875 ps=1.65 w=0.45 l=0.15
X3 VPWR A a_141_450# VPB sky130_fd_pr__pfet_01v8_hvt ad=0.16875 pd=1.65 as=0.08775 ps=0.84 w=0.45 l=0.15
X4 a_141_450# A a_501_36# VNB sky130_fd_pr__nfet_01v8 ad=0.16875 pd=1.65 as=0.08775 ps=0.84 w=0.45 l=0.15
X5 a_141_450# D VPWR VPB sky130_fd_pr__pfet_01v8_hvt ad=0.08775 pd=0.84 as=0.16875 ps=1.65 w=0.45 l=0.15
X6 X a_141_450# VPWR VPB sky130_fd_pr__pfet_01v8_hvt ad=0.2106 pd=1.47 as=0.405 ps=2.91 w=1.08 l=0.15
X7 a_141_36# D VGND VNB sky130_fd_pr__nfet_01v8 ad=0.08775 pd=0.84 as=0.16875 ps=1.65 w=0.45 l=0.15
X8 VGND a_141_450# X VNB sky130_fd_pr__nfet_01v8 ad=0.23625 pd=2.01 as=0.12285 ps=1.02 w=0.63 l=0.15
X9 VPWR a_141_450# X VPB sky130_fd_pr__pfet_01v8_hvt ad=0.405 pd=2.91 as=0.2106 ps=1.47 w=1.08 l=0.15
X10 VPWR C a_141_450# VPB sky130_fd_pr__pfet_01v8_hvt ad=0.16875 pd=1.65 as=0.08775 ps=0.84 w=0.45 l=0.15
X11 a_501_36# B a_249_36# VNB sky130_fd_pr__nfet_01v8 ad=0.08775 pd=0.84 as=0.16875 ps=1.65 w=0.45 l=0.15
C0 VGND B 0.01936f
C1 D a_141_450# 0.01619f
C2 a_249_36# a_501_36# 0.00379f
C3 VGND a_249_36# 0.14074f
C4 VPB A 0.10919f
C5 C VGND 0.02153f
C6 VGND X 0.15357f
C7 A VPWR 0.0253f
C8 VPB B 0.10467f
C9 B VPWR 0.025f
C10 a_141_450# a_501_36# 0.00974f
C12 VGND a_141_450# 0.21419f
C13 VPWR a_249_36# 0.00145f
C14 C VPB 0.10467f
C15 VPB X 0.00865f
C16 C VPWR 0.025f
C17 X VPWR 0.17427f
C18 VPB a_141_450# 0.20205f
C19 VPWR a_141_450# 0.45207f
C20 B A 0.08246f
C21 A a_249_36# 0.0014f
C22 B a_249_36# 0.02154f
C23 A X 0.00172f
C24 C B 0.05771f
C25 C a_249_36# 0.02154f
C26 A a_141_450# 0.19749f
C27 B a_141_450# 0.11782f
C28 a_141_450# a_249_36# 0.02577f
C29 C a_141_450# 0.06867f
C30 X a_141_450# 0.16072f
C31 VGND a_141_36# 0.01236f
C33 VGND D 0.04393f
C34 a_141_36# a_249_36# 0.00469f
C35 D VPB 0.09793f
C36 D VPWR 0.0366f
C37 VGND a_501_36# 0.00635f
C38 a_141_450# a_141_36# 0.0019f
C39 VGND VPB 0.02051f
C41 VGND VPWR 0.11115f
C42 VPB VPWR 0.23111f
C43 D a_249_36# 0.00175f
C44 C D 0.0965f
C45 VGND A 0.01761f
C46 VGND VNB 0.78061f
C47 X VNB 0.03806f
C48 VPWR VNB 0.58749f
C49 A VNB 0.13705f
C50 B VNB 0.1307f
C51 C VNB 0.13301f
C52 D VNB 0.19029f
C53 VPB VNB 1.28304f
C54 a_249_36# VNB 0.02119f
C55 a_141_450# VNB 0.31609f
.ends

.subckt sky130_efx_lvdig__buf_1 A X VGND VNB VPB VPWR
X0 pmos_n4f5_f1_l150_hvt_0.D0 A VPWR VPB sky130_fd_pr__pfet_01v8_hvt ad=0.30375 pd=2.37 as=0.30375 ps=2.37 w=0.81 l=0.15
X1 X pmos_n4f5_f1_l150_hvt_0.D0 VPWR VPB sky130_fd_pr__pfet_01v8_hvt ad=0.30375 pd=2.37 as=0.30375 ps=2.37 w=0.81 l=0.15
X2 pmos_n4f5_f1_l150_hvt_0.D0 A VGND VNB sky130_fd_pr__nfet_01v8 ad=0.2025 pd=1.83 as=0.2025 ps=1.83 w=0.54 l=0.15
X3 X pmos_n4f5_f1_l150_hvt_0.D0 VGND VNB sky130_fd_pr__nfet_01v8 ad=0.2025 pd=1.83 as=0.2025 ps=1.83 w=0.54 l=0.15
C0 X VPB 0.01701f
C1 VPWR X 0.11669f
C2 X pmos_n4f5_f1_l150_hvt_0.D0 0.0765f
C3 VGND A 0.04989f
C4 VGND VPB 0.01397f
C5 VGND pmos_n4f5_f1_l150_hvt_0.D0 0.17189f
C6 VGND VPWR 0.05372f
C7 A VPB 0.08142f
C8 VPWR A 0.04838f
C9 A pmos_n4f5_f1_l150_hvt_0.D0 0.07406f
C10 VPB pmos_n4f5_f1_l150_hvt_0.D0 0.11957f
C11 VPWR VPB 0.12004f
C12 VPWR pmos_n4f5_f1_l150_hvt_0.D0 0.20543f
C13 VGND X 0.09485f
C14 VGND VNB 0.42439f
C15 X VNB 0.11341f
C16 VPWR VNB 0.33045f
C17 A VNB 0.18333f
C18 VPB VNB 0.59875f
C19 pmos_n4f5_f1_l150_hvt_0.D0 VNB 0.23795f
.ends

.subckt sky130_efx_lvdig__buf_2 A X VGND VNB VPB VPWR
X0 pmos_n3f5_f1_l150_hvt_0.D0 A VPWR VPB sky130_fd_pr__pfet_01v8_hvt ad=0.23625 pd=2.01 as=0.23625 ps=2.01 w=0.63 l=0.15
X1 pmos_n3f5_f1_l150_hvt_0.D0 A VGND VNB sky130_fd_pr__nfet_01v8 ad=0.16875 pd=1.65 as=0.16875 ps=1.65 w=0.45 l=0.15
X2 X pmos_n3f5_f1_l150_hvt_0.D0 VPWR VPB sky130_fd_pr__pfet_01v8_hvt ad=0.2106 pd=1.47 as=0.405 ps=2.91 w=1.08 l=0.15
X3 VPWR pmos_n3f5_f1_l150_hvt_0.D0 X VPB sky130_fd_pr__pfet_01v8_hvt ad=0.405 pd=2.91 as=0.2106 ps=1.47 w=1.08 l=0.15
X4 X pmos_n3f5_f1_l150_hvt_0.D0 VGND VNB sky130_fd_pr__nfet_01v8 ad=0.12285 pd=1.02 as=0.23625 ps=2.01 w=0.63 l=0.15
X5 VGND pmos_n3f5_f1_l150_hvt_0.D0 X VNB sky130_fd_pr__nfet_01v8 ad=0.23625 pd=2.01 as=0.12285 ps=1.02 w=0.63 l=0.15
C0 VPWR X 0.22627f
C1 X pmos_n3f5_f1_l150_hvt_0.D0 0.11017f
C2 VGND A 0.04637f
C3 VGND VPB 0.01756f
C4 VGND pmos_n3f5_f1_l150_hvt_0.D0 0.19525f
C5 VGND VPWR 0.08723f
C6 A VPB 0.10218f
C7 VPWR A 0.04391f
C8 A pmos_n3f5_f1_l150_hvt_0.D0 0.09439f
C9 VPWR VPB 0.15612f
C10 pmos_n3f5_f1_l150_hvt_0.D0 VPB 0.15195f
C11 VPWR pmos_n3f5_f1_l150_hvt_0.D0 0.23881f
C12 VGND X 0.15357f
C14 X VPB 0.00808f
C15 VGND VNB 0.53408f
C16 X VNB 0.03639f
C17 VPWR VNB 0.42104f
C18 A VNB 0.20034f
C19 VPB VNB 0.76982f
C20 pmos_n3f5_f1_l150_hvt_0.D0 VNB 0.32719f
.ends

.subckt sky130_efx_lvdig__buf_4 A X VGND VNB VPB VPWR
X0 nmos_n3f5_f1_l150_0.D0 A VPWR VPB sky130_fd_pr__pfet_01v8_hvt ad=0.405 pd=2.91 as=0.405 ps=2.91 w=1.08 l=0.15
X1 VGND nmos_n3f5_f1_l150_0.D0 X VNB sky130_fd_pr__nfet_01v8 ad=0.23625 pd=2.01 as=0.12285 ps=1.02 w=0.63 l=0.15
X2 X nmos_n3f5_f1_l150_0.D0 VGND VNB sky130_fd_pr__nfet_01v8 ad=0.12285 pd=1.02 as=0.12285 ps=1.02 w=0.63 l=0.15
X3 nmos_n3f5_f1_l150_0.D0 A VGND VNB sky130_fd_pr__nfet_01v8 ad=0.23625 pd=2.01 as=0.23625 ps=2.01 w=0.63 l=0.15
X4 X nmos_n3f5_f1_l150_0.D0 VPWR VPB sky130_fd_pr__pfet_01v8_hvt ad=0.2106 pd=1.47 as=0.405 ps=2.91 w=1.08 l=0.15
X5 VPWR nmos_n3f5_f1_l150_0.D0 X VPB sky130_fd_pr__pfet_01v8_hvt ad=0.2106 pd=1.47 as=0.2106 ps=1.47 w=1.08 l=0.15
X6 X nmos_n3f5_f1_l150_0.D0 VPWR VPB sky130_fd_pr__pfet_01v8_hvt ad=0.2106 pd=1.47 as=0.2106 ps=1.47 w=1.08 l=0.15
X7 X nmos_n3f5_f1_l150_0.D0 VGND VNB sky130_fd_pr__nfet_01v8 ad=0.12285 pd=1.02 as=0.23625 ps=2.01 w=0.63 l=0.15
X8 VGND nmos_n3f5_f1_l150_0.D0 X VNB sky130_fd_pr__nfet_01v8 ad=0.12285 pd=1.02 as=0.12285 ps=1.02 w=0.63 l=0.15
X9 VPWR nmos_n3f5_f1_l150_0.D0 X VPB sky130_fd_pr__pfet_01v8_hvt ad=0.405 pd=2.91 as=0.2106 ps=1.47 w=1.08 l=0.15
C0 X VPB 0.01594f
C1 VPWR X 0.48984f
C2 X nmos_n3f5_f1_l150_0.D0 0.24311f
C3 VGND A 0.05517f
C4 VGND VPB 0.01601f
C5 VGND nmos_n3f5_f1_l150_0.D0 0.27844f
C6 VGND VPWR 0.0988f
C7 A VPB 0.05561f
C8 VPWR A 0.06591f
C9 A nmos_n3f5_f1_l150_0.D0 0.08133f
C10 VPB nmos_n3f5_f1_l150_0.D0 0.21827f
C11 VPWR VPB 0.18657f
C12 VPWR nmos_n3f5_f1_l150_0.D0 0.35976f
C13 VGND X 0.34107f
C14 VGND VNB 0.65469f
C15 X VNB 0.04753f
C16 VPWR VNB 0.51428f
C17 A VNB 0.16588f
C18 VPB VNB 1.02643f
C19 nmos_n3f5_f1_l150_0.D0 VNB 0.45288f
.ends

.subckt sky130_efx_lvdig__clkbuf_1 A X VGND VNB VPB VPWR
X0 pmos_n4f5_f1_l150_hvt_0.D0 A VPWR VPB sky130_fd_pr__pfet_01v8_hvt ad=0.30375 pd=2.37 as=0.30375 ps=2.37 w=0.81 l=0.15
X1 X pmos_n4f5_f1_l150_hvt_0.D0 VPWR VPB sky130_fd_pr__pfet_01v8_hvt ad=0.30375 pd=2.37 as=0.30375 ps=2.37 w=0.81 l=0.15
X2 pmos_n4f5_f1_l150_hvt_0.D0 A VGND VNB sky130_fd_pr__nfet_01v8 ad=0.2025 pd=1.83 as=0.2025 ps=1.83 w=0.54 l=0.15
X3 X pmos_n4f5_f1_l150_hvt_0.D0 VGND VNB sky130_fd_pr__nfet_01v8 ad=0.2025 pd=1.83 as=0.2025 ps=1.83 w=0.54 l=0.15
C0 X VPB 0.01701f
C1 VPWR X 0.11669f
C2 X pmos_n4f5_f1_l150_hvt_0.D0 0.08363f
C3 VGND A 0.04989f
C4 VGND VPB 0.01225f
C5 VGND pmos_n4f5_f1_l150_hvt_0.D0 0.18132f
C6 VGND VPWR 0.05022f
C7 A VPB 0.08142f
C8 VPWR A 0.04838f
C9 A pmos_n4f5_f1_l150_hvt_0.D0 0.09073f
C10 VPB pmos_n4f5_f1_l150_hvt_0.D0 0.11187f
C11 VPWR VPB 0.1192f
C12 VPWR pmos_n4f5_f1_l150_hvt_0.D0 0.21283f
C13 VGND X 0.09485f
C14 VGND VNB 0.42297f
C15 X VNB 0.11341f
C16 VPWR VNB 0.32862f
C17 A VNB 0.18389f
C18 VPB VNB 0.59875f
C19 pmos_n4f5_f1_l150_hvt_0.D0 VNB 0.22555f
.ends

.subckt sky130_efx_lvdig__clkbuf_2 A X VGND VNB VPB VPWR
X0 pmos_n6_f1_l150_hvt_0.D0 A VPWR VPB sky130_fd_pr__pfet_01v8_hvt ad=0.405 pd=2.91 as=0.405 ps=2.91 w=1.08 l=0.15
X1 pmos_n6_f1_l150_hvt_0.D0 A VGND VNB sky130_fd_pr__nfet_01v8 ad=0.16875 pd=1.65 as=0.16875 ps=1.65 w=0.45 l=0.15
X2 X pmos_n6_f1_l150_hvt_0.D0 VPWR VPB sky130_fd_pr__pfet_01v8_hvt ad=0.2106 pd=1.47 as=0.405 ps=2.91 w=1.08 l=0.15
X3 VPWR pmos_n6_f1_l150_hvt_0.D0 X VPB sky130_fd_pr__pfet_01v8_hvt ad=0.405 pd=2.91 as=0.2106 ps=1.47 w=1.08 l=0.15
X4 X pmos_n6_f1_l150_hvt_0.D0 VGND VNB sky130_fd_pr__nfet_01v8 ad=0.08775 pd=0.84 as=0.16875 ps=1.65 w=0.45 l=0.15
X5 VGND pmos_n6_f1_l150_hvt_0.D0 X VNB sky130_fd_pr__nfet_01v8 ad=0.16875 pd=1.65 as=0.08775 ps=0.84 w=0.45 l=0.15
C0 X VPB 0.00808f
C1 VPWR X 0.22621f
C2 X pmos_n6_f1_l150_hvt_0.D0 0.12829f
C3 VGND A 0.04557f
C4 VGND VPB 0.01523f
C5 VGND pmos_n6_f1_l150_hvt_0.D0 0.19144f
C6 VGND VPWR 0.07646f
C7 A VPB 0.05561f
C8 VPWR A 0.06598f
C9 A pmos_n6_f1_l150_hvt_0.D0 0.08603f
C10 VPB pmos_n6_f1_l150_hvt_0.D0 0.12607f
C11 VPWR VPB 0.15293f
C12 VPWR pmos_n6_f1_l150_hvt_0.D0 0.2974f
C13 VGND X 0.12436f
C14 VGND VNB 0.5309f
C15 X VNB 0.04762f
C16 VPWR VNB 0.4362f
C17 A VNB 0.18777f
C18 VPB VNB 0.76982f
C19 pmos_n6_f1_l150_hvt_0.D0 VNB 0.32358f
.ends

.subckt sky130_efx_lvdig__clkbuf_4 A X VGND VNB VPB VPWR
X0 nmos_n2f5_f1_l150_0.D0 A VPWR VPB sky130_fd_pr__pfet_01v8_hvt ad=0.405 pd=2.91 as=0.405 ps=2.91 w=1.08 l=0.15
X1 VGND nmos_n2f5_f1_l150_0.D0 X VNB sky130_fd_pr__nfet_01v8 ad=0.16875 pd=1.65 as=0.08775 ps=0.84 w=0.45 l=0.15
X2 X nmos_n2f5_f1_l150_0.D0 VGND VNB sky130_fd_pr__nfet_01v8 ad=0.08775 pd=0.84 as=0.08775 ps=0.84 w=0.45 l=0.15
X3 nmos_n2f5_f1_l150_0.D0 A VGND VNB sky130_fd_pr__nfet_01v8 ad=0.16875 pd=1.65 as=0.16875 ps=1.65 w=0.45 l=0.15
X4 X nmos_n2f5_f1_l150_0.D0 VPWR VPB sky130_fd_pr__pfet_01v8_hvt ad=0.2106 pd=1.47 as=0.405 ps=2.91 w=1.08 l=0.15
X5 VPWR nmos_n2f5_f1_l150_0.D0 X VPB sky130_fd_pr__pfet_01v8_hvt ad=0.2106 pd=1.47 as=0.2106 ps=1.47 w=1.08 l=0.15
X6 X nmos_n2f5_f1_l150_0.D0 VPWR VPB sky130_fd_pr__pfet_01v8_hvt ad=0.2106 pd=1.47 as=0.2106 ps=1.47 w=1.08 l=0.15
X7 X nmos_n2f5_f1_l150_0.D0 VGND VNB sky130_fd_pr__nfet_01v8 ad=0.08775 pd=0.84 as=0.16875 ps=1.65 w=0.45 l=0.15
X8 VGND nmos_n2f5_f1_l150_0.D0 X VNB sky130_fd_pr__nfet_01v8 ad=0.08775 pd=0.84 as=0.08775 ps=0.84 w=0.45 l=0.15
X9 VPWR nmos_n2f5_f1_l150_0.D0 X VPB sky130_fd_pr__pfet_01v8_hvt ad=0.405 pd=2.91 as=0.2106 ps=1.47 w=1.08 l=0.15
C0 X VPB 0.01594f
C1 VPWR X 0.48974f
C2 X nmos_n2f5_f1_l150_0.D0 0.258f
C3 VGND A 0.04557f
C4 VGND VPB 0.0159f
C5 VGND nmos_n2f5_f1_l150_0.D0 0.23943f
C6 VGND VPWR 0.09609f
C7 A VPB 0.05561f
C8 VPWR A 0.06598f
C9 A nmos_n2f5_f1_l150_0.D0 0.08603f
C10 VPB nmos_n2f5_f1_l150_0.D0 0.21827f
C11 VPWR VPB 0.18657f
C12 VPWR nmos_n2f5_f1_l150_0.D0 0.35995f
C13 VGND X 0.27569f
C14 VGND VNB 0.64977f
C15 X VNB 0.06461f
C16 VPWR VNB 0.51679f
C17 A VNB 0.18777f
C18 VPB VNB 1.02643f
C19 nmos_n2f5_f1_l150_0.D0 VNB 0.52005f
.ends

.subckt sky130_efx_lvdig__clkbuf_8 A X VGND VNB VPB VPWR
X0 VPWR nmos_n2f5_f1_l150_0.D0 X VPB sky130_fd_pr__pfet_01v8_hvt ad=0.2106 pd=1.47 as=0.2106 ps=1.47 w=1.08 l=0.15
X1 VGND A nmos_n2f5_f1_l150_0.D0 VNB sky130_fd_pr__nfet_01v8 ad=0.16875 pd=1.65 as=0.08775 ps=0.84 w=0.45 l=0.15
X2 nmos_n2f5_f1_l150_0.D0 A VPWR VPB sky130_fd_pr__pfet_01v8_hvt ad=0.2106 pd=1.47 as=0.405 ps=2.91 w=1.08 l=0.15
X3 VGND nmos_n2f5_f1_l150_0.D0 X VNB sky130_fd_pr__nfet_01v8 ad=0.08775 pd=0.84 as=0.08775 ps=0.84 w=0.45 l=0.15
X4 VPWR A nmos_n2f5_f1_l150_0.D0 VPB sky130_fd_pr__pfet_01v8_hvt ad=0.405 pd=2.91 as=0.2106 ps=1.47 w=1.08 l=0.15
X5 X nmos_n2f5_f1_l150_0.D0 VGND VNB sky130_fd_pr__nfet_01v8 ad=0.08775 pd=0.84 as=0.08775 ps=0.84 w=0.45 l=0.15
X6 X nmos_n2f5_f1_l150_0.D0 VGND VNB sky130_fd_pr__nfet_01v8 ad=0.08775 pd=0.84 as=0.08775 ps=0.84 w=0.45 l=0.15
X7 VGND nmos_n2f5_f1_l150_0.D0 X VNB sky130_fd_pr__nfet_01v8 ad=0.08775 pd=0.84 as=0.08775 ps=0.84 w=0.45 l=0.15
X8 VGND nmos_n2f5_f1_l150_0.D0 X VNB sky130_fd_pr__nfet_01v8 ad=0.08775 pd=0.84 as=0.08775 ps=0.84 w=0.45 l=0.15
X9 X nmos_n2f5_f1_l150_0.D0 VPWR VPB sky130_fd_pr__pfet_01v8_hvt ad=0.2106 pd=1.47 as=0.2106 ps=1.47 w=1.08 l=0.15
X10 VPWR nmos_n2f5_f1_l150_0.D0 X VPB sky130_fd_pr__pfet_01v8_hvt ad=0.2106 pd=1.47 as=0.2106 ps=1.47 w=1.08 l=0.15
X11 nmos_n2f5_f1_l150_0.D0 A VGND VNB sky130_fd_pr__nfet_01v8 ad=0.08775 pd=0.84 as=0.16875 ps=1.65 w=0.45 l=0.15
X12 X nmos_n2f5_f1_l150_0.D0 VGND VNB sky130_fd_pr__nfet_01v8 ad=0.08775 pd=0.84 as=0.08775 ps=0.84 w=0.45 l=0.15
X13 VGND nmos_n2f5_f1_l150_0.D0 X VNB sky130_fd_pr__nfet_01v8 ad=0.16875 pd=1.65 as=0.08775 ps=0.84 w=0.45 l=0.15
X14 X nmos_n2f5_f1_l150_0.D0 VPWR VPB sky130_fd_pr__pfet_01v8_hvt ad=0.2106 pd=1.47 as=0.2106 ps=1.47 w=1.08 l=0.15
X15 X nmos_n2f5_f1_l150_0.D0 VPWR VPB sky130_fd_pr__pfet_01v8_hvt ad=0.2106 pd=1.47 as=0.405 ps=2.91 w=1.08 l=0.15
X16 VPWR nmos_n2f5_f1_l150_0.D0 X VPB sky130_fd_pr__pfet_01v8_hvt ad=0.405 pd=2.91 as=0.2106 ps=1.47 w=1.08 l=0.15
X17 VPWR nmos_n2f5_f1_l150_0.D0 X VPB sky130_fd_pr__pfet_01v8_hvt ad=0.2106 pd=1.47 as=0.2106 ps=1.47 w=1.08 l=0.15
X18 X nmos_n2f5_f1_l150_0.D0 VGND VNB sky130_fd_pr__nfet_01v8 ad=0.08775 pd=0.84 as=0.16875 ps=1.65 w=0.45 l=0.15
X19 X nmos_n2f5_f1_l150_0.D0 VPWR VPB sky130_fd_pr__pfet_01v8_hvt ad=0.2106 pd=1.47 as=0.2106 ps=1.47 w=1.08 l=0.15
C0 X VPB 0.03202f
C1 VPWR X 1.01681f
C2 X nmos_n2f5_f1_l150_0.D0 0.51213f
C3 VGND A 0.06874f
C4 VGND VPB 0.01485f
C5 VGND nmos_n2f5_f1_l150_0.D0 0.37117f
C6 VGND VPWR 0.14178f
C7 A VPB 0.10171f
C8 VPWR A 0.09501f
C9 A nmos_n2f5_f1_l150_0.D0 0.15466f
C10 VPB nmos_n2f5_f1_l150_0.D0 0.39577f
C11 VPWR VPB 0.26249f
C12 VPWR nmos_n2f5_f1_l150_0.D0 0.55102f
C13 VGND X 0.57834f
C15 VGND VNB 0.92512f
C16 X VNB 0.10103f
C17 VPWR VNB 0.70358f
C18 A VNB 0.28601f
C19 VPB VNB 1.62518f
C20 nmos_n2f5_f1_l150_0.D0 VNB 0.91647f
.ends

.subckt sky130_efx_lvdig__clkdlybuf4s50_1 A X VGND VNB VPB VPWR
X0 a_141_36# A VPWR VPB sky130_fd_pr__pfet_01v8_hvt ad=0.405 pd=2.91 as=0.405 ps=2.91 w=1.08 l=0.15
X1 X a_788_36# VGND VNB sky130_fd_pr__nfet_01v8 ad=0.16875 pd=1.65 as=0.16875 ps=1.65 w=0.45 l=0.15
X2 a_788_36# a_464_36# VGND VNB sky130_fd_pr__nfet_01v8 ad=0.2394 pd=2.02 as=0.2394 ps=2.02 w=0.63 l=0.5
X3 X a_788_36# VPWR VPB sky130_fd_pr__pfet_01v8_hvt ad=0.405 pd=2.91 as=0.405 ps=2.91 w=1.08 l=0.15
X4 a_141_36# A VGND VNB sky130_fd_pr__nfet_01v8 ad=0.16875 pd=1.65 as=0.16875 ps=1.65 w=0.45 l=0.15
X5 a_464_36# a_141_36# VPWR VPB sky130_fd_pr__pfet_01v8_hvt ad=0.3078 pd=2.38 as=0.3078 ps=2.38 w=0.81 l=0.5
X6 a_464_36# a_141_36# VGND VNB sky130_fd_pr__nfet_01v8 ad=0.2394 pd=2.02 as=0.2394 ps=2.02 w=0.63 l=0.5
X7 a_788_36# a_464_36# VPWR VPB sky130_fd_pr__pfet_01v8_hvt ad=0.3078 pd=2.38 as=0.3078 ps=2.38 w=0.81 l=0.5
C0 VPB A 0.05563f
C1 VPB a_788_36# 0.08476f
C2 VGND a_464_36# 0.2214f
C3 VPB a_141_36# 0.14802f
C4 VPB VPWR 0.25551f
C6 a_141_36# A 0.08296f
C7 VPB X 0.01018f
C9 VPWR A 0.06592f
C10 VPWR a_788_36# 0.21019f
C11 VPWR a_141_36# 0.28685f
C12 VPB a_464_36# 0.15449f
C13 X a_788_36# 0.07683f
C14 VGND VPB 0.02028f
C15 X VPWR 0.13854f
C17 a_464_36# a_788_36# 0.12043f
C18 VGND A 0.04596f
C19 VGND a_788_36# 0.15333f
C20 a_141_36# a_464_36# 0.12415f
C21 VPWR a_464_36# 0.23145f
C22 VGND a_141_36# 0.23325f
C23 VGND VPWR 0.11658f
C25 VGND X 0.08761f
C26 VGND VNB 0.79617f
C27 X VNB 0.11582f
C28 VPWR VNB 0.58791f
C29 A VNB 0.18914f
C30 VPB VNB 1.36858f
C31 a_788_36# VNB 0.20691f
C32 a_464_36# VNB 0.22168f
C33 a_141_36# VNB 0.24337f
.ends

.subckt sky130_efx_lvdig__clkinv_1 A Y VGND VNB VPB VPWR
X0 Y A VPWR VPB sky130_fd_pr__pfet_01v8_hvt ad=0.15795 pd=1.2 as=0.30375 ps=2.37 w=0.81 l=0.15
X1 VPWR A Y VPB sky130_fd_pr__pfet_01v8_hvt ad=0.30375 pd=2.37 as=0.15795 ps=1.2 w=0.81 l=0.15
X2 Y A VGND VNB sky130_fd_pr__nfet_01v8 ad=0.16875 pd=1.65 as=0.16875 ps=1.65 w=0.45 l=0.15
C0 Y VPB 0.01586f
C1 VPWR VPB 0.08051f
C2 Y VPWR 0.18243f
C3 A VPB 0.13829f
C4 Y A 0.10592f
C5 VGND VPB 0.01034f
C6 VGND Y 0.08768f
C7 VPWR A 0.07453f
C8 VGND VPWR 0.04265f
C9 VGND A 0.05057f
C10 VGND VNB 0.34264f
C11 Y VNB 0.09942f
C12 VPWR VNB 0.3126f
C13 A VNB 0.28405f
C14 VPB VNB 0.42768f
.ends

.subckt sky130_efx_lvdig__clkinv_2 A Y VGND VNB VPB VPWR
X0 VGND A Y VNB sky130_fd_pr__nfet_01v8 ad=0.16875 pd=1.65 as=0.08775 ps=0.84 w=0.45 l=0.15
X1 Y A VPWR VPB sky130_fd_pr__pfet_01v8_hvt ad=0.2106 pd=1.47 as=0.405 ps=2.91 w=1.08 l=0.15
X2 VPWR A Y VPB sky130_fd_pr__pfet_01v8_hvt ad=0.2106 pd=1.47 as=0.2106 ps=1.47 w=1.08 l=0.15
X3 Y A VPWR VPB sky130_fd_pr__pfet_01v8_hvt ad=0.405 pd=2.91 as=0.2106 ps=1.47 w=1.08 l=0.15
X4 Y A VGND VNB sky130_fd_pr__nfet_01v8 ad=0.08775 pd=0.84 as=0.16875 ps=1.65 w=0.45 l=0.15
C0 Y VPB 0.02176f
C1 VPWR VPB 0.10048f
C2 Y VPWR 0.40078f
C3 A VPB 0.14568f
C4 Y A 0.16914f
C5 VGND VPB 0.0105f
C6 VGND Y 0.16327f
C7 VPWR A 0.12664f
C8 VGND VPWR 0.05128f
C9 VGND A 0.07387f
C10 VGND VNB 0.44592f
C11 Y VNB 0.121f
C12 VPWR VNB 0.34061f
C13 A VNB 0.367f
C14 VPB VNB 0.59875f
.ends

.subckt sky130_efx_lvdig__clkinv_4 A Y VGND VNB VPB VPWR
X0 VGND A Y VNB sky130_fd_pr__nfet_01v8 ad=0.08775 pd=0.84 as=0.08775 ps=0.84 w=0.45 l=0.15
X1 Y A VGND VNB sky130_fd_pr__nfet_01v8 ad=0.08775 pd=0.84 as=0.08775 ps=0.84 w=0.45 l=0.15
X2 VGND A Y VNB sky130_fd_pr__nfet_01v8 ad=0.16875 pd=1.65 as=0.08775 ps=0.84 w=0.45 l=0.15
X3 Y A VPWR VPB sky130_fd_pr__pfet_01v8_hvt ad=0.2106 pd=1.47 as=0.405 ps=2.91 w=1.08 l=0.15
X4 VPWR A Y VPB sky130_fd_pr__pfet_01v8_hvt ad=0.2106 pd=1.47 as=0.2106 ps=1.47 w=1.08 l=0.15
X5 Y A VPWR VPB sky130_fd_pr__pfet_01v8_hvt ad=0.2106 pd=1.47 as=0.2106 ps=1.47 w=1.08 l=0.15
X6 VPWR A Y VPB sky130_fd_pr__pfet_01v8_hvt ad=0.2106 pd=1.47 as=0.2106 ps=1.47 w=1.08 l=0.15
X7 Y A VPWR VPB sky130_fd_pr__pfet_01v8_hvt ad=0.2106 pd=1.47 as=0.2106 ps=1.47 w=1.08 l=0.15
X8 Y A VGND VNB sky130_fd_pr__nfet_01v8 ad=0.08775 pd=0.84 as=0.16875 ps=1.65 w=0.45 l=0.15
X9 VPWR A Y VPB sky130_fd_pr__pfet_01v8_hvt ad=0.405 pd=2.91 as=0.2106 ps=1.47 w=1.08 l=0.15
C0 Y VPB 0.02289f
C1 VPWR VPB 0.14389f
C2 Y VPWR 0.75192f
C3 A VPB 0.28229f
C4 Y A 0.3313f
C5 VGND VPB 0.00938f
C6 VGND Y 0.31478f
C7 VPWR A 0.21866f
C8 VGND VPWR 0.08396f
C9 VGND A 0.12756f
C10 VGND VNB 0.61384f
C11 Y VNB 0.09422f
C12 VPWR VNB 0.49588f
C13 A VNB 0.62263f
C14 VPB VNB 0.9409f
.ends

.subckt sky130_efx_lvdig__clkinv_8 A Y VGND VNB VPB VPWR
X0 Y A VGND VNB sky130_fd_pr__nfet_01v8 ad=0.08775 pd=0.84 as=0.08775 ps=0.84 w=0.45 l=0.15
X1 VGND A Y VNB sky130_fd_pr__nfet_01v8 ad=0.08775 pd=0.84 as=0.08775 ps=0.84 w=0.45 l=0.15
X2 VGND A Y VNB sky130_fd_pr__nfet_01v8 ad=0.08775 pd=0.84 as=0.08775 ps=0.84 w=0.45 l=0.15
X3 Y A VGND VNB sky130_fd_pr__nfet_01v8 ad=0.08775 pd=0.84 as=0.08775 ps=0.84 w=0.45 l=0.15
X4 VGND A Y VNB sky130_fd_pr__nfet_01v8 ad=0.08775 pd=0.84 as=0.08775 ps=0.84 w=0.45 l=0.15
X5 VPWR A Y VPB sky130_fd_pr__pfet_01v8_hvt ad=0.2106 pd=1.47 as=0.2106 ps=1.47 w=1.08 l=0.15
X6 Y A VPWR VPB sky130_fd_pr__pfet_01v8_hvt ad=0.2106 pd=1.47 as=0.405 ps=2.91 w=1.08 l=0.15
X7 Y A VPWR VPB sky130_fd_pr__pfet_01v8_hvt ad=0.2106 pd=1.47 as=0.2106 ps=1.47 w=1.08 l=0.15
X8 VPWR A Y VPB sky130_fd_pr__pfet_01v8_hvt ad=0.2106 pd=1.47 as=0.2106 ps=1.47 w=1.08 l=0.15
X9 VPWR A Y VPB sky130_fd_pr__pfet_01v8_hvt ad=0.405 pd=2.91 as=0.2106 ps=1.47 w=1.08 l=0.15
X10 Y A VPWR VPB sky130_fd_pr__pfet_01v8_hvt ad=0.2106 pd=1.47 as=0.2106 ps=1.47 w=1.08 l=0.15
X11 VPWR A Y VPB sky130_fd_pr__pfet_01v8_hvt ad=0.2106 pd=1.47 as=0.2106 ps=1.47 w=1.08 l=0.15
X12 Y A VGND VNB sky130_fd_pr__nfet_01v8 ad=0.08775 pd=0.84 as=0.08775 ps=0.84 w=0.45 l=0.15
X13 VGND A Y VNB sky130_fd_pr__nfet_01v8 ad=0.16875 pd=1.65 as=0.08775 ps=0.84 w=0.45 l=0.15
X14 Y A VPWR VPB sky130_fd_pr__pfet_01v8_hvt ad=0.2106 pd=1.47 as=0.2106 ps=1.47 w=1.08 l=0.15
X15 Y A VGND VNB sky130_fd_pr__nfet_01v8 ad=0.08775 pd=0.84 as=0.16875 ps=1.65 w=0.45 l=0.15
X16 VPWR A Y VPB sky130_fd_pr__pfet_01v8_hvt ad=0.2106 pd=1.47 as=0.2106 ps=1.47 w=1.08 l=0.15
X17 Y A VPWR VPB sky130_fd_pr__pfet_01v8_hvt ad=0.2106 pd=1.47 as=0.2106 ps=1.47 w=1.08 l=0.15
X18 VPWR A Y VPB sky130_fd_pr__pfet_01v8_hvt ad=0.2106 pd=1.47 as=0.2106 ps=1.47 w=1.08 l=0.15
X19 Y A VPWR VPB sky130_fd_pr__pfet_01v8_hvt ad=0.2106 pd=1.47 as=0.2106 ps=1.47 w=1.08 l=0.15
C0 Y VPB 0.04648f
C1 VPWR Y 1.54119f
C2 VGND A 0.23015f
C3 VGND VPB 0.01141f
C4 VGND VPWR 0.14227f
C5 A VPB 0.5589f
C6 VPWR A 0.40455f
C7 VPWR VPB 0.24483f
C8 VGND Y 0.6489f
C9 Y A 0.67362f
C10 VGND VNB 0.99473f
C11 Y VNB 0.14706f
C12 VPWR VNB 0.7425f
C13 A VNB 1.1305f
C14 VPB VNB 1.71072f
.ends

.subckt sky130_efx_lvdig__conb_1 HI LO VGND VNB VPB VPWR
X0 LO VGND sky130_fd_pr__res_generic_po w=0.45 l=0.54
X1 VPWR HI sky130_fd_pr__res_generic_po w=0.45 l=0.54
C0 VPWR HI 0.01662f
C1 LO VPB 0.00575f
C2 LO VGND 0.01662f
C3 LO VPWR 0.00121f
C4 VPB VGND 0.01152f
C5 VPWR VPB 0.09955f
C6 VPWR VGND 0.0242f
C7 LO HI 0.03836f
C8 HI VPB 0.04337f
C9 HI VGND 0.00121f
C10 VGND VNB 0.34028f
C11 LO VNB 0.09623f
C12 HI VNB 0.0586f
C13 VPWR VNB 0.25225f
C14 VPB VNB 0.25661f
.ends

.subckt sky130_efx_lvdig__decap10 VGND VNB VPB VPWR
X0 VPWR VGND VPWR VPB sky130_fd_pr__pfet_01v8_hvt ad=0.324 pd=2.52 as=0.648 ps=5.04 w=0.9 l=0.72
X1 VGND VPWR VGND VNB sky130_fd_pr__nfet_01v8 ad=0.2268 pd=1.98 as=0.4536 ps=3.96 w=0.63 l=0.72
C0 VGND VPWR 0.42724f
C1 VPB VPWR 0.09704f
C2 VPB VGND 0.12613f
C3 VPWR VNB 0.55522f
C4 VGND VNB 0.50734f
C5 VPB VNB 0.42768f
.ends

.subckt sky130_efx_lvdig__decap20 VGND VNB VPB VPWR
X0 VPWR VGND VPWR VPB sky130_fd_pr__pfet_01v8_hvt ad=0.324 pd=2.52 as=0.648 ps=5.04 w=0.9 l=2.52
X1 VGND VPWR VGND VNB sky130_fd_pr__nfet_01v8 ad=0.2268 pd=1.98 as=0.4536 ps=3.96 w=0.63 l=2.52
C0 VGND VPWR 0.97973f
C1 VPB VPWR 0.13934f
C2 VPB VGND 0.26411f
C3 VPWR VNB 0.89151f
C4 VGND VNB 0.74864f
C5 VPB VNB 0.85536f
.ends

.subckt sky130_efx_lvdig__dfbbp_1 CLK D RESET_B SET_B Q Q_N VGND VNB VPB VPWR
X0 a_3093_378# a_2229_36# a_2583_327# VPB sky130_fd_pr__pfet_01v8_hvt ad=0.15795 pd=1.2 as=0.13725 ps=1.2 w=0.81 l=0.15
X1 a_3813_36# a_2583_327# VGND VNB sky130_fd_pr__nfet_01v8 ad=0.16875 pd=1.65 as=0.16875 ps=1.65 w=0.45 l=0.15
X2 Q a_3813_36# VPWR VPB sky130_fd_pr__pfet_01v8_hvt ad=0.405 pd=2.91 as=0.405 ps=2.91 w=1.08 l=0.15
X3 a_1509_378# a_1296_440# VPWR VPB sky130_fd_pr__pfet_01v8_hvt ad=0.15795 pd=1.2 as=0.30375 ps=2.37 w=0.81 l=0.15
X4 VPWR a_1296_440# a_3093_378# VPB sky130_fd_pr__pfet_01v8_hvt ad=0.30375 pd=2.37 as=0.15795 ps=1.2 w=0.81 l=0.15
X5 Q_N a_2583_327# VPWR VPB sky130_fd_pr__pfet_01v8_hvt ad=0.405 pd=2.91 as=0.405 ps=2.91 w=1.08 l=0.15
X6 a_969_450# a_141_36# a_753_36# VPB sky130_fd_pr__pfet_01v8_hvt ad=0.16875 pd=1.2 as=0.20925 ps=1.38 w=0.45 l=0.15
X7 VPWR a_1088_165# a_969_450# VPB sky130_fd_pr__pfet_01v8_hvt ad=0.16875 pd=1.65 as=0.16875 ps=1.2 w=0.45 l=0.15
X8 a_2985_36# SET_B VGND VNB sky130_fd_pr__nfet_01v8 ad=0.1125 pd=1.02 as=0.16875 ps=1.65 w=0.45 l=0.15
X9 a_141_36# CLK VPWR VPB sky130_fd_pr__pfet_01v8_hvt ad=0.23625 pd=2.01 as=0.23625 ps=2.01 w=0.63 l=0.15
X10 a_1088_165# a_753_36# a_1509_378# VPB sky130_fd_pr__pfet_01v8_hvt ad=0.13725 pd=1.2 as=0.15795 ps=1.2 w=0.81 l=0.15
X11 a_645_36# D VGND VNB sky130_fd_pr__nfet_01v8 ad=0.08258 pd=0.84 as=0.16875 ps=1.65 w=0.45 l=0.15
X12 a_753_36# a_141_36# a_645_36# VNB sky130_fd_pr__special_nfet_01v8 ad=0.1674 pd=1.29 as=0.08258 ps=0.84 w=0.36 l=0.15
X13 a_2445_450# a_393_36# a_2229_36# VPB sky130_fd_pr__pfet_01v8_hvt ad=0.16875 pd=1.2 as=0.20925 ps=1.38 w=0.45 l=0.15
X14 a_2583_327# a_2229_36# a_2985_36# VNB sky130_fd_pr__nfet_01v8 ad=0.12285 pd=1.02 as=0.1125 ps=1.02 w=0.63 l=0.15
X15 a_2985_36# a_1296_440# a_2583_327# VNB sky130_fd_pr__nfet_01v8 ad=0.23625 pd=2.01 as=0.12285 ps=1.02 w=0.63 l=0.15
X16 a_2085_36# a_1088_165# VGND VNB sky130_fd_pr__nfet_01v8 ad=0.13972 pd=1.2 as=0.23625 ps=2.01 w=0.63 l=0.15
X17 Q a_3813_36# VGND VNB sky130_fd_pr__nfet_01v8 ad=0.23625 pd=2.01 as=0.23625 ps=2.01 w=0.63 l=0.15
X18 a_1296_440# RESET_B VPWR VPB sky130_fd_pr__pfet_01v8_hvt ad=0.23625 pd=2.01 as=0.23625 ps=2.01 w=0.63 l=0.15
X19 a_3813_36# a_2583_327# VPWR VPB sky130_fd_pr__pfet_01v8_hvt ad=0.23625 pd=2.01 as=0.23625 ps=2.01 w=0.63 l=0.15
X20 a_141_36# CLK VGND VNB sky130_fd_pr__nfet_01v8 ad=0.16875 pd=1.65 as=0.16875 ps=1.65 w=0.45 l=0.15
X21 a_393_36# a_141_36# VPWR VPB sky130_fd_pr__pfet_01v8_hvt ad=0.23625 pd=2.01 as=0.23625 ps=2.01 w=0.63 l=0.15
X22 a_969_36# a_393_36# a_753_36# VNB sky130_fd_pr__special_nfet_01v8 ad=0.15593 pd=1.2 as=0.1674 ps=1.29 w=0.36 l=0.15
X23 VGND a_1088_165# a_969_36# VNB sky130_fd_pr__nfet_01v8 ad=0.16875 pd=1.65 as=0.15593 ps=1.2 w=0.45 l=0.15
X24 Q_N a_2583_327# VGND VNB sky130_fd_pr__nfet_01v8 ad=0.23625 pd=2.01 as=0.23625 ps=2.01 w=0.63 l=0.15
X25 a_2583_327# SET_B VPWR VPB sky130_fd_pr__pfet_01v8_hvt ad=0.13725 pd=1.2 as=0.16875 ps=1.65 w=0.45 l=0.15
X26 a_2445_36# a_141_36# a_2229_36# VNB sky130_fd_pr__special_nfet_01v8 ad=0.15593 pd=1.2 as=0.1674 ps=1.29 w=0.36 l=0.15
X27 a_645_36# D VPWR VPB sky130_fd_pr__pfet_01v8_hvt ad=0.08775 pd=0.84 as=0.16875 ps=1.65 w=0.45 l=0.15
X28 a_2229_36# a_393_36# a_2085_36# VNB sky130_fd_pr__special_nfet_01v8 ad=0.1674 pd=1.29 as=0.13972 ps=1.2 w=0.36 l=0.15
X29 a_1296_440# RESET_B VGND VNB sky130_fd_pr__nfet_01v8 ad=0.16875 pd=1.65 as=0.16875 ps=1.65 w=0.45 l=0.15
X30 a_2085_378# a_1088_165# VPWR VPB sky130_fd_pr__pfet_01v8_hvt ad=0.17775 pd=1.38 as=0.30375 ps=2.37 w=0.81 l=0.15
X31 a_2229_36# a_141_36# a_2085_378# VPB sky130_fd_pr__pfet_01v8_hvt ad=0.20925 pd=1.38 as=0.17775 ps=1.38 w=0.45 l=0.15
X32 VPWR SET_B a_1088_165# VPB sky130_fd_pr__pfet_01v8_hvt ad=0.16875 pd=1.65 as=0.13725 ps=1.2 w=0.45 l=0.15
X33 a_753_36# a_393_36# a_645_36# VPB sky130_fd_pr__pfet_01v8_hvt ad=0.20925 pd=1.38 as=0.08775 ps=0.84 w=0.45 l=0.15
X34 a_393_36# a_141_36# VGND VNB sky130_fd_pr__nfet_01v8 ad=0.16875 pd=1.65 as=0.16875 ps=1.65 w=0.45 l=0.15
X35 VGND a_2583_327# a_2445_36# VNB sky130_fd_pr__nfet_01v8 ad=0.16875 pd=1.65 as=0.15593 ps=1.2 w=0.45 l=0.15
X36 VPWR a_2583_327# a_2445_450# VPB sky130_fd_pr__pfet_01v8_hvt ad=0.16875 pd=1.65 as=0.16875 ps=1.2 w=0.45 l=0.15
X37 VGND SET_B a_1404_36# VNB sky130_fd_pr__nfet_01v8 ad=0.16875 pd=1.65 as=0.1125 ps=1.02 w=0.45 l=0.15
X38 a_1088_165# a_1296_440# a_1404_36# VNB sky130_fd_pr__nfet_01v8 ad=0.12285 pd=1.02 as=0.23625 ps=2.01 w=0.63 l=0.15
X39 a_1404_36# a_753_36# a_1088_165# VNB sky130_fd_pr__nfet_01v8 ad=0.1125 pd=1.02 as=0.12285 ps=1.02 w=0.63 l=0.15
C0 VGND a_2445_36# 0.01736f
C1 a_2583_327# a_393_36# 0.04348f
C4 VGND a_645_36# 0.07973f
C5 a_2229_36# a_393_36# 0.12464f
C6 a_2583_327# VPWR 0.32704f
C7 Q_N VPB 0.01998f
C8 a_2229_36# VPWR 0.09712f
C9 a_141_36# a_1509_378# 0.00229f
C10 VGND a_1404_36# 0.2782f
C12 VPB a_3813_36# 0.09412f
C13 D a_645_36# 0.06045f
C14 a_753_36# a_393_36# 0.16748f
C16 VPB a_393_36# 0.30026f
C17 a_753_36# VPWR 0.13878f
C18 VPB Q 0.01836f
C20 a_2583_327# VGND 0.18827f
C21 VPB VPWR 0.97198f
C22 a_2229_36# VGND 0.13668f
C23 a_1088_165# a_969_36# 0.00259f
C25 VPWR a_2985_36# 0.001f
C26 a_393_36# a_2085_378# 0.00104f
C27 VPWR a_2085_378# 0.01982f
C28 a_141_36# a_2445_36# 0.00173f
C29 a_141_36# a_645_36# 0.15148f
C30 VGND a_753_36# 0.08192f
C31 a_3093_378# a_1296_440# 0.00794f
C32 SET_B a_1296_440# 0.0586f
C33 VGND VPB 0.05087f
C34 a_2229_36# a_2085_36# 0.00346f
C36 VGND a_2985_36# 0.28018f
C37 SET_B a_1088_165# 0.09591f
C38 VGND a_2085_378# 0.00137f
C39 a_393_36# a_969_36# 0.00712f
C40 D VPB 0.11625f
C42 a_2583_327# a_141_36# 0.02694f
C44 a_141_36# a_2229_36# 0.15212f
C45 RESET_B a_1296_440# 0.07541f
C46 a_969_450# a_1296_440# 0.00179f
C47 a_1088_165# a_1296_440# 0.09088f
C48 a_753_36# a_1509_378# 0.00552f
C51 VGND a_969_36# 0.01995f
C53 SET_B a_393_36# 0.23121f
C54 a_141_36# a_753_36# 0.23916f
C56 VPWR a_3093_378# 0.01236f
C57 SET_B VPWR 0.0429f
C58 a_2229_36# a_2445_36# 0.0111f
C59 a_141_36# VPB 0.51324f
C60 a_1296_440# a_2445_450# 0.00876f
C61 Q_N a_1296_440# 0.04516f
C63 a_141_36# a_2085_378# 0.00142f
C64 a_1296_440# a_3813_36# 0.05657f
C65 RESET_B a_3813_36# 0.02006f
C67 CLK VPWR 0.04196f
C68 a_393_36# a_1296_440# 0.15009f
C69 Q a_1296_440# 0.07018f
C70 VGND SET_B 0.8464f
C71 RESET_B Q 0.02636f
C72 VPWR a_1296_440# 2.12377f
C73 a_753_36# a_645_36# 0.04498f
C74 RESET_B VPWR 0.03681f
C75 VPB a_645_36# 0.02422f
C76 a_1088_165# a_393_36# 0.23034f
C77 a_969_450# VPWR 0.0225f
C78 a_2583_327# a_2229_36# 0.29498f
C79 a_1088_165# VPWR 0.18626f
C80 a_753_36# a_1404_36# 0.00743f
C81 Q_N a_3813_36# 0.03531f
C82 VGND CLK 0.04537f
C83 a_393_36# a_2445_450# 0.00194f
C85 VPWR a_2445_450# 0.01954f
C86 VGND a_1296_440# 0.24203f
C87 SET_B a_2085_36# 0.00704f
C88 Q_N VPWR 0.15785f
C89 VGND RESET_B 0.0448f
C90 a_2583_327# VPB 0.41812f
C92 a_2229_36# VPB 0.10094f
C93 VGND a_1088_165# 0.21204f
C94 Q a_3813_36# 0.07073f
C95 VPWR a_3813_36# 0.21175f
C96 a_2583_327# a_2985_36# 0.12366f
C97 a_2229_36# a_2985_36# 0.02607f
C100 a_2229_36# a_2085_378# 0.00444f
C101 a_393_36# VPWR 0.16715f
C102 Q VPWR 0.15785f
C103 a_141_36# SET_B 0.15438f
C104 Q_N VGND 0.12455f
C105 VPB a_753_36# 0.12152f
C106 a_1404_36# a_969_36# 0.00145f
C108 VGND a_3813_36# 0.18409f
C109 a_1296_440# a_1509_378# 0.00855f
C110 VPB a_2985_36# 0.00284f
C111 a_141_36# CLK 0.09924f
C112 VGND a_393_36# 0.52984f
C113 SET_B a_2445_36# 0.00867f
C114 VGND Q 0.12455f
C115 a_1088_165# a_1509_378# 0.00792f
C116 a_141_36# a_1296_440# 0.21673f
C117 VGND VPWR 0.06538f
C119 a_141_36# a_969_450# 0.0071f
C120 a_141_36# a_1088_165# 0.15711f
C121 D a_393_36# 0.09861f
C122 SET_B a_1404_36# 0.01628f
C123 D VPWR 0.03564f
C124 a_753_36# a_969_36# 0.00965f
C125 a_393_36# a_2085_36# 0.00205f
C128 VPWR a_2085_36# 0.00101f
C130 a_2583_327# a_3093_378# 0.01673f
C131 a_2583_327# SET_B 0.0809f
C132 a_2229_36# SET_B 0.16378f
C136 VPWR a_1509_378# 0.01233f
C137 a_1404_36# a_1296_440# 0.00639f
C138 VGND D 0.03533f
C139 a_141_36# a_393_36# 1.38935f
C141 a_141_36# VPWR 0.51667f
C142 a_1088_165# a_1404_36# 0.16334f
C143 VGND a_2085_36# 0.01561f
C144 a_753_36# SET_B 0.06169f
C145 VPB SET_B 0.24074f
C146 a_2583_327# a_1296_440# 0.22138f
C147 a_2583_327# RESET_B 0.00425f
C148 a_2229_36# a_1296_440# 0.12291f
C150 SET_B a_2985_36# 0.01886f
C151 a_2229_36# a_1088_165# 0.00147f
C152 a_141_36# VGND 0.25046f
C153 a_393_36# a_645_36# 0.07535f
C154 CLK VPB 0.09785f
C155 a_753_36# a_1296_440# 0.10257f
C156 VPWR a_645_36# 0.08042f
C158 VPB a_1296_440# 0.59969f
C159 Q_N a_2583_327# 0.10499f
C160 a_2229_36# a_2445_450# 0.01115f
C161 VPB RESET_B 0.10492f
C162 a_393_36# a_1404_36# 0.15118f
C163 a_969_450# a_753_36# 0.01125f
C164 a_753_36# a_1088_165# 0.24303f
C165 a_1296_440# a_2985_36# 0.04357f
C166 a_141_36# D 0.07933f
C168 VPB a_1088_165# 0.23983f
C169 a_1296_440# a_2085_378# 0.00869f
C170 a_2583_327# a_3813_36# 0.067f
C171 Q VNB 0.02432f
C172 Q_N VNB 0.01953f
C173 RESET_B VNB 0.18367f
C174 VGND VNB 2.78038f
C175 SET_B VNB 0.58231f
C176 VPWR VNB 1.86588f
C177 D VNB 0.13204f
C178 CLK VNB 0.19841f
C179 VPB VNB 5.30323f
C180 a_2985_36# VNB 0.02385f
C181 a_3813_36# VNB 0.16507f
C182 a_1404_36# VNB 0.01441f
C183 a_2229_36# VNB 0.15469f
C184 a_2583_327# VNB 0.50006f
C185 a_753_36# VNB 0.14401f
C186 a_645_36# VNB 0.02294f
C187 a_1296_440# VNB 0.39786f
C188 a_1088_165# VNB 0.33518f
C189 a_393_36# VNB 0.43063f
C190 a_141_36# VNB 0.6062f
.ends

.subckt sky130_efx_lvdig__dfrbp_1 CLK D RESET_B Q Q_N VGND VNB VPB VPWR
X0 Q a_2060_165# VGND VNB sky130_fd_pr__nfet_01v8 ad=0.23625 pd=2.01 as=0.23625 ps=2.01 w=0.63 l=0.15
X1 a_969_450# a_141_36# a_753_36# VPB sky130_fd_pr__pfet_01v8_hvt ad=0.16875 pd=1.2 as=0.20925 ps=1.38 w=0.45 l=0.15
X2 VPWR a_1088_165# a_969_450# VPB sky130_fd_pr__pfet_01v8_hvt ad=0.08775 pd=0.84 as=0.16875 ps=1.2 w=0.45 l=0.15
X3 a_141_36# CLK VPWR VPB sky130_fd_pr__pfet_01v8_hvt ad=0.23625 pd=2.01 as=0.23625 ps=2.01 w=0.63 l=0.15
X4 VPWR a_1725_36# a_2060_165# VPB sky130_fd_pr__pfet_01v8_hvt ad=0.16875 pd=1.65 as=0.08775 ps=0.84 w=0.45 l=0.15
X5 a_645_36# D VGND VNB sky130_fd_pr__nfet_01v8 ad=0.08258 pd=0.84 as=0.16875 ps=1.65 w=0.45 l=0.15
X6 a_753_36# a_141_36# a_645_36# VNB sky130_fd_pr__special_nfet_01v8 ad=0.1674 pd=1.29 as=0.08258 ps=0.84 w=0.36 l=0.15
X7 Q_N a_2841_36# VPWR VPB sky130_fd_pr__pfet_01v8_hvt ad=0.405 pd=2.91 as=0.405 ps=2.91 w=1.08 l=0.15
X8 a_969_450# RESET_B VPWR VPB sky130_fd_pr__pfet_01v8_hvt ad=0.16875 pd=1.65 as=0.08775 ps=0.84 w=0.45 l=0.15
X9 Q a_2060_165# VPWR VPB sky130_fd_pr__pfet_01v8_hvt ad=0.405 pd=2.91 as=0.405 ps=2.91 w=1.08 l=0.15
X10 a_1941_450# a_393_36# a_1725_36# VPB sky130_fd_pr__pfet_01v8_hvt ad=0.16875 pd=1.2 as=0.20925 ps=1.38 w=0.45 l=0.15
X11 VGND a_2060_165# a_1941_36# VNB sky130_fd_pr__nfet_01v8 ad=0.08775 pd=0.84 as=0.15593 ps=1.2 w=0.45 l=0.15
X12 Q_N a_2841_36# VGND VNB sky130_fd_pr__nfet_01v8 ad=0.23625 pd=2.01 as=0.23625 ps=2.01 w=0.63 l=0.15
X13 a_141_36# CLK VGND VNB sky130_fd_pr__nfet_01v8 ad=0.16875 pd=1.65 as=0.16875 ps=1.65 w=0.45 l=0.15
X14 a_1088_165# a_753_36# VGND VNB sky130_fd_pr__nfet_01v8 ad=0.13702 pd=1.2 as=0.23625 ps=2.01 w=0.63 l=0.15
X15 a_393_36# a_141_36# VPWR VPB sky130_fd_pr__pfet_01v8_hvt ad=0.23625 pd=2.01 as=0.23625 ps=2.01 w=0.63 l=0.15
X16 a_969_36# a_393_36# a_753_36# VNB sky130_fd_pr__special_nfet_01v8 ad=0.15593 pd=1.2 as=0.1674 ps=1.29 w=0.36 l=0.15
X17 a_1149_36# a_1088_165# a_969_36# VNB sky130_fd_pr__nfet_01v8 ad=0.08775 pd=0.84 as=0.15593 ps=1.2 w=0.45 l=0.15
X18 VGND RESET_B a_1149_36# VNB sky130_fd_pr__nfet_01v8 ad=0.16875 pd=1.65 as=0.08775 ps=0.84 w=0.45 l=0.15
X19 VPWR a_2060_165# a_1941_450# VPB sky130_fd_pr__pfet_01v8_hvt ad=0.08775 pd=0.84 as=0.16875 ps=1.2 w=0.45 l=0.15
X20 a_2060_165# a_1725_36# a_2229_36# VNB sky130_fd_pr__nfet_01v8 ad=0.16875 pd=1.65 as=0.08775 ps=0.84 w=0.45 l=0.15
X21 a_2229_36# RESET_B VGND VNB sky130_fd_pr__nfet_01v8 ad=0.08775 pd=0.84 as=0.08775 ps=0.84 w=0.45 l=0.15
X22 a_645_36# D VPWR VPB sky130_fd_pr__pfet_01v8_hvt ad=0.08775 pd=0.84 as=0.16875 ps=1.65 w=0.45 l=0.15
X23 a_2060_165# RESET_B VPWR VPB sky130_fd_pr__pfet_01v8_hvt ad=0.08775 pd=0.84 as=0.08775 ps=0.84 w=0.45 l=0.15
X24 a_2841_36# a_2060_165# VGND VNB sky130_fd_pr__nfet_01v8 ad=0.16875 pd=1.65 as=0.16875 ps=1.65 w=0.45 l=0.15
X25 a_1725_36# a_141_36# a_1088_165# VPB sky130_fd_pr__pfet_01v8_hvt ad=0.20925 pd=1.38 as=0.17415 ps=1.38 w=0.45 l=0.15
X26 a_753_36# a_393_36# a_645_36# VPB sky130_fd_pr__pfet_01v8_hvt ad=0.20925 pd=1.38 as=0.08775 ps=0.84 w=0.45 l=0.15
X27 a_1088_165# a_753_36# VPWR VPB sky130_fd_pr__pfet_01v8_hvt ad=0.17415 pd=1.38 as=0.30375 ps=2.37 w=0.81 l=0.15
X28 a_393_36# a_141_36# VGND VNB sky130_fd_pr__nfet_01v8 ad=0.16875 pd=1.65 as=0.16875 ps=1.65 w=0.45 l=0.15
X29 a_2841_36# a_2060_165# VPWR VPB sky130_fd_pr__pfet_01v8_hvt ad=0.23625 pd=2.01 as=0.23625 ps=2.01 w=0.63 l=0.15
X30 a_1941_36# a_141_36# a_1725_36# VNB sky130_fd_pr__special_nfet_01v8 ad=0.15593 pd=1.2 as=0.1674 ps=1.29 w=0.36 l=0.15
X31 a_1725_36# a_393_36# a_1088_165# VNB sky130_fd_pr__special_nfet_01v8 ad=0.1674 pd=1.29 as=0.13702 ps=1.2 w=0.36 l=0.15
C0 a_1088_165# VGND 0.21474f
C2 CLK VGND 0.04537f
C3 a_1088_165# a_141_36# 0.071f
C4 VPB Q 0.01836f
C5 a_1941_36# VGND 0.01995f
C7 a_753_36# VPWR 0.12161f
C8 CLK a_141_36# 0.09924f
C9 a_1941_36# a_141_36# 0.00331f
C10 a_969_36# a_753_36# 0.00965f
C11 a_393_36# a_1725_36# 0.12511f
C12 Q VGND 0.12516f
C13 a_645_36# VPWR 0.08042f
C14 a_393_36# a_2060_165# 0.02289f
C16 a_645_36# a_753_36# 0.04498f
C17 a_1088_165# a_969_450# 0.01004f
C18 a_2060_165# a_1725_36# 0.26033f
C20 a_1149_36# VGND 0.01143f
C22 a_1088_165# a_393_36# 0.27871f
C25 a_1088_165# a_1725_36# 0.04489f
C26 a_2060_165# a_2229_36# 0.00952f
C27 a_1725_36# a_1941_36# 0.00965f
C28 a_2841_36# VPB 0.09198f
C29 a_2060_165# a_1941_36# 0.00277f
C30 D VPWR 0.03564f
C31 RESET_B VPWR 0.58229f
C32 RESET_B a_753_36# 0.12175f
C33 a_393_36# a_1941_450# 0.00194f
C34 a_1725_36# Q 0.00104f
C35 a_2841_36# VGND 0.18408f
C36 a_2060_165# Q 0.11061f
C38 a_1725_36# a_1941_450# 0.01125f
C39 a_393_36# a_1149_36# 0.00304f
C40 D a_645_36# 0.06045f
C42 VPB VPWR 0.69688f
C43 VPB a_753_36# 0.12579f
C44 VGND VPWR 0.13306f
C45 a_753_36# VGND 0.0875f
C46 a_2841_36# Q_N 0.07073f
C47 a_645_36# VPB 0.02422f
C48 a_141_36# VPWR 0.47472f
C49 a_753_36# a_141_36# 0.26238f
C50 a_969_36# VGND 0.01733f
C51 a_645_36# VGND 0.07973f
C52 a_1088_165# a_1149_36# 0.00499f
C53 a_645_36# a_141_36# 0.1515f
C54 Q_N VPWR 0.13857f
C57 a_969_450# VPWR 0.31722f
C58 a_969_450# a_753_36# 0.03755f
C59 a_2841_36# a_2060_165# 0.067f
C60 a_393_36# VPWR 0.16374f
C61 a_393_36# a_753_36# 0.18375f
C62 D VPB 0.11625f
C63 RESET_B VPB 0.26969f
C65 a_393_36# a_969_36# 0.00712f
C66 a_1725_36# VPWR 0.10784f
C67 a_2060_165# VPWR 0.30709f
C68 D VGND 0.03531f
C69 a_393_36# a_645_36# 0.07535f
C70 RESET_B VGND 0.064f
C71 D a_141_36# 0.07935f
C72 RESET_B a_141_36# 0.12282f
C73 a_2841_36# Q 0.03531f
C75 VPB VGND 0.04601f
C76 a_1088_165# VPWR 0.10986f
C77 a_1088_165# a_753_36# 0.22834f
C78 CLK VPWR 0.04196f
C79 VPB a_141_36# 0.47949f
C81 a_1088_165# a_969_36# 0.00254f
C83 a_969_450# RESET_B 0.08113f
C84 a_141_36# VGND 0.31437f
C85 Q VPWR 0.1707f
C86 a_393_36# D 0.09861f
C87 a_393_36# RESET_B 0.17237f
C88 VPB Q_N 0.01435f
C89 a_1941_450# VPWR 0.01954f
C90 a_969_450# VPB 0.02169f
C91 RESET_B a_1725_36# 0.16906f
C92 Q_N VGND 0.10221f
C93 a_753_36# a_1149_36# 0.00188f
C94 RESET_B a_2060_165# 0.18498f
C95 a_393_36# VPB 0.28962f
C97 a_969_450# a_141_36# 0.0791f
C98 a_1725_36# VPB 0.14352f
C99 a_393_36# VGND 0.54006f
C100 a_2060_165# VPB 0.32795f
C102 a_1088_165# RESET_B 0.14905f
C103 a_393_36# a_141_36# 1.12349f
C104 a_1725_36# VGND 0.09182f
C105 RESET_B a_1941_36# 0.00166f
C106 a_1725_36# a_141_36# 0.16186f
C107 a_2060_165# VGND 0.29256f
C108 a_2841_36# VPWR 0.22976f
C109 a_2060_165# a_141_36# 0.05535f
C110 a_1088_165# VPB 0.10846f
C111 RESET_B Q 0.00136f
C112 CLK VPB 0.09785f
C113 RESET_B a_1941_450# 0.00876f
C115 a_2229_36# VGND 0.01143f
C116 Q_N VNB 0.10703f
C117 Q VNB 0.0171f
C118 VGND VNB 2.02269f
C119 VPWR VNB 1.38982f
C120 RESET_B VNB 0.19691f
C121 D VNB 0.13204f
C122 CLK VNB 0.19841f
C123 VPB VNB 3.84912f
C124 a_969_450# VNB 0.0028f
C125 a_645_36# VNB 0.02294f
C126 a_2841_36# VNB 0.18599f
C127 a_1725_36# VNB 0.15264f
C128 a_2060_165# VNB 0.48832f
C129 a_753_36# VNB 0.16567f
C130 a_1088_165# VNB 0.17373f
C131 a_393_36# VNB 0.40194f
C132 a_141_36# VNB 0.58852f
.ends

.subckt sky130_efx_lvdig__dfrbp_2 CLK D RESET_B Q Q_N VGND VNB VPB VPWR
X0 VGND a_2060_165# Q VNB sky130_fd_pr__nfet_01v8 ad=0.23625 pd=2.01 as=0.12285 ps=1.02 w=0.63 l=0.15
X1 a_2949_36# a_2060_165# VPWR VPB sky130_fd_pr__pfet_01v8_hvt ad=0.23625 pd=2.01 as=0.23625 ps=2.01 w=0.63 l=0.15
X2 Q a_2060_165# VGND VNB sky130_fd_pr__nfet_01v8 ad=0.12285 pd=1.02 as=0.23625 ps=2.01 w=0.63 l=0.15
X3 a_969_450# a_141_36# a_753_36# VPB sky130_fd_pr__pfet_01v8_hvt ad=0.16875 pd=1.2 as=0.20925 ps=1.38 w=0.45 l=0.15
X4 VPWR a_1088_165# a_969_450# VPB sky130_fd_pr__pfet_01v8_hvt ad=0.08775 pd=0.84 as=0.16875 ps=1.2 w=0.45 l=0.15
X5 a_141_36# CLK VPWR VPB sky130_fd_pr__pfet_01v8_hvt ad=0.23625 pd=2.01 as=0.23625 ps=2.01 w=0.63 l=0.15
X6 VPWR a_1725_36# a_2060_165# VPB sky130_fd_pr__pfet_01v8_hvt ad=0.16875 pd=1.65 as=0.08775 ps=0.84 w=0.45 l=0.15
X7 a_645_36# D VGND VNB sky130_fd_pr__nfet_01v8 ad=0.08258 pd=0.84 as=0.16875 ps=1.65 w=0.45 l=0.15
X8 a_753_36# a_141_36# a_645_36# VNB sky130_fd_pr__special_nfet_01v8 ad=0.1674 pd=1.29 as=0.08258 ps=0.84 w=0.36 l=0.15
X9 a_969_450# RESET_B VPWR VPB sky130_fd_pr__pfet_01v8_hvt ad=0.16875 pd=1.65 as=0.08775 ps=0.84 w=0.45 l=0.15
X10 Q a_2060_165# VPWR VPB sky130_fd_pr__pfet_01v8_hvt ad=0.2106 pd=1.47 as=0.405 ps=2.91 w=1.08 l=0.15
X11 Q_N a_2949_36# VPWR VPB sky130_fd_pr__pfet_01v8_hvt ad=0.2106 pd=1.47 as=0.405 ps=2.91 w=1.08 l=0.15
X12 a_1941_450# a_393_36# a_1725_36# VPB sky130_fd_pr__pfet_01v8_hvt ad=0.16875 pd=1.2 as=0.20925 ps=1.38 w=0.45 l=0.15
X13 VGND a_2060_165# a_1941_36# VNB sky130_fd_pr__nfet_01v8 ad=0.08775 pd=0.84 as=0.15593 ps=1.2 w=0.45 l=0.15
X14 a_2949_36# a_2060_165# VGND VNB sky130_fd_pr__nfet_01v8 ad=0.16875 pd=1.65 as=0.16875 ps=1.65 w=0.45 l=0.15
X15 VPWR a_2060_165# Q VPB sky130_fd_pr__pfet_01v8_hvt ad=0.405 pd=2.91 as=0.2106 ps=1.47 w=1.08 l=0.15
X16 VPWR a_2949_36# Q_N VPB sky130_fd_pr__pfet_01v8_hvt ad=0.405 pd=2.91 as=0.2106 ps=1.47 w=1.08 l=0.15
X17 Q_N a_2949_36# VGND VNB sky130_fd_pr__nfet_01v8 ad=0.12285 pd=1.02 as=0.23625 ps=2.01 w=0.63 l=0.15
X18 a_141_36# CLK VGND VNB sky130_fd_pr__nfet_01v8 ad=0.16875 pd=1.65 as=0.16875 ps=1.65 w=0.45 l=0.15
X19 a_1088_165# a_753_36# VGND VNB sky130_fd_pr__nfet_01v8 ad=0.13702 pd=1.2 as=0.23625 ps=2.01 w=0.63 l=0.15
X20 a_393_36# a_141_36# VPWR VPB sky130_fd_pr__pfet_01v8_hvt ad=0.23625 pd=2.01 as=0.23625 ps=2.01 w=0.63 l=0.15
X21 a_969_36# a_393_36# a_753_36# VNB sky130_fd_pr__special_nfet_01v8 ad=0.15593 pd=1.2 as=0.1674 ps=1.29 w=0.36 l=0.15
X22 a_1149_36# a_1088_165# a_969_36# VNB sky130_fd_pr__nfet_01v8 ad=0.08775 pd=0.84 as=0.15593 ps=1.2 w=0.45 l=0.15
X23 VGND RESET_B a_1149_36# VNB sky130_fd_pr__nfet_01v8 ad=0.16875 pd=1.65 as=0.08775 ps=0.84 w=0.45 l=0.15
X24 VPWR a_2060_165# a_1941_450# VPB sky130_fd_pr__pfet_01v8_hvt ad=0.08775 pd=0.84 as=0.16875 ps=1.2 w=0.45 l=0.15
X25 a_2060_165# a_1725_36# a_2229_36# VNB sky130_fd_pr__nfet_01v8 ad=0.16875 pd=1.65 as=0.08775 ps=0.84 w=0.45 l=0.15
X26 a_2229_36# RESET_B VGND VNB sky130_fd_pr__nfet_01v8 ad=0.08775 pd=0.84 as=0.08775 ps=0.84 w=0.45 l=0.15
X27 a_645_36# D VPWR VPB sky130_fd_pr__pfet_01v8_hvt ad=0.08775 pd=0.84 as=0.16875 ps=1.65 w=0.45 l=0.15
X28 a_2060_165# RESET_B VPWR VPB sky130_fd_pr__pfet_01v8_hvt ad=0.08775 pd=0.84 as=0.08775 ps=0.84 w=0.45 l=0.15
X29 a_1725_36# a_141_36# a_1088_165# VPB sky130_fd_pr__pfet_01v8_hvt ad=0.20925 pd=1.38 as=0.17415 ps=1.38 w=0.45 l=0.15
X30 VGND a_2949_36# Q_N VNB sky130_fd_pr__nfet_01v8 ad=0.23625 pd=2.01 as=0.12285 ps=1.02 w=0.63 l=0.15
X31 a_753_36# a_393_36# a_645_36# VPB sky130_fd_pr__pfet_01v8_hvt ad=0.20925 pd=1.38 as=0.08775 ps=0.84 w=0.45 l=0.15
X32 a_1088_165# a_753_36# VPWR VPB sky130_fd_pr__pfet_01v8_hvt ad=0.17415 pd=1.38 as=0.30375 ps=2.37 w=0.81 l=0.15
X33 a_393_36# a_141_36# VGND VNB sky130_fd_pr__nfet_01v8 ad=0.16875 pd=1.65 as=0.16875 ps=1.65 w=0.45 l=0.15
X34 a_1941_36# a_141_36# a_1725_36# VNB sky130_fd_pr__special_nfet_01v8 ad=0.15593 pd=1.2 as=0.1674 ps=1.29 w=0.36 l=0.15
X35 a_1725_36# a_393_36# a_1088_165# VNB sky130_fd_pr__special_nfet_01v8 ad=0.1674 pd=1.29 as=0.13702 ps=1.2 w=0.36 l=0.15
C0 a_1088_165# VGND 0.21474f
C2 CLK VGND 0.04537f
C3 a_1088_165# a_141_36# 0.071f
C4 VPB Q 0.00889f
C5 a_1941_36# VGND 0.01995f
C7 a_753_36# VPWR 0.12161f
C8 CLK a_141_36# 0.09924f
C9 a_1941_36# a_141_36# 0.00331f
C10 a_969_36# a_753_36# 0.00965f
C11 a_393_36# a_1725_36# 0.12511f
C12 Q VGND 0.15357f
C13 a_645_36# VPWR 0.08042f
C14 a_393_36# a_2060_165# 0.02289f
C16 a_645_36# a_753_36# 0.04498f
C17 a_1088_165# a_969_450# 0.01004f
C18 a_2060_165# a_1725_36# 0.25953f
C20 a_1149_36# VGND 0.01143f
C22 a_1088_165# a_393_36# 0.27871f
C25 a_1088_165# a_1725_36# 0.04489f
C26 a_2060_165# a_2229_36# 0.00952f
C27 a_1725_36# a_1941_36# 0.00965f
C28 a_2949_36# VPB 0.1389f
C29 a_2060_165# a_1941_36# 0.00277f
C30 D VPWR 0.03564f
C31 RESET_B VPWR 0.58314f
C32 RESET_B a_753_36# 0.12175f
C33 a_393_36# a_1941_450# 0.00194f
C34 a_1725_36# Q 0.00104f
C35 a_2949_36# VGND 0.21597f
C36 a_2060_165# Q 0.13176f
C38 a_1725_36# a_1941_450# 0.01125f
C39 a_393_36# a_1149_36# 0.00304f
C40 D a_645_36# 0.06045f
C42 VPB VPWR 0.74883f
C43 VPB a_753_36# 0.12579f
C44 VGND VPWR 0.17818f
C45 a_753_36# VGND 0.0875f
C46 a_2949_36# Q_N 0.1198f
C47 a_645_36# VPB 0.02422f
C48 a_141_36# VPWR 0.47472f
C49 a_753_36# a_141_36# 0.26238f
C50 a_969_36# VGND 0.01733f
C51 a_645_36# VGND 0.07973f
C52 a_1088_165# a_1149_36# 0.00499f
C53 a_645_36# a_141_36# 0.1515f
C54 Q_N VPWR 0.22627f
C57 a_969_450# VPWR 0.31722f
C58 a_969_450# a_753_36# 0.03755f
C59 a_2949_36# a_2060_165# 0.0697f
C60 a_393_36# VPWR 0.16374f
C61 a_393_36# a_753_36# 0.18375f
C62 D VPB 0.11625f
C63 RESET_B VPB 0.26878f
C65 a_393_36# a_969_36# 0.00712f
C66 a_1725_36# VPWR 0.10827f
C67 a_2060_165# VPWR 0.35209f
C68 D VGND 0.03531f
C69 a_393_36# a_645_36# 0.07535f
C70 RESET_B VGND 0.064f
C71 D a_141_36# 0.07935f
C72 RESET_B a_141_36# 0.12282f
C73 a_2949_36# Q 0.01307f
C75 VPB VGND 0.04933f
C76 a_1088_165# VPWR 0.10986f
C77 a_1088_165# a_753_36# 0.22834f
C78 CLK VPWR 0.04196f
C79 VPB a_141_36# 0.47951f
C81 a_1088_165# a_969_36# 0.00254f
C83 a_969_450# RESET_B 0.08113f
C84 a_141_36# VGND 0.31442f
C85 Q VPWR 0.22627f
C86 a_393_36# D 0.09861f
C87 a_393_36# RESET_B 0.17237f
C88 VPB Q_N 0.00808f
C89 a_1941_450# VPWR 0.01954f
C90 a_969_450# VPB 0.02169f
C91 RESET_B a_1725_36# 0.16906f
C92 Q_N VGND 0.15357f
C93 a_753_36# a_1149_36# 0.00188f
C94 RESET_B a_2060_165# 0.18554f
C95 a_393_36# VPB 0.28962f
C97 a_969_450# a_141_36# 0.0791f
C98 a_1725_36# VPB 0.14421f
C99 a_393_36# VGND 0.54006f
C100 a_2060_165# VPB 0.37538f
C102 a_1088_165# RESET_B 0.14905f
C103 a_393_36# a_141_36# 1.12349f
C104 a_1725_36# VGND 0.09195f
C105 RESET_B a_1941_36# 0.00166f
C106 a_1725_36# a_141_36# 0.16186f
C107 a_2060_165# VGND 0.33059f
C108 a_2949_36# VPWR 0.27185f
C109 a_2060_165# a_141_36# 0.05568f
C110 a_1088_165# VPB 0.10846f
C111 RESET_B Q 0.00144f
C112 CLK VPB 0.09785f
C113 RESET_B a_1941_450# 0.00876f
C115 a_2229_36# VGND 0.01143f
C116 Q_N VNB 0.03639f
C117 Q VNB 0.01272f
C118 VGND VNB 2.17392f
C119 VPWR VNB 1.51072f
C120 RESET_B VNB 0.1956f
C121 D VNB 0.13204f
C122 CLK VNB 0.19841f
C123 VPB VNB 4.10573f
C124 a_969_450# VNB 0.0028f
C125 a_645_36# VNB 0.02294f
C126 a_2949_36# VNB 0.27373f
C127 a_1725_36# VNB 0.15274f
C128 a_2060_165# VNB 0.57432f
C129 a_753_36# VNB 0.16567f
C130 a_1088_165# VNB 0.17373f
C131 a_393_36# VNB 0.40194f
C132 a_141_36# VNB 0.58807f
.ends

.subckt sky130_efx_lvdig__dfrtp_1 CLK D RESET_B Q VGND VNB VPB VPWR
X0 Q a_2060_165# VGND VNB sky130_fd_pr__nfet_01v8 ad=0.23625 pd=2.01 as=0.23625 ps=2.01 w=0.63 l=0.15
X1 a_969_450# a_141_36# a_753_36# VPB sky130_fd_pr__pfet_01v8_hvt ad=0.16875 pd=1.2 as=0.20925 ps=1.38 w=0.45 l=0.15
X2 VPWR a_1088_165# a_969_450# VPB sky130_fd_pr__pfet_01v8_hvt ad=0.08775 pd=0.84 as=0.16875 ps=1.2 w=0.45 l=0.15
X3 a_141_36# CLK VPWR VPB sky130_fd_pr__pfet_01v8_hvt ad=0.23625 pd=2.01 as=0.23625 ps=2.01 w=0.63 l=0.15
X4 VPWR a_1725_36# a_2060_165# VPB sky130_fd_pr__pfet_01v8_hvt ad=0.16875 pd=1.65 as=0.08775 ps=0.84 w=0.45 l=0.15
X5 a_645_36# D VGND VNB sky130_fd_pr__nfet_01v8 ad=0.08258 pd=0.84 as=0.16875 ps=1.65 w=0.45 l=0.15
X6 a_753_36# a_141_36# a_645_36# VNB sky130_fd_pr__special_nfet_01v8 ad=0.1674 pd=1.29 as=0.08258 ps=0.84 w=0.36 l=0.15
X7 a_969_450# RESET_B VPWR VPB sky130_fd_pr__pfet_01v8_hvt ad=0.16875 pd=1.65 as=0.08775 ps=0.84 w=0.45 l=0.15
X8 Q a_2060_165# VPWR VPB sky130_fd_pr__pfet_01v8_hvt ad=0.405 pd=2.91 as=0.405 ps=2.91 w=1.08 l=0.15
X9 a_1941_450# a_393_36# a_1725_36# VPB sky130_fd_pr__pfet_01v8_hvt ad=0.16875 pd=1.2 as=0.20925 ps=1.38 w=0.45 l=0.15
X10 VGND a_2060_165# a_1941_36# VNB sky130_fd_pr__nfet_01v8 ad=0.08775 pd=0.84 as=0.15593 ps=1.2 w=0.45 l=0.15
X11 a_141_36# CLK VGND VNB sky130_fd_pr__nfet_01v8 ad=0.16875 pd=1.65 as=0.16875 ps=1.65 w=0.45 l=0.15
X12 a_1088_165# a_753_36# VGND VNB sky130_fd_pr__nfet_01v8 ad=0.13702 pd=1.2 as=0.23625 ps=2.01 w=0.63 l=0.15
X13 a_393_36# a_141_36# VPWR VPB sky130_fd_pr__pfet_01v8_hvt ad=0.23625 pd=2.01 as=0.23625 ps=2.01 w=0.63 l=0.15
X14 a_969_36# a_393_36# a_753_36# VNB sky130_fd_pr__special_nfet_01v8 ad=0.15593 pd=1.2 as=0.1674 ps=1.29 w=0.36 l=0.15
X15 a_1149_36# a_1088_165# a_969_36# VNB sky130_fd_pr__nfet_01v8 ad=0.08775 pd=0.84 as=0.15593 ps=1.2 w=0.45 l=0.15
X16 VGND RESET_B a_1149_36# VNB sky130_fd_pr__nfet_01v8 ad=0.16875 pd=1.65 as=0.08775 ps=0.84 w=0.45 l=0.15
X17 VPWR a_2060_165# a_1941_450# VPB sky130_fd_pr__pfet_01v8_hvt ad=0.08775 pd=0.84 as=0.16875 ps=1.2 w=0.45 l=0.15
X18 a_2060_165# a_1725_36# a_2229_36# VNB sky130_fd_pr__nfet_01v8 ad=0.16875 pd=1.65 as=0.08775 ps=0.84 w=0.45 l=0.15
X19 a_2229_36# RESET_B VGND VNB sky130_fd_pr__nfet_01v8 ad=0.08775 pd=0.84 as=0.08775 ps=0.84 w=0.45 l=0.15
X20 a_645_36# D VPWR VPB sky130_fd_pr__pfet_01v8_hvt ad=0.08775 pd=0.84 as=0.16875 ps=1.65 w=0.45 l=0.15
X21 a_2060_165# RESET_B VPWR VPB sky130_fd_pr__pfet_01v8_hvt ad=0.08775 pd=0.84 as=0.08775 ps=0.84 w=0.45 l=0.15
X22 a_1725_36# a_141_36# a_1088_165# VPB sky130_fd_pr__pfet_01v8_hvt ad=0.20925 pd=1.38 as=0.17415 ps=1.38 w=0.45 l=0.15
X23 a_753_36# a_393_36# a_645_36# VPB sky130_fd_pr__pfet_01v8_hvt ad=0.20925 pd=1.38 as=0.08775 ps=0.84 w=0.45 l=0.15
X24 a_1088_165# a_753_36# VPWR VPB sky130_fd_pr__pfet_01v8_hvt ad=0.17415 pd=1.38 as=0.30375 ps=2.37 w=0.81 l=0.15
X25 a_393_36# a_141_36# VGND VNB sky130_fd_pr__nfet_01v8 ad=0.16875 pd=1.65 as=0.16875 ps=1.65 w=0.45 l=0.15
X26 a_1941_36# a_141_36# a_1725_36# VNB sky130_fd_pr__special_nfet_01v8 ad=0.15593 pd=1.2 as=0.1674 ps=1.29 w=0.36 l=0.15
X27 a_1725_36# a_393_36# a_1088_165# VNB sky130_fd_pr__special_nfet_01v8 ad=0.1674 pd=1.29 as=0.13702 ps=1.2 w=0.36 l=0.15
C0 a_753_36# a_969_450# 0.03755f
C1 a_753_36# a_1088_165# 0.22834f
C2 a_141_36# CLK 0.09924f
C3 a_2060_165# a_141_36# 0.05478f
C4 a_753_36# a_645_36# 0.04498f
C5 a_1088_165# a_1149_36# 0.00499f
C6 VPWR a_141_36# 0.47472f
C7 VPB a_141_36# 0.47938f
C8 RESET_B a_1941_36# 0.00166f
C11 a_1088_165# a_393_36# 0.27871f
C12 a_393_36# a_645_36# 0.07535f
C13 a_1088_165# a_969_450# 0.01004f
C14 a_753_36# VPWR 0.12161f
C15 a_1941_36# a_141_36# 0.00331f
C16 a_753_36# VPB 0.12579f
C19 a_2060_165# a_393_36# 0.02289f
C20 a_393_36# VPWR 0.16374f
C21 a_393_36# VPB 0.28962f
C23 VPWR a_969_450# 0.31722f
C24 a_969_450# VPB 0.02169f
C25 a_1088_165# VPWR 0.10986f
C26 a_1941_450# RESET_B 0.00876f
C27 a_1088_165# VPB 0.10846f
C28 VPWR a_645_36# 0.08042f
C29 a_645_36# VPB 0.02422f
C30 VGND a_1725_36# 0.09182f
C31 Q a_1725_36# 0.00104f
C32 VGND a_2229_36# 0.01143f
C33 VPWR CLK 0.04196f
C34 VGND a_969_36# 0.01733f
C35 VPB CLK 0.09785f
C36 a_2060_165# VPWR 0.26709f
C37 a_2060_165# VPB 0.18361f
C38 RESET_B a_1725_36# 0.16906f
C39 VPWR VPB 0.573f
C41 VGND D 0.03531f
C42 a_1725_36# a_141_36# 0.16186f
C43 a_2060_165# a_1941_36# 0.00277f
C44 a_393_36# a_1941_450# 0.00194f
C46 VGND Q 0.10221f
C47 a_141_36# D 0.07935f
C48 a_753_36# a_969_36# 0.00965f
C49 a_393_36# a_1725_36# 0.12511f
C50 VGND RESET_B 0.064f
C51 Q RESET_B 0.00136f
C52 a_1088_165# a_1725_36# 0.04489f
C53 a_1941_450# VPWR 0.01954f
C54 a_393_36# a_969_36# 0.00712f
C55 VGND a_141_36# 0.31434f
C57 a_1088_165# a_969_36# 0.00254f
C58 a_393_36# D 0.09861f
C59 a_2060_165# a_1725_36# 0.25607f
C60 RESET_B a_141_36# 0.12282f
C61 VPWR a_1725_36# 0.10768f
C62 a_753_36# VGND 0.0875f
C63 a_1725_36# VPB 0.14214f
C64 a_2060_165# a_2229_36# 0.00952f
C67 VGND a_1149_36# 0.01143f
C68 a_645_36# D 0.06045f
C69 a_393_36# VGND 0.54006f
C70 a_753_36# RESET_B 0.12175f
C71 a_1941_36# a_1725_36# 0.00965f
C72 a_1088_165# VGND 0.21474f
C73 VGND a_645_36# 0.07973f
C74 VPWR D 0.03564f
C75 VPB D 0.11625f
C76 a_393_36# RESET_B 0.17237f
C77 a_753_36# a_141_36# 0.26238f
C78 a_969_450# RESET_B 0.08113f
C79 a_1088_165# RESET_B 0.14905f
C80 VGND CLK 0.04537f
C82 a_2060_165# VGND 0.25144f
C83 a_2060_165# Q 0.07073f
C84 a_393_36# a_141_36# 1.12349f
C85 VGND VPWR 0.0767f
C86 VPWR Q 0.13857f
C87 VGND VPB 0.03136f
C88 Q VPB 0.01435f
C89 a_969_450# a_141_36# 0.0791f
C90 a_753_36# a_1149_36# 0.00188f
C91 a_1088_165# a_141_36# 0.071f
C92 a_1941_450# a_1725_36# 0.01125f
C93 a_645_36# a_141_36# 0.1515f
C94 a_2060_165# RESET_B 0.18456f
C95 VPWR RESET_B 0.58159f
C96 a_753_36# a_393_36# 0.18375f
C97 RESET_B VPB 0.26748f
C98 VGND a_1941_36# 0.01995f
C99 a_393_36# a_1149_36# 0.00304f
C100 Q VNB 0.10703f
C101 VGND VNB 1.71773f
C102 VPWR VNB 1.19142f
C103 RESET_B VNB 0.2032f
C104 D VNB 0.13204f
C105 CLK VNB 0.19841f
C106 VPB VNB 3.25037f
C107 a_969_450# VNB 0.0028f
C108 a_645_36# VNB 0.02294f
C109 a_1725_36# VNB 0.15837f
C110 a_2060_165# VNB 0.30916f
C111 a_753_36# VNB 0.16567f
C112 a_1088_165# VNB 0.17373f
C113 a_393_36# VNB 0.40194f
C114 a_141_36# VNB 0.59072f
.ends

.subckt sky130_efx_lvdig__dfrtp_2 CLK D RESET_B Q VGND VNB VPB VPWR
X0 VGND a_2060_165# Q VNB sky130_fd_pr__nfet_01v8 ad=0.23625 pd=2.01 as=0.12285 ps=1.02 w=0.63 l=0.15
X1 Q a_2060_165# VGND VNB sky130_fd_pr__nfet_01v8 ad=0.12285 pd=1.02 as=0.23625 ps=2.01 w=0.63 l=0.15
X2 a_969_450# a_141_36# a_753_36# VPB sky130_fd_pr__pfet_01v8_hvt ad=0.16875 pd=1.2 as=0.20925 ps=1.38 w=0.45 l=0.15
X3 VPWR a_1088_165# a_969_450# VPB sky130_fd_pr__pfet_01v8_hvt ad=0.08775 pd=0.84 as=0.16875 ps=1.2 w=0.45 l=0.15
X4 a_141_36# CLK VPWR VPB sky130_fd_pr__pfet_01v8_hvt ad=0.23625 pd=2.01 as=0.23625 ps=2.01 w=0.63 l=0.15
X5 VPWR a_1725_36# a_2060_165# VPB sky130_fd_pr__pfet_01v8_hvt ad=0.16875 pd=1.65 as=0.08775 ps=0.84 w=0.45 l=0.15
X6 a_645_36# D VGND VNB sky130_fd_pr__nfet_01v8 ad=0.08258 pd=0.84 as=0.16875 ps=1.65 w=0.45 l=0.15
X7 a_753_36# a_141_36# a_645_36# VNB sky130_fd_pr__special_nfet_01v8 ad=0.1674 pd=1.29 as=0.08258 ps=0.84 w=0.36 l=0.15
X8 a_969_450# RESET_B VPWR VPB sky130_fd_pr__pfet_01v8_hvt ad=0.16875 pd=1.65 as=0.08775 ps=0.84 w=0.45 l=0.15
X9 Q a_2060_165# VPWR VPB sky130_fd_pr__pfet_01v8_hvt ad=0.2106 pd=1.47 as=0.405 ps=2.91 w=1.08 l=0.15
X10 a_1941_450# a_393_36# a_1725_36# VPB sky130_fd_pr__pfet_01v8_hvt ad=0.16875 pd=1.2 as=0.20925 ps=1.38 w=0.45 l=0.15
X11 VGND a_2060_165# a_1941_36# VNB sky130_fd_pr__nfet_01v8 ad=0.08775 pd=0.84 as=0.15593 ps=1.2 w=0.45 l=0.15
X12 VPWR a_2060_165# Q VPB sky130_fd_pr__pfet_01v8_hvt ad=0.405 pd=2.91 as=0.2106 ps=1.47 w=1.08 l=0.15
X13 a_141_36# CLK VGND VNB sky130_fd_pr__nfet_01v8 ad=0.16875 pd=1.65 as=0.16875 ps=1.65 w=0.45 l=0.15
X14 a_1088_165# a_753_36# VGND VNB sky130_fd_pr__nfet_01v8 ad=0.13702 pd=1.2 as=0.23625 ps=2.01 w=0.63 l=0.15
X15 a_393_36# a_141_36# VPWR VPB sky130_fd_pr__pfet_01v8_hvt ad=0.23625 pd=2.01 as=0.23625 ps=2.01 w=0.63 l=0.15
X16 a_969_36# a_393_36# a_753_36# VNB sky130_fd_pr__special_nfet_01v8 ad=0.15593 pd=1.2 as=0.1674 ps=1.29 w=0.36 l=0.15
X17 a_1149_36# a_1088_165# a_969_36# VNB sky130_fd_pr__nfet_01v8 ad=0.08775 pd=0.84 as=0.15593 ps=1.2 w=0.45 l=0.15
X18 VGND RESET_B a_1149_36# VNB sky130_fd_pr__nfet_01v8 ad=0.16875 pd=1.65 as=0.08775 ps=0.84 w=0.45 l=0.15
X19 VPWR a_2060_165# a_1941_450# VPB sky130_fd_pr__pfet_01v8_hvt ad=0.08775 pd=0.84 as=0.16875 ps=1.2 w=0.45 l=0.15
X20 a_2060_165# a_1725_36# a_2229_36# VNB sky130_fd_pr__nfet_01v8 ad=0.16875 pd=1.65 as=0.08775 ps=0.84 w=0.45 l=0.15
X21 a_2229_36# RESET_B VGND VNB sky130_fd_pr__nfet_01v8 ad=0.08775 pd=0.84 as=0.08775 ps=0.84 w=0.45 l=0.15
X22 a_645_36# D VPWR VPB sky130_fd_pr__pfet_01v8_hvt ad=0.08775 pd=0.84 as=0.16875 ps=1.65 w=0.45 l=0.15
X23 a_2060_165# RESET_B VPWR VPB sky130_fd_pr__pfet_01v8_hvt ad=0.08775 pd=0.84 as=0.08775 ps=0.84 w=0.45 l=0.15
X24 a_1725_36# a_141_36# a_1088_165# VPB sky130_fd_pr__pfet_01v8_hvt ad=0.20925 pd=1.38 as=0.17415 ps=1.38 w=0.45 l=0.15
X25 a_753_36# a_393_36# a_645_36# VPB sky130_fd_pr__pfet_01v8_hvt ad=0.20925 pd=1.38 as=0.08775 ps=0.84 w=0.45 l=0.15
X26 a_1088_165# a_753_36# VPWR VPB sky130_fd_pr__pfet_01v8_hvt ad=0.17415 pd=1.38 as=0.30375 ps=2.37 w=0.81 l=0.15
X27 a_393_36# a_141_36# VGND VNB sky130_fd_pr__nfet_01v8 ad=0.16875 pd=1.65 as=0.16875 ps=1.65 w=0.45 l=0.15
X28 a_1941_36# a_141_36# a_1725_36# VNB sky130_fd_pr__special_nfet_01v8 ad=0.15593 pd=1.2 as=0.1674 ps=1.29 w=0.36 l=0.15
X29 a_1725_36# a_393_36# a_1088_165# VNB sky130_fd_pr__special_nfet_01v8 ad=0.1674 pd=1.29 as=0.13702 ps=1.2 w=0.36 l=0.15
C0 a_753_36# a_969_450# 0.03755f
C1 a_753_36# a_1088_165# 0.22834f
C2 a_141_36# CLK 0.09924f
C3 a_2060_165# a_141_36# 0.05502f
C4 a_753_36# a_645_36# 0.04498f
C5 a_1088_165# a_1149_36# 0.00499f
C6 VPWR a_141_36# 0.47472f
C7 VPB a_141_36# 0.47939f
C8 RESET_B a_1941_36# 0.00166f
C11 a_1088_165# a_393_36# 0.27871f
C12 a_393_36# a_645_36# 0.07535f
C13 a_1088_165# a_969_450# 0.01004f
C14 a_753_36# VPWR 0.12161f
C15 a_1941_36# a_141_36# 0.00331f
C16 a_753_36# VPB 0.12579f
C19 a_2060_165# a_393_36# 0.02289f
C20 a_393_36# VPWR 0.16374f
C21 a_393_36# VPB 0.28962f
C23 VPWR a_969_450# 0.31722f
C24 a_969_450# VPB 0.02169f
C25 a_1088_165# VPWR 0.10986f
C26 a_1941_450# RESET_B 0.00876f
C27 a_1088_165# VPB 0.10846f
C28 VPWR a_645_36# 0.08042f
C29 a_645_36# VPB 0.02422f
C30 VGND a_1725_36# 0.09195f
C31 Q a_1725_36# 0.00104f
C32 VGND a_2229_36# 0.01143f
C33 VPWR CLK 0.04196f
C34 VGND a_969_36# 0.01733f
C35 VPB CLK 0.09785f
C36 a_2060_165# VPWR 0.29791f
C37 a_2060_165# VPB 0.22801f
C38 RESET_B a_1725_36# 0.16906f
C39 VPWR VPB 0.58277f
C41 VGND D 0.03531f
C42 a_1725_36# a_141_36# 0.16186f
C43 a_2060_165# a_1941_36# 0.00277f
C44 a_393_36# a_1941_450# 0.00194f
C46 VGND Q 0.15357f
C47 a_141_36# D 0.07935f
C48 a_753_36# a_969_36# 0.00965f
C49 a_393_36# a_1725_36# 0.12511f
C50 VGND RESET_B 0.064f
C51 Q RESET_B 0.00144f
C52 a_1088_165# a_1725_36# 0.04489f
C53 a_1941_450# VPWR 0.01954f
C54 a_393_36# a_969_36# 0.00712f
C55 VGND a_141_36# 0.31438f
C57 a_1088_165# a_969_36# 0.00254f
C58 a_393_36# D 0.09861f
C59 a_2060_165# a_1725_36# 0.25607f
C60 RESET_B a_141_36# 0.12282f
C61 VPWR a_1725_36# 0.10814f
C62 a_753_36# VGND 0.0875f
C63 a_1725_36# VPB 0.14291f
C64 a_2060_165# a_2229_36# 0.00952f
C67 VGND a_1149_36# 0.01143f
C68 a_645_36# D 0.06045f
C69 a_393_36# VGND 0.54006f
C70 a_753_36# RESET_B 0.12175f
C71 a_1941_36# a_1725_36# 0.00965f
C72 a_1088_165# VGND 0.21474f
C73 VGND a_645_36# 0.07973f
C74 VPWR D 0.03564f
C75 VPB D 0.11625f
C76 a_393_36# RESET_B 0.17237f
C77 a_753_36# a_141_36# 0.26238f
C78 a_969_450# RESET_B 0.08113f
C79 a_1088_165# RESET_B 0.14905f
C80 VGND CLK 0.04537f
C82 a_2060_165# VGND 0.27868f
C83 a_2060_165# Q 0.1198f
C84 a_393_36# a_141_36# 1.12349f
C85 VGND VPWR 0.0948f
C86 VPWR Q 0.22627f
C87 VGND VPB 0.02998f
C88 Q VPB 0.00762f
C89 a_969_450# a_141_36# 0.0791f
C90 a_753_36# a_1149_36# 0.00188f
C91 a_1088_165# a_141_36# 0.071f
C92 a_1941_450# a_1725_36# 0.01125f
C93 a_645_36# a_141_36# 0.1515f
C94 a_2060_165# RESET_B 0.18523f
C95 VPWR RESET_B 0.58244f
C96 a_753_36# a_393_36# 0.18375f
C97 RESET_B VPB 0.26648f
C98 VGND a_1941_36# 0.01995f
C99 a_393_36# a_1149_36# 0.00304f
C100 Q VNB 0.03684f
C101 VGND VNB 1.78139f
C102 VPWR VNB 1.25981f
C103 RESET_B VNB 0.20182f
C104 D VNB 0.13204f
C105 CLK VNB 0.19841f
C106 VPB VNB 3.3359f
C107 a_969_450# VNB 0.0028f
C108 a_645_36# VNB 0.02294f
C109 a_1725_36# VNB 0.1576f
C110 a_2060_165# VNB 0.39739f
C111 a_753_36# VNB 0.16567f
C112 a_1088_165# VNB 0.17373f
C113 a_393_36# VNB 0.40194f
C114 a_141_36# VNB 0.59034f
.ends

.subckt sky130_efx_lvdig__dfstp_1 CLK D SET_B Q VGND VNB VPB VPWR
X0 a_1137_171# a_789_36# VPWR VPB sky130_fd_pr__pfet_01v8_hvt ad=0.08775 pd=0.84 as=0.16875 ps=1.65 w=0.45 l=0.15
X1 a_2985_36# a_1977_36# VGND VNB sky130_fd_pr__nfet_01v8 ad=0.16875 pd=1.65 as=0.16875 ps=1.65 w=0.45 l=0.15
X2 a_141_36# CLK VPWR VPB sky130_fd_pr__pfet_01v8_hvt ad=0.23625 pd=2.01 as=0.23625 ps=2.01 w=0.63 l=0.15
X3 a_645_36# D VGND VNB sky130_fd_pr__nfet_01v8 ad=0.13702 pd=1.2 as=0.23625 ps=2.01 w=0.63 l=0.15
X4 a_789_36# a_393_36# a_645_36# VPB sky130_fd_pr__pfet_01v8_hvt ad=0.20925 pd=1.38 as=0.17415 ps=1.38 w=0.45 l=0.15
X5 VPWR SET_B a_1137_171# VPB sky130_fd_pr__pfet_01v8_hvt ad=0.16875 pd=1.65 as=0.08775 ps=0.84 w=0.45 l=0.15
X6 a_1869_36# a_789_36# VGND VNB sky130_fd_pr__nfet_01v8 ad=0.08775 pd=0.84 as=0.16875 ps=1.65 w=0.45 l=0.15
X7 a_1977_36# a_393_36# a_1869_36# VNB sky130_fd_pr__nfet_01v8 ad=0.20925 pd=1.38 as=0.08775 ps=0.84 w=0.45 l=0.15
X8 a_645_36# D VPWR VPB sky130_fd_pr__pfet_01v8_hvt ad=0.17415 pd=1.38 as=0.30375 ps=2.37 w=0.81 l=0.15
X9 a_2985_36# a_1977_36# VPWR VPB sky130_fd_pr__pfet_01v8_hvt ad=0.23625 pd=2.01 as=0.23625 ps=2.01 w=0.63 l=0.15
X10 VPWR a_1137_171# a_1005_450# VPB sky130_fd_pr__pfet_01v8_hvt ad=0.16875 pd=1.65 as=0.16875 ps=1.2 w=0.45 l=0.15
X11 a_1005_450# a_141_36# a_789_36# VPB sky130_fd_pr__pfet_01v8_hvt ad=0.16875 pd=1.2 as=0.20925 ps=1.38 w=0.45 l=0.15
X12 VPWR a_2325_171# a_2193_450# VPB sky130_fd_pr__pfet_01v8_hvt ad=0.08775 pd=0.84 as=0.16875 ps=1.2 w=0.45 l=0.15
X13 a_2193_36# a_141_36# a_1977_36# VNB sky130_fd_pr__nfet_01v8 ad=0.16875 pd=1.2 as=0.20925 ps=1.38 w=0.45 l=0.15
X14 a_1005_36# a_393_36# a_789_36# VNB sky130_fd_pr__special_nfet_01v8 ad=0.15593 pd=1.2 as=0.1674 ps=1.29 w=0.36 l=0.15
X15 VGND a_1137_171# a_1005_36# VNB sky130_fd_pr__nfet_01v8 ad=0.16875 pd=1.65 as=0.15593 ps=1.2 w=0.45 l=0.15
X16 a_1869_450# a_789_36# VPWR VPB sky130_fd_pr__pfet_01v8_hvt ad=0.08775 pd=0.84 as=0.16875 ps=1.65 w=0.45 l=0.15
X17 a_2193_450# a_393_36# a_1977_36# VPB sky130_fd_pr__pfet_01v8_hvt ad=0.16875 pd=1.2 as=0.20925 ps=1.38 w=0.45 l=0.15
X18 a_1977_36# SET_B VPWR VPB sky130_fd_pr__pfet_01v8_hvt ad=0.16875 pd=1.65 as=0.08775 ps=0.84 w=0.45 l=0.15
X19 a_789_36# a_141_36# a_645_36# VNB sky130_fd_pr__special_nfet_01v8 ad=0.1674 pd=1.29 as=0.13702 ps=1.2 w=0.36 l=0.15
X20 a_141_36# CLK VGND VNB sky130_fd_pr__nfet_01v8 ad=0.16875 pd=1.65 as=0.16875 ps=1.65 w=0.45 l=0.15
X21 a_2373_36# a_2325_171# a_2193_36# VNB sky130_fd_pr__nfet_01v8 ad=0.08775 pd=0.84 as=0.16875 ps=1.2 w=0.45 l=0.15
X22 VGND SET_B a_2373_36# VNB sky130_fd_pr__nfet_01v8 ad=0.16875 pd=1.65 as=0.08775 ps=0.84 w=0.45 l=0.15
X23 a_1977_36# a_141_36# a_1869_450# VPB sky130_fd_pr__pfet_01v8_hvt ad=0.20925 pd=1.38 as=0.08775 ps=0.84 w=0.45 l=0.15
X24 a_393_36# a_141_36# VPWR VPB sky130_fd_pr__pfet_01v8_hvt ad=0.23625 pd=2.01 as=0.23625 ps=2.01 w=0.63 l=0.15
X25 a_2325_171# a_1977_36# VPWR VPB sky130_fd_pr__pfet_01v8_hvt ad=0.30375 pd=2.37 as=0.30375 ps=2.37 w=0.81 l=0.15
X26 Q a_2985_36# VGND VNB sky130_fd_pr__nfet_01v8 ad=0.23625 pd=2.01 as=0.23625 ps=2.01 w=0.63 l=0.15
X27 a_1437_36# a_789_36# a_1137_171# VNB sky130_fd_pr__nfet_01v8 ad=0.08775 pd=0.84 as=0.16875 ps=1.65 w=0.45 l=0.15
X28 VGND SET_B a_1437_36# VNB sky130_fd_pr__nfet_01v8 ad=0.16875 pd=1.65 as=0.08775 ps=0.84 w=0.45 l=0.15
X29 Q a_2985_36# VPWR VPB sky130_fd_pr__pfet_01v8_hvt ad=0.405 pd=2.91 as=0.405 ps=2.91 w=1.08 l=0.15
X30 a_2325_171# a_1977_36# VGND VNB sky130_fd_pr__nfet_01v8 ad=0.2025 pd=1.83 as=0.2025 ps=1.83 w=0.54 l=0.15
X31 a_393_36# a_141_36# VGND VNB sky130_fd_pr__nfet_01v8 ad=0.16875 pd=1.65 as=0.16875 ps=1.65 w=0.45 l=0.15
C1 SET_B VPB 0.31464f
C2 a_141_36# VPB 0.47373f
C3 a_789_36# SET_B 0.2062f
C4 a_789_36# a_141_36# 0.33311f
C5 a_393_36# VGND 0.64998f
C6 a_1977_36# a_2193_36# 0.01122f
C8 a_2193_450# VPWR 0.01954f
C9 VGND D 0.04181f
C11 Q VPWR 0.13857f
C12 a_2325_171# a_2373_36# 0.00509f
C13 a_141_36# SET_B 0.09697f
C14 a_789_36# a_1005_450# 0.01115f
C16 a_645_36# VPB 0.01874f
C17 a_2985_36# Q 0.07073f
C18 VGND a_2193_36# 0.01833f
C19 a_1005_36# a_789_36# 0.01032f
C20 a_789_36# a_645_36# 0.04067f
C21 a_393_36# a_1437_36# 0.00304f
C22 a_393_36# a_1869_36# 0.00323f
C23 a_1977_36# VGND 0.15355f
C24 a_1977_36# a_1869_450# 0.00277f
C26 a_141_36# a_1005_450# 0.0071f
C27 a_1137_171# VGND 0.14853f
C28 a_2325_171# VPB 0.10947f
C29 VPWR VPB 0.74953f
C31 a_141_36# a_645_36# 0.11337f
C32 a_393_36# a_2193_450# 0.00194f
C33 a_789_36# VPWR 0.13891f
C34 a_2985_36# VPB 0.09198f
C37 a_1977_36# a_1869_36# 0.00267f
C38 VGND CLK 0.04537f
C39 a_2325_171# SET_B 0.12029f
C40 a_141_36# a_2325_171# 0.04768f
C41 a_1437_36# a_1137_171# 0.00469f
C42 SET_B VPWR 0.58001f
C43 a_141_36# VPWR 0.58649f
C44 a_2985_36# SET_B 0.00107f
C46 a_1977_36# a_2193_450# 0.01125f
C47 a_1437_36# VGND 0.01236f
C48 a_1869_36# VGND 0.01236f
C49 a_393_36# VPB 0.31051f
C51 a_1977_36# a_2373_36# 0.00188f
C52 a_393_36# a_789_36# 0.25128f
C53 a_1005_450# VPWR 0.0225f
C54 D VPB 0.08736f
C55 a_645_36# VPWR 0.11347f
C56 VGND Q 0.10221f
C57 a_393_36# SET_B 0.18256f
C58 VGND a_2373_36# 0.01143f
C59 a_393_36# a_141_36# 1.24978f
C60 a_1977_36# VPB 0.30084f
C61 a_2325_171# VPWR 0.16682f
C62 a_1977_36# a_789_36# 0.00188f
C64 a_141_36# D 0.05442f
C65 a_1137_171# VPB 0.16003f
C66 a_2325_171# a_2985_36# 0.03531f
C67 a_789_36# a_1137_171# 0.31798f
C68 a_2985_36# VPWR 0.22976f
C69 SET_B a_2193_36# 0.00169f
C70 a_141_36# a_2193_36# 0.00422f
C71 VGND VPB 0.04941f
C72 a_393_36# a_1005_36# 0.00712f
C73 a_1977_36# SET_B 0.17698f
C74 a_393_36# a_645_36# 0.06208f
C75 a_789_36# VGND 0.16626f
C76 a_1977_36# a_141_36# 0.16395f
C78 a_1137_171# SET_B 0.05571f
C79 a_1137_171# a_141_36# 0.10794f
C80 CLK VPB 0.09785f
C81 a_645_36# D 0.05765f
C82 SET_B VGND 0.06764f
C83 a_393_36# a_2325_171# 0.02269f
C84 a_141_36# VGND 0.31627f
C85 a_393_36# VPWR 0.1838f
C86 SET_B a_1869_450# 0.00455f
C87 a_1437_36# a_789_36# 0.00294f
C92 a_141_36# CLK 0.09923f
C93 D VPWR 0.0516f
C94 a_1005_36# a_1137_171# 0.00182f
C95 a_2325_171# a_2193_36# 0.00158f
C96 a_1005_36# VGND 0.01995f
C97 Q VPB 0.01435f
C98 a_645_36# VGND 0.09765f
C99 a_1977_36# a_2325_171# 0.25889f
C100 a_1977_36# VPWR 0.31101f
C101 a_1977_36# a_2985_36# 0.067f
C102 a_1137_171# VPWR 0.21437f
C103 a_2193_450# SET_B 0.00876f
C104 a_2325_171# VGND 0.23586f
C105 VGND VPWR 0.12695f
C108 a_393_36# D 0.06896f
C109 SET_B a_2373_36# 0.00142f
C110 a_1869_450# VPWR 0.01083f
C111 a_2985_36# VGND 0.18408f
C112 a_789_36# VPB 0.24553f
C113 CLK VPWR 0.04196f
C114 a_393_36# a_1977_36# 0.12536f
C115 a_393_36# a_1137_171# 0.1153f
C116 Q VNB 0.10703f
C117 VGND VNB 2.12866f
C118 VPWR VNB 1.44523f
C119 SET_B VNB 0.23004f
C120 D VNB 0.12037f
C121 CLK VNB 0.19841f
C122 VPB VNB 4.02019f
C123 a_645_36# VNB 0.02229f
C124 a_2985_36# VNB 0.18599f
C125 a_1977_36# VNB 0.36389f
C126 a_2325_171# VNB 0.16072f
C127 a_789_36# VNB 0.31694f
C128 a_1137_171# VNB 0.16766f
C129 a_393_36# VNB 0.42112f
C130 a_141_36# VNB 0.59336f
.ends

.subckt sky130_efx_lvdig__dfstp_2 CLK D SET_B Q VGND VNB VPB VPWR
X0 a_1137_171# a_789_36# VPWR VPB sky130_fd_pr__pfet_01v8_hvt ad=0.08775 pd=0.84 as=0.16875 ps=1.65 w=0.45 l=0.15
X1 nmos_n3f5_f1_l150_0.D0 a_1977_36# VGND VNB sky130_fd_pr__nfet_01v8 ad=0.23625 pd=2.01 as=0.23625 ps=2.01 w=0.63 l=0.15
X2 a_141_36# CLK VPWR VPB sky130_fd_pr__pfet_01v8_hvt ad=0.23625 pd=2.01 as=0.23625 ps=2.01 w=0.63 l=0.15
X3 a_645_36# D VGND VNB sky130_fd_pr__nfet_01v8 ad=0.13702 pd=1.2 as=0.23625 ps=2.01 w=0.63 l=0.15
X4 a_789_36# a_393_36# a_645_36# VPB sky130_fd_pr__pfet_01v8_hvt ad=0.20925 pd=1.38 as=0.17415 ps=1.38 w=0.45 l=0.15
X5 VPWR SET_B a_1137_171# VPB sky130_fd_pr__pfet_01v8_hvt ad=0.16875 pd=1.65 as=0.08775 ps=0.84 w=0.45 l=0.15
X6 a_1869_36# a_789_36# VGND VNB sky130_fd_pr__nfet_01v8 ad=0.08775 pd=0.84 as=0.16875 ps=1.65 w=0.45 l=0.15
X7 a_1977_36# a_393_36# a_1869_36# VNB sky130_fd_pr__nfet_01v8 ad=0.20925 pd=1.38 as=0.08775 ps=0.84 w=0.45 l=0.15
X8 a_645_36# D VPWR VPB sky130_fd_pr__pfet_01v8_hvt ad=0.17415 pd=1.38 as=0.30375 ps=2.37 w=0.81 l=0.15
X9 nmos_n3f5_f1_l150_0.D0 a_1977_36# VPWR VPB sky130_fd_pr__pfet_01v8_hvt ad=0.405 pd=2.91 as=0.405 ps=2.91 w=1.08 l=0.15
X10 VPWR a_1137_171# a_1005_450# VPB sky130_fd_pr__pfet_01v8_hvt ad=0.16875 pd=1.65 as=0.16875 ps=1.2 w=0.45 l=0.15
X11 a_1005_450# a_141_36# a_789_36# VPB sky130_fd_pr__pfet_01v8_hvt ad=0.16875 pd=1.2 as=0.20925 ps=1.38 w=0.45 l=0.15
X12 VPWR a_2325_171# a_2193_450# VPB sky130_fd_pr__pfet_01v8_hvt ad=0.08775 pd=0.84 as=0.16875 ps=1.2 w=0.45 l=0.15
X13 a_2193_36# a_141_36# a_1977_36# VNB sky130_fd_pr__nfet_01v8 ad=0.16875 pd=1.2 as=0.20925 ps=1.38 w=0.45 l=0.15
X14 a_1005_36# a_393_36# a_789_36# VNB sky130_fd_pr__special_nfet_01v8 ad=0.15593 pd=1.2 as=0.1674 ps=1.29 w=0.36 l=0.15
X15 VGND a_1137_171# a_1005_36# VNB sky130_fd_pr__nfet_01v8 ad=0.16875 pd=1.65 as=0.15593 ps=1.2 w=0.45 l=0.15
X16 a_1869_450# a_789_36# VPWR VPB sky130_fd_pr__pfet_01v8_hvt ad=0.08775 pd=0.84 as=0.16875 ps=1.65 w=0.45 l=0.15
X17 a_2193_450# a_393_36# a_1977_36# VPB sky130_fd_pr__pfet_01v8_hvt ad=0.16875 pd=1.2 as=0.20925 ps=1.38 w=0.45 l=0.15
X18 a_1977_36# SET_B VPWR VPB sky130_fd_pr__pfet_01v8_hvt ad=0.16875 pd=1.65 as=0.08775 ps=0.84 w=0.45 l=0.15
X19 a_789_36# a_141_36# a_645_36# VNB sky130_fd_pr__special_nfet_01v8 ad=0.1674 pd=1.29 as=0.13702 ps=1.2 w=0.36 l=0.15
X20 a_141_36# CLK VGND VNB sky130_fd_pr__nfet_01v8 ad=0.16875 pd=1.65 as=0.16875 ps=1.65 w=0.45 l=0.15
X21 a_2373_36# a_2325_171# a_2193_36# VNB sky130_fd_pr__nfet_01v8 ad=0.08775 pd=0.84 as=0.16875 ps=1.2 w=0.45 l=0.15
X22 VGND SET_B a_2373_36# VNB sky130_fd_pr__nfet_01v8 ad=0.16875 pd=1.65 as=0.08775 ps=0.84 w=0.45 l=0.15
X23 a_1977_36# a_141_36# a_1869_450# VPB sky130_fd_pr__pfet_01v8_hvt ad=0.20925 pd=1.38 as=0.08775 ps=0.84 w=0.45 l=0.15
X24 a_393_36# a_141_36# VPWR VPB sky130_fd_pr__pfet_01v8_hvt ad=0.23625 pd=2.01 as=0.23625 ps=2.01 w=0.63 l=0.15
X25 a_2325_171# a_1977_36# VPWR VPB sky130_fd_pr__pfet_01v8_hvt ad=0.30375 pd=2.37 as=0.30375 ps=2.37 w=0.81 l=0.15
X26 Q nmos_n3f5_f1_l150_0.D0 VGND VNB sky130_fd_pr__nfet_01v8 ad=0.12285 pd=1.02 as=0.23625 ps=2.01 w=0.63 l=0.15
X27 VGND nmos_n3f5_f1_l150_0.D0 Q VNB sky130_fd_pr__nfet_01v8 ad=0.23625 pd=2.01 as=0.12285 ps=1.02 w=0.63 l=0.15
X28 a_1437_36# a_789_36# a_1137_171# VNB sky130_fd_pr__nfet_01v8 ad=0.08775 pd=0.84 as=0.16875 ps=1.65 w=0.45 l=0.15
X29 VGND SET_B a_1437_36# VNB sky130_fd_pr__nfet_01v8 ad=0.16875 pd=1.65 as=0.08775 ps=0.84 w=0.45 l=0.15
X30 Q nmos_n3f5_f1_l150_0.D0 VPWR VPB sky130_fd_pr__pfet_01v8_hvt ad=0.2106 pd=1.47 as=0.405 ps=2.91 w=1.08 l=0.15
X31 a_2325_171# a_1977_36# VGND VNB sky130_fd_pr__nfet_01v8 ad=0.2025 pd=1.83 as=0.2025 ps=1.83 w=0.54 l=0.15
X32 a_393_36# a_141_36# VGND VNB sky130_fd_pr__nfet_01v8 ad=0.16875 pd=1.65 as=0.16875 ps=1.65 w=0.45 l=0.15
X33 VPWR nmos_n3f5_f1_l150_0.D0 Q VPB sky130_fd_pr__pfet_01v8_hvt ad=0.405 pd=2.91 as=0.2106 ps=1.47 w=1.08 l=0.15
C0 a_1869_450# VPWR 0.01083f
C1 a_1977_36# VPWR 0.32078f
C2 a_789_36# VPB 0.24553f
C3 a_1977_36# a_1869_36# 0.00267f
C5 a_141_36# VPB 0.47374f
C7 a_789_36# a_1437_36# 0.00294f
C8 a_1137_171# VPWR 0.21437f
C9 SET_B VPB 0.31395f
C10 VPWR D 0.0516f
C11 a_645_36# VPB 0.01874f
C13 a_789_36# a_141_36# 0.33311f
C14 a_1977_36# a_2373_36# 0.00188f
C15 a_2325_171# VPWR 0.18977f
C17 a_393_36# a_1977_36# 0.12536f
C18 VGND VPB 0.04497f
C19 a_789_36# SET_B 0.2062f
C20 a_789_36# a_645_36# 0.04067f
C21 VGND a_1437_36# 0.01236f
C22 a_141_36# SET_B 0.09697f
C23 a_141_36# a_645_36# 0.11337f
C24 a_789_36# VGND 0.16626f
C25 a_393_36# a_1137_171# 0.1153f
C26 a_393_36# D 0.06896f
C27 a_2325_171# a_2373_36# 0.00509f
C28 a_141_36# VGND 0.31631f
C30 a_393_36# a_2325_171# 0.02269f
C31 a_789_36# a_1005_36# 0.01032f
C32 Q VPB 0.00762f
C33 VGND SET_B 0.06773f
C34 VPWR VPB 0.75738f
C35 a_1977_36# nmos_n3f5_f1_l150_0.D0 0.06155f
C36 VGND a_645_36# 0.09765f
C37 a_1869_450# a_1977_36# 0.00277f
C38 a_789_36# a_1005_450# 0.01115f
C39 a_2193_450# SET_B 0.00876f
C40 a_141_36# a_1005_450# 0.0071f
C41 a_789_36# VPWR 0.13891f
C43 a_1977_36# a_2193_36# 0.01122f
C45 a_141_36# VPWR 0.58649f
C46 a_1005_36# VGND 0.01995f
C49 a_2325_171# nmos_n3f5_f1_l150_0.D0 0.01986f
C51 a_393_36# VPB 0.31051f
C52 SET_B VPWR 0.58108f
C53 a_1977_36# a_2325_171# 0.25568f
C54 a_645_36# VPWR 0.11347f
C55 a_393_36# a_1437_36# 0.00304f
C56 Q VGND 0.15357f
C57 a_2325_171# a_2193_36# 0.00158f
C58 VGND VPWR 0.15021f
C59 a_789_36# a_393_36# 0.25128f
C60 CLK VPB 0.09785f
C61 VGND a_1869_36# 0.01236f
C62 a_393_36# a_141_36# 1.24978f
C63 a_2193_450# VPWR 0.01954f
C64 SET_B a_2373_36# 0.00142f
C65 a_393_36# SET_B 0.18256f
C66 nmos_n3f5_f1_l150_0.D0 VPB 0.12483f
C67 a_393_36# a_645_36# 0.06208f
C68 a_141_36# CLK 0.09923f
C69 VGND a_2373_36# 0.01143f
C70 a_1005_450# VPWR 0.0225f
C71 a_1977_36# VPB 0.25526f
C72 a_393_36# VGND 0.64998f
C73 Q VPWR 0.22627f
C76 a_2193_450# a_393_36# 0.00194f
C78 a_393_36# a_1005_36# 0.00712f
C79 a_789_36# a_1977_36# 0.00188f
C81 a_1137_171# VPB 0.16003f
C82 VGND CLK 0.04537f
C83 VPB D 0.08736f
C84 a_141_36# a_1977_36# 0.16395f
C85 a_1137_171# a_1437_36# 0.00469f
C86 a_2325_171# VPB 0.10661f
C87 SET_B nmos_n3f5_f1_l150_0.D0 0.00143f
C88 a_1869_450# SET_B 0.00455f
C90 a_1977_36# SET_B 0.17513f
C91 a_789_36# a_1137_171# 0.31798f
C92 a_141_36# a_2193_36# 0.00422f
C93 a_393_36# VPWR 0.1838f
C94 VGND nmos_n3f5_f1_l150_0.D0 0.22602f
C95 a_141_36# a_1137_171# 0.10794f
C96 a_393_36# a_1869_36# 0.00323f
C97 a_141_36# D 0.05442f
C98 SET_B a_2193_36# 0.00169f
C100 a_1977_36# VGND 0.15768f
C101 a_141_36# a_2325_171# 0.04768f
C102 a_1137_171# SET_B 0.05571f
C104 CLK VPWR 0.04196f
C105 VGND a_2193_36# 0.01833f
C106 a_2193_450# a_1977_36# 0.01125f
C107 a_645_36# D 0.05765f
C108 a_2325_171# SET_B 0.12029f
C109 a_1137_171# VGND 0.14853f
C110 VGND D 0.04181f
C111 Q nmos_n3f5_f1_l150_0.D0 0.1198f
C112 a_2325_171# VGND 0.24504f
C113 nmos_n3f5_f1_l150_0.D0 VPWR 0.29706f
C114 a_1005_36# a_1137_171# 0.00182f
C116 Q VNB 0.03684f
C117 VGND VNB 2.19062f
C118 VPWR VNB 1.51109f
C119 SET_B VNB 0.23064f
C120 D VNB 0.12037f
C121 CLK VNB 0.19841f
C122 VPB VNB 4.10573f
C123 a_645_36# VNB 0.02229f
C124 nmos_n3f5_f1_l150_0.D0 VNB 0.26959f
C125 a_1977_36# VNB 0.34185f
C126 a_2325_171# VNB 0.15957f
C127 a_789_36# VNB 0.31694f
C128 a_1137_171# VNB 0.16766f
C129 a_393_36# VNB 0.42111f
C130 a_141_36# VNB 0.59311f
.ends

.subckt sky130_efx_lvdig__dfxbp_2 CLK D Q Q_N VGND VNB VPB VPWR
X0 VGND a_1736_165# a_1617_36# VNB sky130_fd_pr__nfet_01v8 ad=0.1134 pd=1.02 as=0.15593 ps=1.2 w=0.45 l=0.15
X1 a_1736_165# a_1401_36# VGND VNB sky130_fd_pr__nfet_01v8 ad=0.23625 pd=2.01 as=0.1134 ps=1.02 w=0.63 l=0.15
X2 a_969_450# a_141_36# a_753_36# VPB sky130_fd_pr__pfet_01v8_hvt ad=0.16875 pd=1.2 as=0.20925 ps=1.38 w=0.45 l=0.15
X3 VPWR a_1088_165# a_969_450# VPB sky130_fd_pr__pfet_01v8_hvt ad=0.12622 pd=1.11 as=0.16875 ps=1.2 w=0.45 l=0.15
X4 Q_N a_2517_36# VPWR VPB sky130_fd_pr__pfet_01v8_hvt ad=0.2106 pd=1.47 as=0.405 ps=2.91 w=1.08 l=0.15
X5 a_141_36# CLK VPWR VPB sky130_fd_pr__pfet_01v8_hvt ad=0.23625 pd=2.01 as=0.23625 ps=2.01 w=0.63 l=0.15
X6 a_645_36# D VGND VNB sky130_fd_pr__nfet_01v8 ad=0.08258 pd=0.84 as=0.16875 ps=1.65 w=0.45 l=0.15
X7 a_753_36# a_141_36# a_645_36# VNB sky130_fd_pr__special_nfet_01v8 ad=0.1674 pd=1.29 as=0.08258 ps=0.84 w=0.36 l=0.15
X8 Q_N a_2517_36# VGND VNB sky130_fd_pr__nfet_01v8 ad=0.12285 pd=1.02 as=0.23625 ps=2.01 w=0.63 l=0.15
X9 VGND a_2517_36# Q_N VNB sky130_fd_pr__nfet_01v8 ad=0.23625 pd=2.01 as=0.12285 ps=1.02 w=0.63 l=0.15
X10 VPWR a_2517_36# Q_N VPB sky130_fd_pr__pfet_01v8_hvt ad=0.405 pd=2.91 as=0.2106 ps=1.47 w=1.08 l=0.15
X11 a_1088_165# a_753_36# VPWR VPB sky130_fd_pr__pfet_01v8_hvt ad=0.16267 pd=1.29 as=0.12622 ps=1.11 w=0.72 l=0.15
X12 a_1736_165# a_1401_36# VPWR VPB sky130_fd_pr__pfet_01v8_hvt ad=0.405 pd=2.91 as=0.17752 ps=1.47 w=1.08 l=0.15
X13 a_2517_36# a_1736_165# VPWR VPB sky130_fd_pr__pfet_01v8_hvt ad=0.23625 pd=2.01 as=0.23625 ps=2.01 w=0.63 l=0.15
X14 a_1401_36# a_393_36# a_1088_165# VNB sky130_fd_pr__special_nfet_01v8 ad=0.1674 pd=1.29 as=0.13702 ps=1.2 w=0.36 l=0.15
X15 a_1401_36# a_141_36# a_1088_165# VPB sky130_fd_pr__pfet_01v8_hvt ad=0.20925 pd=1.38 as=0.16267 ps=1.29 w=0.45 l=0.15
X16 a_141_36# CLK VGND VNB sky130_fd_pr__nfet_01v8 ad=0.16875 pd=1.65 as=0.16875 ps=1.65 w=0.45 l=0.15
X17 Q a_1736_165# VGND VNB sky130_fd_pr__nfet_01v8 ad=0.12285 pd=1.02 as=0.23625 ps=2.01 w=0.63 l=0.15
X18 VGND a_1736_165# Q VNB sky130_fd_pr__nfet_01v8 ad=0.23625 pd=2.01 as=0.12285 ps=1.02 w=0.63 l=0.15
X19 a_393_36# a_141_36# VPWR VPB sky130_fd_pr__pfet_01v8_hvt ad=0.23625 pd=2.01 as=0.23625 ps=2.01 w=0.63 l=0.15
X20 a_969_36# a_393_36# a_753_36# VNB sky130_fd_pr__special_nfet_01v8 ad=0.15593 pd=1.2 as=0.1674 ps=1.29 w=0.36 l=0.15
X21 VGND a_1088_165# a_969_36# VNB sky130_fd_pr__nfet_01v8 ad=0.1134 pd=1.02 as=0.15593 ps=1.2 w=0.45 l=0.15
X22 a_1088_165# a_753_36# VGND VNB sky130_fd_pr__nfet_01v8 ad=0.13702 pd=1.2 as=0.1134 ps=1.02 w=0.63 l=0.15
X23 VPWR a_1736_165# a_1617_450# VPB sky130_fd_pr__pfet_01v8_hvt ad=0.17752 pd=1.47 as=0.16875 ps=1.2 w=0.45 l=0.15
X24 a_1617_450# a_393_36# a_1401_36# VPB sky130_fd_pr__pfet_01v8_hvt ad=0.16875 pd=1.2 as=0.20925 ps=1.38 w=0.45 l=0.15
X25 a_645_36# D VPWR VPB sky130_fd_pr__pfet_01v8_hvt ad=0.08775 pd=0.84 as=0.16875 ps=1.65 w=0.45 l=0.15
X26 Q a_1736_165# VPWR VPB sky130_fd_pr__pfet_01v8_hvt ad=0.2106 pd=1.47 as=0.405 ps=2.91 w=1.08 l=0.15
X27 a_753_36# a_393_36# a_645_36# VPB sky130_fd_pr__pfet_01v8_hvt ad=0.20925 pd=1.38 as=0.08775 ps=0.84 w=0.45 l=0.15
X28 a_393_36# a_141_36# VGND VNB sky130_fd_pr__nfet_01v8 ad=0.16875 pd=1.65 as=0.16875 ps=1.65 w=0.45 l=0.15
X29 a_2517_36# a_1736_165# VGND VNB sky130_fd_pr__nfet_01v8 ad=0.16875 pd=1.65 as=0.16875 ps=1.65 w=0.45 l=0.15
X30 VPWR a_1736_165# Q VPB sky130_fd_pr__pfet_01v8_hvt ad=0.405 pd=2.91 as=0.2106 ps=1.47 w=1.08 l=0.15
X31 a_1617_36# a_141_36# a_1401_36# VNB sky130_fd_pr__special_nfet_01v8 ad=0.15593 pd=1.2 as=0.1674 ps=1.29 w=0.36 l=0.15
C0 a_393_36# a_1088_165# 0.23777f
C1 a_1736_165# Q 0.13235f
C2 a_1736_165# a_393_36# 0.03107f
C3 a_1401_36# VPB 0.08098f
C4 VGND a_1088_165# 0.1446f
C5 a_1736_165# VGND 0.33199f
C6 a_969_450# a_141_36# 0.00743f
C7 a_753_36# a_969_36# 0.00965f
C8 D a_141_36# 0.07887f
C9 a_2517_36# Q 0.01307f
C11 VPB Q 0.00889f
C12 a_2517_36# VGND 0.21597f
C13 VPB a_393_36# 0.2897f
C14 a_645_36# VPB 0.02422f
C15 a_1401_36# a_1617_450# 0.01125f
C16 VPB VGND 0.04665f
C17 VPWR a_1088_165# 0.10157f
C18 a_645_36# a_753_36# 0.04498f
C19 a_753_36# a_393_36# 0.18653f
C20 a_1736_165# VPWR 0.32899f
C22 a_753_36# VGND 0.08895f
C23 a_969_36# a_393_36# 0.00712f
C24 a_1401_36# a_393_36# 0.13691f
C25 a_1617_450# a_393_36# 0.00381f
C26 a_969_36# VGND 0.01995f
C27 VPB CLK 0.09785f
C28 a_1401_36# VGND 0.09505f
C29 a_2517_36# VPWR 0.27185f
C30 a_1617_450# VGND 0.00122f
C31 VPB VPWR 0.66289f
C33 a_645_36# a_393_36# 0.07535f
C34 a_753_36# VPWR 0.11659f
C35 a_1617_36# a_1736_165# 0.00305f
C36 VGND Q 0.15357f
C37 VGND a_393_36# 0.44778f
C38 a_645_36# VGND 0.07973f
C39 a_1401_36# VPWR 0.12438f
C40 a_1617_450# VPWR 0.0225f
C42 a_141_36# a_1088_165# 0.09882f
C43 CLK VGND 0.04537f
C44 a_1736_165# a_141_36# 0.05641f
C45 VPWR Q 0.22627f
C46 VPWR a_393_36# 0.23676f
C47 a_645_36# VPWR 0.08042f
C48 VGND VPWR 0.19171f
C49 a_1401_36# a_1617_36# 0.00965f
C51 VPB a_141_36# 0.46609f
C52 D VPB 0.11625f
C54 a_753_36# a_969_450# 0.01125f
C55 CLK VPWR 0.04196f
C56 a_753_36# a_141_36# 0.21485f
C57 a_2517_36# Q_N 0.1198f
C58 a_1617_36# VGND 0.01995f
C59 a_1401_36# a_141_36# 0.16214f
C60 VPB Q_N 0.00808f
C62 a_141_36# a_393_36# 0.91413f
C63 a_645_36# a_141_36# 0.15126f
C64 D a_393_36# 0.09861f
C65 a_645_36# D 0.06045f
C66 VGND a_141_36# 0.31443f
C67 a_1617_36# VPWR 0.0012f
C68 D VGND 0.03533f
C69 CLK a_141_36# 0.09922f
C71 a_969_450# VPWR 0.0225f
C72 VGND Q_N 0.15357f
C73 VPWR a_141_36# 0.53956f
C74 D VPWR 0.03564f
C75 a_2517_36# a_1736_165# 0.06974f
C76 VPB a_1088_165# 0.11761f
C77 a_1736_165# VPB 0.38042f
C78 a_753_36# a_1088_165# 0.2195f
C79 a_969_36# a_1088_165# 0.00294f
C80 a_2517_36# VPB 0.1389f
C81 VPWR Q_N 0.22627f
C82 a_1401_36# a_1088_165# 0.04489f
C83 a_1401_36# a_1736_165# 0.22982f
C84 a_1617_36# a_141_36# 0.00331f
C85 a_753_36# VPB 0.10487f
C86 Q_N VNB 0.03639f
C87 Q VNB 0.01272f
C88 VGND VNB 1.91424f
C89 VPWR VNB 1.34543f
C90 D VNB 0.13204f
C91 CLK VNB 0.19841f
C92 VPB VNB 3.59251f
C93 a_645_36# VNB 0.02294f
C94 a_2517_36# VNB 0.27373f
C95 a_1401_36# VNB 0.12934f
C96 a_1736_165# VNB 0.56549f
C97 a_753_36# VNB 0.12466f
C98 a_1088_165# VNB 0.13891f
C99 a_393_36# VNB 0.38818f
C100 a_141_36# VNB 0.58182f
.ends

.subckt sky130_efx_lvdig__dfxtp_2 CLK D Q VGND VNB VPB VPWR
X0 VGND a_1736_165# a_1617_36# VNB sky130_fd_pr__nfet_01v8 ad=0.1134 pd=1.02 as=0.15593 ps=1.2 w=0.45 l=0.15
X1 a_1736_165# a_1401_36# VGND VNB sky130_fd_pr__nfet_01v8 ad=0.23625 pd=2.01 as=0.1134 ps=1.02 w=0.63 l=0.15
X2 a_969_450# a_141_36# a_753_36# VPB sky130_fd_pr__pfet_01v8_hvt ad=0.16875 pd=1.2 as=0.20925 ps=1.38 w=0.45 l=0.15
X3 VPWR a_1088_165# a_969_450# VPB sky130_fd_pr__pfet_01v8_hvt ad=0.12622 pd=1.11 as=0.16875 ps=1.2 w=0.45 l=0.15
X4 a_141_36# CLK VPWR VPB sky130_fd_pr__pfet_01v8_hvt ad=0.23625 pd=2.01 as=0.23625 ps=2.01 w=0.63 l=0.15
X5 a_645_36# D VGND VNB sky130_fd_pr__nfet_01v8 ad=0.08258 pd=0.84 as=0.16875 ps=1.65 w=0.45 l=0.15
X6 a_753_36# a_141_36# a_645_36# VNB sky130_fd_pr__special_nfet_01v8 ad=0.1674 pd=1.29 as=0.08258 ps=0.84 w=0.36 l=0.15
X7 a_1088_165# a_753_36# VPWR VPB sky130_fd_pr__pfet_01v8_hvt ad=0.16267 pd=1.29 as=0.12622 ps=1.11 w=0.72 l=0.15
X8 a_1736_165# a_1401_36# VPWR VPB sky130_fd_pr__pfet_01v8_hvt ad=0.405 pd=2.91 as=0.17752 ps=1.47 w=1.08 l=0.15
X9 a_1401_36# a_393_36# a_1088_165# VNB sky130_fd_pr__special_nfet_01v8 ad=0.1674 pd=1.29 as=0.13702 ps=1.2 w=0.36 l=0.15
X10 a_1401_36# a_141_36# a_1088_165# VPB sky130_fd_pr__pfet_01v8_hvt ad=0.20925 pd=1.38 as=0.16267 ps=1.29 w=0.45 l=0.15
X11 a_141_36# CLK VGND VNB sky130_fd_pr__nfet_01v8 ad=0.16875 pd=1.65 as=0.16875 ps=1.65 w=0.45 l=0.15
X12 Q a_1736_165# VGND VNB sky130_fd_pr__nfet_01v8 ad=0.12285 pd=1.02 as=0.23625 ps=2.01 w=0.63 l=0.15
X13 VGND a_1736_165# Q VNB sky130_fd_pr__nfet_01v8 ad=0.23625 pd=2.01 as=0.12285 ps=1.02 w=0.63 l=0.15
X14 a_393_36# a_141_36# VPWR VPB sky130_fd_pr__pfet_01v8_hvt ad=0.23625 pd=2.01 as=0.23625 ps=2.01 w=0.63 l=0.15
X15 a_969_36# a_393_36# a_753_36# VNB sky130_fd_pr__special_nfet_01v8 ad=0.15593 pd=1.2 as=0.1674 ps=1.29 w=0.36 l=0.15
X16 VGND a_1088_165# a_969_36# VNB sky130_fd_pr__nfet_01v8 ad=0.1134 pd=1.02 as=0.15593 ps=1.2 w=0.45 l=0.15
X17 a_1088_165# a_753_36# VGND VNB sky130_fd_pr__nfet_01v8 ad=0.13702 pd=1.2 as=0.1134 ps=1.02 w=0.63 l=0.15
X18 VPWR a_1736_165# a_1617_450# VPB sky130_fd_pr__pfet_01v8_hvt ad=0.17752 pd=1.47 as=0.16875 ps=1.2 w=0.45 l=0.15
X19 a_1617_450# a_393_36# a_1401_36# VPB sky130_fd_pr__pfet_01v8_hvt ad=0.16875 pd=1.2 as=0.20925 ps=1.38 w=0.45 l=0.15
X20 a_645_36# D VPWR VPB sky130_fd_pr__pfet_01v8_hvt ad=0.08775 pd=0.84 as=0.16875 ps=1.65 w=0.45 l=0.15
X21 Q a_1736_165# VPWR VPB sky130_fd_pr__pfet_01v8_hvt ad=0.2106 pd=1.47 as=0.405 ps=2.91 w=1.08 l=0.15
X22 a_753_36# a_393_36# a_645_36# VPB sky130_fd_pr__pfet_01v8_hvt ad=0.20925 pd=1.38 as=0.08775 ps=0.84 w=0.45 l=0.15
X23 a_393_36# a_141_36# VGND VNB sky130_fd_pr__nfet_01v8 ad=0.16875 pd=1.65 as=0.16875 ps=1.65 w=0.45 l=0.15
X24 VPWR a_1736_165# Q VPB sky130_fd_pr__pfet_01v8_hvt ad=0.405 pd=2.91 as=0.2106 ps=1.47 w=1.08 l=0.15
X25 a_1617_36# a_141_36# a_1401_36# VNB sky130_fd_pr__special_nfet_01v8 ad=0.15593 pd=1.2 as=0.1674 ps=1.29 w=0.36 l=0.15
C0 a_393_36# a_1088_165# 0.23777f
C1 VPB a_1736_165# 0.23171f
C2 a_969_36# a_1088_165# 0.00294f
C3 VPWR VPB 0.49683f
C4 a_645_36# a_393_36# 0.07535f
C5 a_969_450# VPWR 0.0225f
C6 a_1401_36# a_1088_165# 0.04489f
C7 a_1617_36# a_141_36# 0.00331f
C8 a_753_36# VPB 0.10487f
C9 a_969_450# a_753_36# 0.01125f
C11 a_1617_450# a_393_36# 0.00381f
C12 D a_141_36# 0.07887f
C13 a_1736_165# a_393_36# 0.03099f
C14 VGND a_1088_165# 0.1446f
C15 VPWR a_393_36# 0.23665f
C16 a_1617_450# a_1401_36# 0.01125f
C17 a_645_36# VGND 0.07973f
C18 a_1401_36# a_1736_165# 0.22982f
C19 VPWR a_1401_36# 0.12438f
C20 a_753_36# a_393_36# 0.18653f
C21 a_969_36# a_753_36# 0.00965f
C22 a_1617_450# VGND 0.00122f
C23 VPB a_393_36# 0.28897f
C24 VGND a_1736_165# 0.28008f
C25 VPWR VGND 0.10833f
C26 VPB a_1401_36# 0.08098f
C27 a_753_36# VGND 0.08895f
C28 a_969_36# a_393_36# 0.00712f
C29 VPB VGND 0.02729f
C30 a_1401_36# a_393_36# 0.13691f
C31 VGND a_393_36# 0.44778f
C32 a_969_36# VGND 0.01995f
C33 CLK VPWR 0.04196f
C34 a_141_36# a_1088_165# 0.09882f
C35 VGND a_1401_36# 0.09505f
C36 a_645_36# a_141_36# 0.15126f
C37 a_645_36# D 0.06045f
C38 CLK VPB 0.09785f
C39 a_1617_36# a_1736_165# 0.00305f
C40 VPWR a_1617_36# 0.0012f
C41 a_1736_165# a_141_36# 0.05557f
C42 Q a_1736_165# 0.12039f
C43 VPWR a_141_36# 0.53956f
C44 Q VPWR 0.22627f
C45 VPWR D 0.03564f
C46 a_753_36# a_141_36# 0.21485f
C48 VPB a_141_36# 0.46569f
C49 Q VPB 0.00762f
C50 a_969_450# a_141_36# 0.00743f
C51 D VPB 0.11625f
C52 CLK VGND 0.04537f
C53 a_141_36# a_393_36# 0.91413f
C55 a_1617_36# a_1401_36# 0.00965f
C56 a_1401_36# a_141_36# 0.16214f
C57 D a_393_36# 0.09861f
C58 VGND a_1617_36# 0.01995f
C59 VGND a_141_36# 0.31438f
C60 Q VGND 0.15357f
C61 D VGND 0.03533f
C62 VPWR a_1088_165# 0.10157f
C63 a_645_36# VPWR 0.08042f
C64 a_753_36# a_1088_165# 0.2195f
C65 a_753_36# a_645_36# 0.04498f
C66 VPB a_1088_165# 0.11761f
C67 a_1617_450# VPWR 0.0225f
C68 a_645_36# VPB 0.02422f
C69 VPWR a_1736_165# 0.27472f
C70 CLK a_141_36# 0.09922f
C71 a_753_36# VPWR 0.11659f
C72 Q VNB 0.03684f
C73 VGND VNB 1.52171f
C74 VPWR VNB 1.09452f
C75 D VNB 0.13204f
C76 CLK VNB 0.19841f
C77 VPB VNB 2.82269f
C78 a_645_36# VNB 0.02294f
C79 a_1401_36# VNB 0.12934f
C80 a_1736_165# VNB 0.39235f
C81 a_753_36# VNB 0.12466f
C82 a_1088_165# VNB 0.13891f
C83 a_393_36# VNB 0.38979f
C84 a_141_36# VNB 0.58502f
.ends

.subckt sky130_efx_lvdig__dlygate4sd3_1 A X VGND VNB VPB VPWR
X0 X a_788_36# VGND VNB sky130_fd_pr__nfet_01v8 ad=0.23625 pd=2.01 as=0.23625 ps=2.01 w=0.63 l=0.15
X1 a_464_36# a_141_36# VPWR VPB sky130_fd_pr__pfet_01v8_hvt ad=0.171 pd=1.66 as=0.171 ps=1.66 w=0.45 l=0.5
X2 a_788_36# a_464_36# VGND VNB sky130_fd_pr__nfet_01v8 ad=0.171 pd=1.66 as=0.171 ps=1.66 w=0.45 l=0.5
X3 a_788_36# a_464_36# VPWR VPB sky130_fd_pr__pfet_01v8_hvt ad=0.171 pd=1.66 as=0.171 ps=1.66 w=0.45 l=0.5
X4 a_141_36# A VPWR VPB sky130_fd_pr__pfet_01v8_hvt ad=0.16875 pd=1.65 as=0.16875 ps=1.65 w=0.45 l=0.15
X5 X a_788_36# VPWR VPB sky130_fd_pr__pfet_01v8_hvt ad=0.405 pd=2.91 as=0.405 ps=2.91 w=1.08 l=0.15
X6 a_141_36# A VGND VNB sky130_fd_pr__nfet_01v8 ad=0.16875 pd=1.65 as=0.16875 ps=1.65 w=0.45 l=0.15
X7 a_464_36# a_141_36# VGND VNB sky130_fd_pr__nfet_01v8 ad=0.171 pd=1.66 as=0.171 ps=1.66 w=0.45 l=0.5
C0 a_464_36# a_788_36# 0.13523f
C1 VPB A 0.11464f
C2 VPB a_464_36# 0.21799f
C3 VPWR a_788_36# 0.19608f
C4 VGND a_141_36# 0.21139f
C5 VPB VPWR 0.26331f
C6 X a_788_36# 0.07073f
C7 VPB X 0.01018f
C8 VPWR A 0.03739f
C9 VPWR a_464_36# 0.18366f
C10 VGND a_788_36# 0.16497f
C11 VPB a_141_36# 0.21435f
C12 X a_464_36# 0.00104f
C13 VGND VPB 0.02434f
C14 X VPWR 0.13857f
C15 a_141_36# A 0.1005f
C16 a_141_36# a_464_36# 0.14675f
C17 VGND A 0.04538f
C18 VGND a_464_36# 0.19303f
C19 VPWR a_141_36# 0.20077f
C20 VPB a_788_36# 0.09327f
C21 VGND VPWR 0.11363f
C22 VGND X 0.10221f
C23 VGND VNB 0.79796f
C24 X VNB 0.1112f
C25 VPWR VNB 0.57068f
C26 A VNB 0.2029f
C27 VPB VNB 1.36858f
C28 a_788_36# VNB 0.18678f
C29 a_464_36# VNB 0.25839f
C30 a_141_36# VNB 0.28533f
.ends

.subckt sky130_efx_lvdig__edfxbp_1 CLK D DE Q Q_N VGND VNB VPB VPWR
X0 a_936_288# a_2697_36# VGND VNB sky130_fd_pr__nfet_01v8 ad=0.16875 pd=1.65 as=0.16875 ps=1.65 w=0.45 l=0.15
X1 a_249_36# D a_144_36# VNB sky130_fd_pr__nfet_01v8 ad=0.08775 pd=0.84 as=0.16875 ps=1.65 w=0.45 l=0.15
X2 VGND DE a_249_36# VNB sky130_fd_pr__nfet_01v8 ad=0.16875 pd=1.65 as=0.08775 ps=0.84 w=0.45 l=0.15
X3 a_2697_36# a_1509_36# a_2553_36# VNB sky130_fd_pr__special_nfet_01v8 ad=0.1674 pd=1.29 as=0.11542 ps=1.02 w=0.36 l=0.15
X4 a_2913_36# a_1257_36# a_2697_36# VNB sky130_fd_pr__special_nfet_01v8 ad=0.15593 pd=1.2 as=0.1674 ps=1.29 w=0.36 l=0.15
X5 Q_N a_936_288# VPWR VPB sky130_fd_pr__pfet_01v8_hvt ad=0.405 pd=2.91 as=0.405 ps=2.91 w=1.08 l=0.15
X6 a_861_36# a_324_288# VGND VNB sky130_fd_pr__nfet_01v8 ad=0.08775 pd=0.84 as=0.16875 ps=1.65 w=0.45 l=0.15
X7 a_1977_36# a_1509_36# a_1761_36# VNB sky130_fd_pr__special_nfet_01v8 ad=0.15593 pd=1.2 as=0.1674 ps=1.29 w=0.36 l=0.15
X8 a_1509_36# a_1257_36# VPWR VPB sky130_fd_pr__pfet_01v8_hvt ad=0.23625 pd=2.01 as=0.23625 ps=2.01 w=0.63 l=0.15
X9 VPWR a_2096_165# a_1977_450# VPB sky130_fd_pr__pfet_01v8_hvt ad=0.12622 pd=1.11 as=0.16875 ps=1.2 w=0.45 l=0.15
X10 Q_N a_936_288# VGND VNB sky130_fd_pr__nfet_01v8 ad=0.23625 pd=2.01 as=0.23625 ps=2.01 w=0.63 l=0.15
X11 a_249_414# D a_144_36# VPB sky130_fd_pr__pfet_01v8_hvt ad=0.12285 pd=1.02 as=0.23625 ps=2.01 w=0.63 l=0.15
X12 a_2553_450# a_2096_165# VPWR VPB sky130_fd_pr__pfet_01v8_hvt ad=0.12825 pd=1.02 as=0.16875 ps=1.65 w=0.45 l=0.15
X13 VGND DE a_324_288# VNB sky130_fd_pr__nfet_01v8 ad=0.16875 pd=1.65 as=0.16875 ps=1.65 w=0.45 l=0.15
X14 VPWR a_324_288# a_249_414# VPB sky130_fd_pr__pfet_01v8_hvt ad=0.23625 pd=2.01 as=0.12285 ps=1.02 w=0.63 l=0.15
X15 a_1761_36# a_1509_36# a_144_36# VPB sky130_fd_pr__pfet_01v8_hvt ad=0.20925 pd=1.38 as=0.16875 ps=1.65 w=0.45 l=0.15
X16 a_936_288# a_2697_36# VPWR VPB sky130_fd_pr__pfet_01v8_hvt ad=0.23625 pd=2.01 as=0.23625 ps=2.01 w=0.63 l=0.15
X17 VGND a_936_288# a_2913_36# VNB sky130_fd_pr__nfet_01v8 ad=0.16875 pd=1.65 as=0.15593 ps=1.2 w=0.45 l=0.15
X18 a_2096_165# a_1761_36# VPWR VPB sky130_fd_pr__pfet_01v8_hvt ad=0.3996 pd=2.55 as=0.12622 ps=1.11 w=0.72 l=0.15
X19 a_861_414# DE VPWR VPB sky130_fd_pr__pfet_01v8_hvt ad=0.12285 pd=1.02 as=0.23625 ps=2.01 w=0.63 l=0.15
X20 VPWR a_936_288# a_2913_450# VPB sky130_fd_pr__pfet_01v8_hvt ad=0.16875 pd=1.65 as=0.16875 ps=1.2 w=0.45 l=0.15
X21 VGND a_2096_165# a_1977_36# VNB sky130_fd_pr__nfet_01v8 ad=0.1134 pd=1.02 as=0.15593 ps=1.2 w=0.45 l=0.15
X22 a_2096_165# a_1761_36# VGND VNB sky130_fd_pr__nfet_01v8 ad=0.34965 pd=2.37 as=0.1134 ps=1.02 w=0.63 l=0.15
X23 a_1977_450# a_1257_36# a_1761_36# VPB sky130_fd_pr__pfet_01v8_hvt ad=0.16875 pd=1.2 as=0.20925 ps=1.38 w=0.45 l=0.15
X24 a_144_36# a_936_288# a_861_36# VNB sky130_fd_pr__nfet_01v8 ad=0.16875 pd=1.65 as=0.08775 ps=0.84 w=0.45 l=0.15
X25 a_1257_36# CLK VGND VNB sky130_fd_pr__nfet_01v8 ad=0.16875 pd=1.65 as=0.16875 ps=1.65 w=0.45 l=0.15
X26 Q a_2697_36# VGND VNB sky130_fd_pr__nfet_01v8 ad=0.23625 pd=2.01 as=0.23625 ps=2.01 w=0.63 l=0.15
X27 a_144_36# a_936_288# a_861_414# VPB sky130_fd_pr__pfet_01v8_hvt ad=0.23625 pd=2.01 as=0.12285 ps=1.02 w=0.63 l=0.15
X28 a_2553_36# a_2096_165# VGND VNB sky130_fd_pr__nfet_01v8 ad=0.11542 pd=1.02 as=0.16875 ps=1.65 w=0.45 l=0.15
X29 a_2697_36# a_1257_36# a_2553_450# VPB sky130_fd_pr__pfet_01v8_hvt ad=0.20925 pd=1.38 as=0.12825 ps=1.02 w=0.45 l=0.15
X30 a_1761_36# a_1257_36# a_144_36# VNB sky130_fd_pr__special_nfet_01v8 ad=0.1674 pd=1.29 as=0.135 ps=1.47 w=0.36 l=0.15
X31 a_1257_36# CLK VPWR VPB sky130_fd_pr__pfet_01v8_hvt ad=0.23625 pd=2.01 as=0.23625 ps=2.01 w=0.63 l=0.15
X32 VPWR DE a_324_288# VPB sky130_fd_pr__pfet_01v8_hvt ad=0.23625 pd=2.01 as=0.23625 ps=2.01 w=0.63 l=0.15
X33 Q a_2697_36# VPWR VPB sky130_fd_pr__pfet_01v8_hvt ad=0.405 pd=2.91 as=0.405 ps=2.91 w=1.08 l=0.15
X34 a_2913_450# a_1509_36# a_2697_36# VPB sky130_fd_pr__pfet_01v8_hvt ad=0.16875 pd=1.2 as=0.20925 ps=1.38 w=0.45 l=0.15
X35 a_1509_36# a_1257_36# VGND VNB sky130_fd_pr__nfet_01v8 ad=0.16875 pd=1.65 as=0.16875 ps=1.65 w=0.45 l=0.15
C0 a_144_36# VPB 0.13243f
C1 a_1509_36# VPB 0.31027f
C2 a_2697_36# a_2913_450# 0.00773f
C6 a_936_288# a_1977_450# 0.00876f
C7 DE a_324_288# 0.26955f
C8 a_2697_36# a_2913_36# 0.0111f
C9 VPWR a_1761_36# 0.10756f
C10 a_324_288# VPB 0.15411f
C11 a_2697_36# a_1257_36# 0.16334f
C12 DE a_1257_36# 0.00177f
C13 a_2697_36# VGND 0.19932f
C14 a_1761_36# a_1977_36# 0.00965f
C16 VPWR D 0.02183f
C17 a_144_36# a_249_36# 0.00958f
C18 DE VGND 0.05794f
C19 a_1257_36# VPB 0.46213f
C20 VGND VPB 0.04115f
C21 a_1761_36# a_1977_450# 0.01125f
C23 a_249_414# VPWR 0.01672f
C24 a_861_414# VPWR 0.01047f
C25 a_936_288# a_1761_36# 0.05033f
C29 Q_N VPB 0.01018f
C30 a_936_288# a_861_36# 0.00184f
C32 a_1509_36# a_2553_36# 0.00413f
C34 VPWR a_2697_36# 0.17664f
C35 VPWR DE 0.10418f
C36 VGND a_249_36# 0.01023f
C37 VPWR VPB 0.82238f
C39 a_936_288# a_861_414# 0.01122f
C40 VPWR a_2553_450# 0.01533f
C41 a_144_36# CLK 0.04734f
C44 a_1509_36# a_2096_165# 0.19905f
C45 a_144_36# a_1509_36# 0.30067f
C46 Q a_1257_36# 0.00348f
C47 a_936_288# a_2697_36# 0.23938f
C48 VGND a_2553_36# 0.01602f
C49 Q VGND 0.12234f
C50 a_936_288# DE 0.05327f
C51 a_936_288# VPB 0.43177f
C53 a_1509_36# a_2913_450# 0.00194f
C54 a_936_288# a_2553_450# 0.00666f
C55 a_144_36# a_324_288# 0.11492f
C56 CLK a_1257_36# 0.09905f
C59 CLK VGND 0.03978f
C60 a_1257_36# a_2096_165# 0.1444f
C61 VGND a_2096_165# 0.21283f
C62 a_144_36# a_1257_36# 0.26704f
C63 a_1509_36# a_1257_36# 1.09117f
C64 a_144_36# VGND 1.36087f
C65 a_1509_36# VGND 0.41384f
C66 a_1761_36# VPB 0.1135f
C68 VPWR Q 0.15781f
C69 DE D 0.02996f
C70 D VPB 0.09247f
C72 a_324_288# VGND 0.20484f
C73 a_1257_36# a_2913_36# 0.00331f
C75 VPWR CLK 0.03739f
C76 VGND a_2913_36# 0.02103f
C77 VPWR a_2096_165# 0.15219f
C78 a_1257_36# VGND 0.26305f
C79 a_936_288# Q 0.07807f
C80 a_144_36# VPWR 0.38882f
C81 VPWR a_1509_36# 0.13399f
C82 a_2096_165# a_1977_36# 0.00294f
C83 a_144_36# a_1977_36# 0.00159f
C84 a_2697_36# VPB 0.23403f
C85 a_1509_36# a_1977_36# 0.00712f
C86 DE VPB 0.23954f
C87 VPWR a_2913_450# 0.01687f
C88 a_2697_36# a_2553_450# 0.0037f
C89 a_936_288# CLK 0.03532f
C91 a_936_288# a_2096_165# 0.05601f
C92 VPWR a_324_288# 0.21529f
C93 Q_N VGND 0.10221f
C94 a_936_288# a_144_36# 0.25946f
C95 a_936_288# a_1509_36# 0.24867f
C96 VPWR a_1257_36# 0.22074f
C97 VPWR VGND 0.07322f
C98 a_936_288# a_2913_450# 0.01451f
C99 VGND a_1977_36# 0.01995f
C100 a_2096_165# a_1761_36# 0.24064f
C101 a_936_288# a_324_288# 0.04645f
C102 a_1257_36# a_1977_450# 0.00194f
C103 a_936_288# a_2913_36# 0.00166f
C104 a_144_36# a_1761_36# 0.04862f
C105 a_1509_36# a_1761_36# 0.16151f
C106 Q_N VPWR 0.13857f
C107 a_936_288# a_1257_36# 0.56753f
C108 a_144_36# a_861_36# 0.00958f
C109 a_144_36# D 0.07622f
C110 a_936_288# VGND 0.30367f
C112 a_2697_36# a_2553_36# 0.00322f
C113 a_2697_36# Q 0.0949f
C114 Q VPB 0.02034f
C115 a_249_414# a_144_36# 0.00844f
C116 a_144_36# a_861_414# 0.0044f
C118 a_324_288# D 0.04295f
C119 a_936_288# Q_N 0.07201f
C120 a_1257_36# a_1761_36# 0.1829f
C121 a_2697_36# a_2096_165# 0.00517f
C122 VGND a_1761_36# 0.09007f
C123 VPWR a_1977_450# 0.01954f
C124 CLK VPB 0.10634f
C127 a_2697_36# a_1509_36# 0.12554f
C128 a_2096_165# VPB 0.24528f
C129 VGND D 0.01622f
C130 a_936_288# VPWR 1.88459f
C131 a_144_36# DE 0.03773f
C132 VGND a_861_36# 0.00929f
C135 Q_N VNB 0.1112f
C136 Q VNB 0.01963f
C137 VGND VNB 2.41959f
C138 VPWR VNB 1.65955f
C139 CLK VNB 0.15114f
C140 DE VNB 0.35579f
C141 D VNB 0.17704f
C142 VPB VNB 4.70448f
C143 a_144_36# VNB 0.27525f
C144 a_2697_36# VNB 0.36018f
C145 a_1761_36# VNB 0.13301f
C146 a_2096_165# VNB 0.28484f
C147 a_1509_36# VNB 0.40491f
C148 a_1257_36# VNB 0.57249f
C149 a_936_288# VNB 0.46168f
C150 a_324_288# VNB 0.19908f
.ends

.subckt sky130_efx_lvdig__edfxtp_1 CLK D DE Q VGND VNB VPB VPWR
X0 a_936_288# a_2697_36# VGND VNB sky130_fd_pr__nfet_01v8 ad=0.16875 pd=1.65 as=0.16875 ps=1.65 w=0.45 l=0.15
X1 a_249_36# D a_144_36# VNB sky130_fd_pr__nfet_01v8 ad=0.08775 pd=0.84 as=0.16875 ps=1.65 w=0.45 l=0.15
X2 VGND DE a_249_36# VNB sky130_fd_pr__nfet_01v8 ad=0.16875 pd=1.65 as=0.08775 ps=0.84 w=0.45 l=0.15
X3 a_2697_36# a_1509_36# a_2553_36# VNB sky130_fd_pr__special_nfet_01v8 ad=0.1674 pd=1.29 as=0.11542 ps=1.02 w=0.36 l=0.15
X4 a_2913_36# a_1257_36# a_2697_36# VNB sky130_fd_pr__special_nfet_01v8 ad=0.15593 pd=1.2 as=0.1674 ps=1.29 w=0.36 l=0.15
X5 a_861_36# a_324_288# VGND VNB sky130_fd_pr__nfet_01v8 ad=0.08775 pd=0.84 as=0.16875 ps=1.65 w=0.45 l=0.15
X6 a_1977_36# a_1509_36# a_1761_36# VNB sky130_fd_pr__special_nfet_01v8 ad=0.15593 pd=1.2 as=0.1674 ps=1.29 w=0.36 l=0.15
X7 a_1509_36# a_1257_36# VPWR VPB sky130_fd_pr__pfet_01v8_hvt ad=0.23625 pd=2.01 as=0.23625 ps=2.01 w=0.63 l=0.15
X8 VPWR a_2096_165# a_1977_450# VPB sky130_fd_pr__pfet_01v8_hvt ad=0.12622 pd=1.11 as=0.16875 ps=1.2 w=0.45 l=0.15
X9 a_249_414# D a_144_36# VPB sky130_fd_pr__pfet_01v8_hvt ad=0.12285 pd=1.02 as=0.23625 ps=2.01 w=0.63 l=0.15
X10 a_2553_450# a_2096_165# VPWR VPB sky130_fd_pr__pfet_01v8_hvt ad=0.12825 pd=1.02 as=0.16875 ps=1.65 w=0.45 l=0.15
X11 VGND DE a_324_288# VNB sky130_fd_pr__nfet_01v8 ad=0.16875 pd=1.65 as=0.16875 ps=1.65 w=0.45 l=0.15
X12 VPWR a_324_288# a_249_414# VPB sky130_fd_pr__pfet_01v8_hvt ad=0.23625 pd=2.01 as=0.12285 ps=1.02 w=0.63 l=0.15
X13 a_1761_36# a_1509_36# a_144_36# VPB sky130_fd_pr__pfet_01v8_hvt ad=0.20925 pd=1.38 as=0.16875 ps=1.65 w=0.45 l=0.15
X14 a_936_288# a_2697_36# VPWR VPB sky130_fd_pr__pfet_01v8_hvt ad=0.23625 pd=2.01 as=0.23625 ps=2.01 w=0.63 l=0.15
X15 VGND a_936_288# a_2913_36# VNB sky130_fd_pr__nfet_01v8 ad=0.16875 pd=1.65 as=0.15593 ps=1.2 w=0.45 l=0.15
X16 a_2096_165# a_1761_36# VPWR VPB sky130_fd_pr__pfet_01v8_hvt ad=0.3996 pd=2.55 as=0.12622 ps=1.11 w=0.72 l=0.15
X17 a_861_414# DE VPWR VPB sky130_fd_pr__pfet_01v8_hvt ad=0.12285 pd=1.02 as=0.23625 ps=2.01 w=0.63 l=0.15
X18 VPWR a_936_288# a_2913_450# VPB sky130_fd_pr__pfet_01v8_hvt ad=0.16875 pd=1.65 as=0.16875 ps=1.2 w=0.45 l=0.15
X19 VGND a_2096_165# a_1977_36# VNB sky130_fd_pr__nfet_01v8 ad=0.1134 pd=1.02 as=0.15593 ps=1.2 w=0.45 l=0.15
X20 a_2096_165# a_1761_36# VGND VNB sky130_fd_pr__nfet_01v8 ad=0.34965 pd=2.37 as=0.1134 ps=1.02 w=0.63 l=0.15
X21 a_1977_450# a_1257_36# a_1761_36# VPB sky130_fd_pr__pfet_01v8_hvt ad=0.16875 pd=1.2 as=0.20925 ps=1.38 w=0.45 l=0.15
X22 a_144_36# a_936_288# a_861_36# VNB sky130_fd_pr__nfet_01v8 ad=0.16875 pd=1.65 as=0.08775 ps=0.84 w=0.45 l=0.15
X23 a_1257_36# CLK VGND VNB sky130_fd_pr__nfet_01v8 ad=0.16875 pd=1.65 as=0.16875 ps=1.65 w=0.45 l=0.15
X24 Q a_2697_36# VGND VNB sky130_fd_pr__nfet_01v8 ad=0.23625 pd=2.01 as=0.23625 ps=2.01 w=0.63 l=0.15
X25 a_144_36# a_936_288# a_861_414# VPB sky130_fd_pr__pfet_01v8_hvt ad=0.23625 pd=2.01 as=0.12285 ps=1.02 w=0.63 l=0.15
X26 a_2553_36# a_2096_165# VGND VNB sky130_fd_pr__nfet_01v8 ad=0.11542 pd=1.02 as=0.16875 ps=1.65 w=0.45 l=0.15
X27 a_2697_36# a_1257_36# a_2553_450# VPB sky130_fd_pr__pfet_01v8_hvt ad=0.20925 pd=1.38 as=0.12825 ps=1.02 w=0.45 l=0.15
X28 a_1761_36# a_1257_36# a_144_36# VNB sky130_fd_pr__special_nfet_01v8 ad=0.1674 pd=1.29 as=0.135 ps=1.47 w=0.36 l=0.15
X29 a_1257_36# CLK VPWR VPB sky130_fd_pr__pfet_01v8_hvt ad=0.23625 pd=2.01 as=0.23625 ps=2.01 w=0.63 l=0.15
X30 VPWR DE a_324_288# VPB sky130_fd_pr__pfet_01v8_hvt ad=0.23625 pd=2.01 as=0.23625 ps=2.01 w=0.63 l=0.15
X31 Q a_2697_36# VPWR VPB sky130_fd_pr__pfet_01v8_hvt ad=0.405 pd=2.91 as=0.405 ps=2.91 w=1.08 l=0.15
X32 a_2913_450# a_1509_36# a_2697_36# VPB sky130_fd_pr__pfet_01v8_hvt ad=0.16875 pd=1.2 as=0.20925 ps=1.38 w=0.45 l=0.15
X33 a_1509_36# a_1257_36# VGND VNB sky130_fd_pr__nfet_01v8 ad=0.16875 pd=1.65 as=0.16875 ps=1.65 w=0.45 l=0.15
C0 a_144_36# a_249_36# 0.00958f
C1 a_144_36# a_936_288# 0.25946f
C2 VGND VPB 0.04035f
C3 CLK a_936_288# 0.03532f
C5 VGND a_2697_36# 0.1978f
C7 a_144_36# a_1509_36# 0.30067f
C8 a_324_288# VPWR 0.21529f
C9 a_936_288# a_2913_450# 0.01451f
C11 a_2697_36# a_2553_36# 0.00322f
C12 VGND DE 0.05794f
C13 VGND a_1977_36# 0.01995f
C15 a_1509_36# a_2913_450# 0.00194f
C16 a_2697_36# a_2553_450# 0.0037f
C17 a_1257_36# VPB 0.46208f
C19 a_1257_36# a_2697_36# 0.16334f
C20 a_936_288# a_861_36# 0.00184f
C21 a_1257_36# DE 0.00177f
C22 a_324_288# a_936_288# 0.04645f
C23 VGND a_144_36# 1.36087f
C24 VGND CLK 0.03978f
C25 VPB a_2697_36# 0.22689f
C27 VPWR a_1761_36# 0.10756f
C28 VGND D 0.01622f
C30 a_1257_36# a_1977_450# 0.00194f
C31 a_249_414# VPWR 0.01672f
C32 VPWR a_2096_165# 0.15219f
C33 DE VPB 0.23954f
C34 a_936_288# a_2913_36# 0.00166f
C35 a_2096_165# a_1761_36# 0.24064f
C37 a_1257_36# a_144_36# 0.26704f
C38 a_1257_36# CLK 0.09905f
C39 VPWR a_936_288# 1.7537f
C41 a_936_288# a_1761_36# 0.05033f
C42 VGND a_861_36# 0.00929f
C43 a_324_288# VGND 0.20484f
C45 VPWR a_1509_36# 0.13388f
C46 a_936_288# a_2096_165# 0.05601f
C47 a_144_36# VPB 0.13243f
C48 VPWR Q 0.15781f
C49 a_1509_36# a_1761_36# 0.16151f
C50 CLK VPB 0.10634f
C52 VPB D 0.09247f
C53 a_2096_165# a_1509_36# 0.19905f
C54 a_144_36# DE 0.03773f
C55 a_144_36# a_1977_36# 0.00159f
C56 VGND a_2913_36# 0.02103f
C57 a_2697_36# a_2913_450# 0.00773f
C58 DE D 0.02996f
C60 a_861_414# a_144_36# 0.0044f
C61 a_936_288# a_1509_36# 0.2486f
C62 a_936_288# Q 0.07807f
C63 VGND VPWR 0.05335f
C64 VGND a_1761_36# 0.09007f
C65 a_1257_36# a_2913_36# 0.00331f
C67 a_324_288# VPB 0.15411f
C70 VGND a_2096_165# 0.21283f
C71 CLK a_144_36# 0.04734f
C72 VPWR a_2553_450# 0.01533f
C73 a_144_36# D 0.07622f
C75 a_324_288# DE 0.26955f
C76 VGND a_249_36# 0.01023f
C77 a_1257_36# VPWR 0.22074f
C79 a_1257_36# a_1761_36# 0.1829f
C80 VGND a_936_288# 0.20733f
C81 a_2913_36# a_2697_36# 0.0111f
C82 a_1257_36# a_2096_165# 0.1444f
C83 VGND a_1509_36# 0.41384f
C84 VGND Q 0.12234f
C85 VPWR VPB 0.77303f
C86 a_144_36# a_861_36# 0.00958f
C87 a_936_288# a_2553_450# 0.00666f
C88 a_1509_36# a_2553_36# 0.00413f
C89 VPB a_1761_36# 0.1135f
C90 VPWR a_2697_36# 0.17437f
C91 a_324_288# a_144_36# 0.11492f
C92 a_2096_165# VPB 0.24528f
C93 a_1257_36# a_936_288# 0.56717f
C95 VPWR DE 0.10418f
C96 a_324_288# D 0.04295f
C97 a_2096_165# a_2697_36# 0.00517f
C98 a_1977_36# a_1761_36# 0.00965f
C99 a_1257_36# a_1509_36# 1.09117f
C100 a_2096_165# a_1977_36# 0.00294f
C101 a_1257_36# Q 0.00348f
C103 a_861_414# VPWR 0.01047f
C104 a_1977_450# VPWR 0.01954f
C105 a_936_288# VPB 0.36672f
C106 a_1977_450# a_1761_36# 0.01125f
C107 a_936_288# a_2697_36# 0.21796f
C108 VGND a_2553_36# 0.01602f
C109 a_1509_36# VPB 0.31018f
C110 Q VPB 0.02034f
C111 a_936_288# DE 0.05327f
C113 VPWR a_144_36# 0.38882f
C114 a_1509_36# a_2697_36# 0.12554f
C115 VPWR CLK 0.03739f
C116 a_144_36# a_1761_36# 0.04862f
C117 Q a_2697_36# 0.0949f
C119 VPWR D 0.02183f
C120 a_1509_36# a_1977_36# 0.00712f
C122 a_249_414# a_144_36# 0.00844f
C124 VPWR a_2913_450# 0.01687f
C125 a_1257_36# VGND 0.26302f
C126 a_861_414# a_936_288# 0.01122f
C127 a_1977_450# a_936_288# 0.00876f
C128 Q VNB 0.01963f
C129 VGND VNB 2.29314f
C130 VPWR VNB 1.57992f
C131 CLK VNB 0.15114f
C132 DE VNB 0.35579f
C133 D VNB 0.17704f
C134 VPB VNB 4.44787f
C135 a_144_36# VNB 0.27525f
C136 a_2697_36# VNB 0.38598f
C137 a_1761_36# VNB 0.13301f
C138 a_2096_165# VNB 0.28484f
C139 a_1509_36# VNB 0.40556f
C140 a_1257_36# VNB 0.57375f
C141 a_936_288# VNB 0.38901f
C142 a_324_288# VNB 0.19908f
.ends

.subckt sky130_efx_lvdig__ha_1 A B COUT SUM VGND VNB VPB VPWR
X0 a_108_216# B VPWR VPB sky130_fd_pr__pfet_01v8_hvt ad=0.08775 pd=0.84 as=0.16875 ps=1.65 w=0.45 l=0.15
X1 a_717_450# a_108_216# VPWR VPB sky130_fd_pr__pfet_01v8_hvt ad=0.16875 pd=1.65 as=0.16875 ps=1.65 w=0.45 l=0.15
X2 VPWR a_108_216# COUT VPB sky130_fd_pr__pfet_01v8_hvt ad=0.405 pd=2.91 as=0.405 ps=2.91 w=1.08 l=0.15
X3 VPWR A a_108_216# VPB sky130_fd_pr__pfet_01v8_hvt ad=0.08775 pd=0.84 as=0.08775 ps=0.84 w=0.45 l=0.15
X4 SUM a_717_450# VPWR VPB sky130_fd_pr__pfet_01v8_hvt ad=0.405 pd=2.91 as=0.405 ps=2.91 w=1.08 l=0.15
X5 a_609_450# A VPWR VPB sky130_fd_pr__pfet_01v8_hvt ad=0.08775 pd=0.84 as=0.08775 ps=0.84 w=0.45 l=0.15
X6 VGND B a_609_36# VNB sky130_fd_pr__nfet_01v8 ad=0.16875 pd=1.65 as=0.08775 ps=0.84 w=0.45 l=0.15
X7 a_717_450# B a_609_450# VPB sky130_fd_pr__pfet_01v8_hvt ad=0.16875 pd=1.65 as=0.08775 ps=0.84 w=0.45 l=0.15
X8 a_609_36# A VGND VNB sky130_fd_pr__nfet_01v8 ad=0.08775 pd=0.84 as=0.08775 ps=0.84 w=0.45 l=0.15
X9 SUM a_717_450# VGND VNB sky130_fd_pr__nfet_01v8 ad=0.23625 pd=2.01 as=0.23625 ps=2.01 w=0.63 l=0.15
X10 VGND a_108_216# COUT VNB sky130_fd_pr__nfet_01v8 ad=0.23625 pd=2.01 as=0.23625 ps=2.01 w=0.63 l=0.15
X11 a_717_450# a_108_216# a_609_36# VNB sky130_fd_pr__nfet_01v8 ad=0.16875 pd=1.65 as=0.16875 ps=1.65 w=0.45 l=0.15
X12 a_393_36# B a_108_216# VNB sky130_fd_pr__nfet_01v8 ad=0.08775 pd=0.84 as=0.16875 ps=1.65 w=0.45 l=0.15
X13 VGND A a_393_36# VNB sky130_fd_pr__nfet_01v8 ad=0.08775 pd=0.84 as=0.08775 ps=0.84 w=0.45 l=0.15
C0 VGND a_609_36# 0.21068f
C1 a_108_216# a_717_450# 0.18125f
C2 VGND COUT 0.10221f
C3 SUM a_108_216# 0.00317f
C4 VPB a_717_450# 0.14007f
C5 VPWR a_717_450# 0.30654f
C6 a_609_36# A 0.01013f
C7 VPB SUM 0.01417f
C8 SUM VPWR 0.08434f
C9 a_609_36# B 0.07025f
C11 B COUT 0.00292f
C12 a_609_36# a_108_216# 0.14741f
C13 COUT a_108_216# 0.11243f
C14 VPB a_609_36# 0.00557f
C15 a_609_36# VPWR 0.00726f
C16 a_609_450# B 0.00213f
C17 VPWR COUT 0.08657f
C18 VPB COUT 0.01121f
C19 VGND A 0.04842f
C20 VGND B 0.05631f
C21 a_609_450# VPWR 0.01236f
C22 VGND a_108_216# 0.51417f
C23 B A 0.19992f
C24 VGND VPB 0.01609f
C25 VGND VPWR 0.07429f
C26 A a_108_216# 0.08372f
C27 B a_108_216# 0.48466f
C28 VPB A 0.16404f
C29 A VPWR 0.07432f
C30 B VPWR 0.11728f
C31 VPB B 0.2208f
C32 VPB a_108_216# 0.23347f
C33 VPWR a_108_216# 0.26769f
C34 VPB VPWR 0.28343f
C35 VGND a_393_36# 0.0054f
C37 a_393_36# a_108_216# 0.01094f
C38 SUM a_717_450# 0.11842f
C40 a_609_36# a_717_450# 0.06858f
C41 a_609_450# a_717_450# 0.00469f
C42 VGND a_717_450# 0.14883f
C43 VGND SUM 0.10221f
C44 a_609_450# a_609_36# 0.00132f
C45 A a_717_450# 0.01603f
C46 B a_717_450# 0.06243f
C47 VGND VNB 0.90436f
C48 SUM VNB 0.10703f
C49 VPWR VNB 0.63825f
C50 COUT VNB 0.11242f
C51 A VNB 0.18026f
C52 B VNB 0.29018f
C53 VPB VNB 1.62518f
C54 a_609_36# VNB 0.03762f
C55 a_717_450# VNB 0.18881f
C56 a_108_216# VNB 0.40202f
.ends

.subckt sky130_efx_lvdig__inv_1 A Y VGND VNB VPB VPWR
X0 Y A VPWR VPB sky130_fd_pr__pfet_01v8_hvt ad=0.405 pd=2.91 as=0.405 ps=2.91 w=1.08 l=0.15
X1 Y A VGND VNB sky130_fd_pr__nfet_01v8 ad=0.23625 pd=2.01 as=0.23625 ps=2.01 w=0.63 l=0.15
C0 Y VPB 0.01427f
C1 VPWR VPB 0.06715f
C2 Y VPWR 0.13749f
C3 A VPB 0.05348f
C4 Y A 0.04374f
C5 VGND VPB 0.01012f
C6 VGND Y 0.10009f
C7 VPWR A 0.06489f
C8 VGND VPWR 0.03199f
C9 VGND A 0.05415f
C10 VGND VNB 0.29936f
C11 Y VNB 0.1195f
C12 VPWR VNB 0.25752f
C13 A VNB 0.18799f
C14 VPB VNB 0.34214f
.ends

.subckt sky130_efx_lvdig__inv_2 A Y VGND VNB VPB VPWR
X0 VGND A Y VNB sky130_fd_pr__nfet_01v8 ad=0.23625 pd=2.01 as=0.12285 ps=1.02 w=0.63 l=0.15
X1 Y A VPWR VPB sky130_fd_pr__pfet_01v8_hvt ad=0.2106 pd=1.47 as=0.405 ps=2.91 w=1.08 l=0.15
X2 VPWR A Y VPB sky130_fd_pr__pfet_01v8_hvt ad=0.405 pd=2.91 as=0.2106 ps=1.47 w=1.08 l=0.15
X3 Y A VGND VNB sky130_fd_pr__nfet_01v8 ad=0.12285 pd=1.02 as=0.23625 ps=2.01 w=0.63 l=0.15
C0 Y VPB 0.00717f
C1 VPWR VPB 0.0766f
C2 Y VPWR 0.22627f
C3 A VPB 0.09788f
C4 Y A 0.10877f
C5 VGND VPB 0.00844f
C6 VGND Y 0.15357f
C7 VPWR A 0.09572f
C8 VGND VPWR 0.05009f
C9 VGND A 0.08139f
C10 VGND VNB 0.3618f
C11 Y VNB 0.04877f
C12 VPWR VNB 0.32499f
C13 A VNB 0.27502f
C14 VPB VNB 0.42768f
.ends

.subckt sky130_efx_lvdig__inv_4 A Y VGND VNB VPB VPWR
X0 VGND A Y VNB sky130_fd_pr__nfet_01v8 ad=0.12285 pd=1.02 as=0.12285 ps=1.02 w=0.63 l=0.15
X1 Y A VGND VNB sky130_fd_pr__nfet_01v8 ad=0.12285 pd=1.02 as=0.12285 ps=1.02 w=0.63 l=0.15
X2 VGND A Y VNB sky130_fd_pr__nfet_01v8 ad=0.23625 pd=2.01 as=0.12285 ps=1.02 w=0.63 l=0.15
X3 Y A VPWR VPB sky130_fd_pr__pfet_01v8_hvt ad=0.2106 pd=1.47 as=0.405 ps=2.91 w=1.08 l=0.15
X4 VPWR A Y VPB sky130_fd_pr__pfet_01v8_hvt ad=0.2106 pd=1.47 as=0.2106 ps=1.47 w=1.08 l=0.15
X5 Y A VPWR VPB sky130_fd_pr__pfet_01v8_hvt ad=0.2106 pd=1.47 as=0.2106 ps=1.47 w=1.08 l=0.15
X6 VPWR A Y VPB sky130_fd_pr__pfet_01v8_hvt ad=0.405 pd=2.91 as=0.2106 ps=1.47 w=1.08 l=0.15
X7 Y A VGND VNB sky130_fd_pr__nfet_01v8 ad=0.12285 pd=1.02 as=0.23625 ps=2.01 w=0.63 l=0.15
C0 Y VPB 0.01503f
C1 VPWR VPB 0.11025f
C2 Y VPWR 0.48984f
C3 A VPB 0.19009f
C4 Y A 0.23208f
C5 VGND VPB 0.00912f
C6 VGND Y 0.34107f
C7 VPWR A 0.15818f
C8 VGND VPWR 0.07001f
C9 VGND A 0.13357f
C10 VGND VNB 0.47787f
C11 Y VNB 0.05991f
C12 VPWR VNB 0.40517f
C13 A VNB 0.44808f
C14 VPB VNB 0.68429f
.ends

.subckt sky130_efx_lvdig__mux2_1 A0 A1 S X VGND VNB VPB VPWR
X0 a_861_450# a_324_180# VPWR VPB sky130_fd_pr__pfet_01v8_hvt ad=0.08775 pd=0.84 as=0.16875 ps=1.65 w=0.45 l=0.15
X1 a_249_36# A0 a_144_36# VNB sky130_fd_pr__nfet_01v8 ad=0.08775 pd=0.84 as=0.16875 ps=1.65 w=0.45 l=0.15
X2 VGND a_324_180# a_249_36# VNB sky130_fd_pr__nfet_01v8 ad=0.16875 pd=1.65 as=0.08775 ps=0.84 w=0.45 l=0.15
X3 a_144_36# A1 a_861_450# VPB sky130_fd_pr__pfet_01v8_hvt ad=0.16875 pd=1.65 as=0.08775 ps=0.84 w=0.45 l=0.15
X4 a_861_36# S VGND VNB sky130_fd_pr__nfet_01v8 ad=0.08775 pd=0.84 as=0.16875 ps=1.65 w=0.45 l=0.15
X5 VPWR S a_324_180# VPB sky130_fd_pr__pfet_01v8_hvt ad=0.16875 pd=1.65 as=0.16875 ps=1.65 w=0.45 l=0.15
X6 VGND S a_324_180# VNB sky130_fd_pr__nfet_01v8 ad=0.16875 pd=1.65 as=0.16875 ps=1.65 w=0.45 l=0.15
X7 a_144_36# A1 a_861_36# VNB sky130_fd_pr__nfet_01v8 ad=0.16875 pd=1.65 as=0.08775 ps=0.84 w=0.45 l=0.15
X8 X a_144_36# VGND VNB sky130_fd_pr__nfet_01v8 ad=0.23625 pd=2.01 as=0.23625 ps=2.01 w=0.63 l=0.15
X9 a_249_450# A0 a_144_36# VPB sky130_fd_pr__pfet_01v8_hvt ad=0.08775 pd=0.84 as=0.16875 ps=1.65 w=0.45 l=0.15
X10 VPWR S a_249_450# VPB sky130_fd_pr__pfet_01v8_hvt ad=0.16875 pd=1.65 as=0.08775 ps=0.84 w=0.45 l=0.15
X11 X a_144_36# VPWR VPB sky130_fd_pr__pfet_01v8_hvt ad=0.405 pd=2.91 as=0.405 ps=2.91 w=1.08 l=0.15
C0 VPWR VPB 0.29762f
C1 VGND X 0.10221f
C2 a_144_36# a_249_450# 0.00602f
C3 VPWR a_144_36# 0.49056f
C4 VGND A0 0.01596f
C5 VPWR A1 0.02569f
C6 A0 S 0.04299f
C7 VGND VPB 0.0141f
C8 VPB S 0.28386f
C9 a_249_36# a_144_36# 0.00928f
C10 VGND a_144_36# 0.91995f
C11 S a_144_36# 0.04485f
C12 VGND A1 0.01693f
C13 A1 S 0.03776f
C14 a_861_450# a_144_36# 0.00602f
C15 X VPB 0.00972f
C16 X a_144_36# 0.07501f
C17 VPB A0 0.13097f
C18 X A1 0.00107f
C19 A0 a_144_36# 0.07713f
C20 VPB a_144_36# 0.17077f
C21 VPB A1 0.1359f
C22 A1 a_144_36# 0.10684f
C23 VPWR a_324_180# 0.21947f
C24 VGND a_324_180# 0.16966f
C25 S a_324_180# 0.24193f
C26 A0 a_324_180# 0.04316f
C27 VPB a_324_180# 0.17742f
C29 a_324_180# a_144_36# 0.10482f
C30 A1 a_324_180# 0.04911f
C31 VGND a_861_36# 0.01079f
C32 VPWR a_249_450# 0.01236f
C35 VGND VPWR 0.04137f
C36 VPWR S 0.0684f
C37 VGND a_249_36# 0.01079f
C38 a_861_450# VPWR 0.01236f
C39 VGND S 0.08055f
C40 a_861_36# a_144_36# 0.00928f
C41 X VPWR 0.13857f
C43 VPWR A0 0.02312f
C44 VGND VNB 0.88905f
C45 X VNB 0.11052f
C46 VPWR VNB 0.65006f
C47 A1 VNB 0.12997f
C48 S VNB 0.34046f
C49 A0 VNB 0.1521f
C50 VPB VNB 1.62518f
C51 a_144_36# VNB 0.40928f
C52 a_324_180# VNB 0.19368f
.ends

.subckt sky130_efx_lvdig__mux2_2 A0 A1 S X VGND VNB VPB VPWR
X0 a_249_36# A0 a_144_36# VNB sky130_fd_pr__nfet_01v8 ad=0.08775 pd=0.84 as=0.16875 ps=1.65 w=0.45 l=0.15
X1 VGND a_324_180# a_249_36# VNB sky130_fd_pr__nfet_01v8 ad=0.16875 pd=1.65 as=0.08775 ps=0.84 w=0.45 l=0.15
X2 a_861_36# S VGND VNB sky130_fd_pr__nfet_01v8 ad=0.08775 pd=0.84 as=0.16875 ps=1.65 w=0.45 l=0.15
X3 a_249_414# A0 a_144_36# VPB sky130_fd_pr__pfet_01v8_hvt ad=0.12285 pd=1.02 as=0.23625 ps=2.01 w=0.63 l=0.15
X4 VGND S a_324_180# VNB sky130_fd_pr__nfet_01v8 ad=0.16875 pd=1.65 as=0.16875 ps=1.65 w=0.45 l=0.15
X5 VPWR S a_249_414# VPB sky130_fd_pr__pfet_01v8_hvt ad=0.23625 pd=2.01 as=0.12285 ps=1.02 w=0.63 l=0.15
X6 a_861_414# a_324_180# VPWR VPB sky130_fd_pr__pfet_01v8_hvt ad=0.12285 pd=1.02 as=0.23625 ps=2.01 w=0.63 l=0.15
X7 a_144_36# A1 a_861_36# VNB sky130_fd_pr__nfet_01v8 ad=0.16875 pd=1.65 as=0.08775 ps=0.84 w=0.45 l=0.15
X8 X a_144_36# VGND VNB sky130_fd_pr__nfet_01v8 ad=0.12285 pd=1.02 as=0.23625 ps=2.01 w=0.63 l=0.15
X9 VGND a_144_36# X VNB sky130_fd_pr__nfet_01v8 ad=0.23625 pd=2.01 as=0.12285 ps=1.02 w=0.63 l=0.15
X10 a_144_36# A1 a_861_414# VPB sky130_fd_pr__pfet_01v8_hvt ad=0.23625 pd=2.01 as=0.12285 ps=1.02 w=0.63 l=0.15
X11 X a_144_36# VPWR VPB sky130_fd_pr__pfet_01v8_hvt ad=0.2106 pd=1.47 as=0.405 ps=2.91 w=1.08 l=0.15
X12 VPWR S a_324_180# VPB sky130_fd_pr__pfet_01v8_hvt ad=0.23625 pd=2.01 as=0.23625 ps=2.01 w=0.63 l=0.15
X13 VPWR a_144_36# X VPB sky130_fd_pr__pfet_01v8_hvt ad=0.405 pd=2.91 as=0.2106 ps=1.47 w=1.08 l=0.15
C0 X VPWR 0.22627f
C1 a_144_36# a_249_414# 0.00854f
C3 VPWR A0 0.02289f
C4 A1 a_144_36# 0.11129f
C5 VGND A1 0.01719f
C6 X VPB 0.00762f
C7 A1 S 0.03126f
C8 VPB A0 0.11271f
C9 VPWR a_861_414# 0.01672f
C10 X a_144_36# 0.12414f
C11 X VGND 0.15357f
C12 A0 a_144_36# 0.08097f
C13 VGND A0 0.0161f
C14 S A0 0.03278f
C15 VPWR VPB 0.32944f
C17 a_861_414# a_144_36# 0.00854f
C18 VPWR a_144_36# 0.53883f
C19 VGND VPWR 0.06841f
C20 VPWR S 0.0757f
C22 VPB a_144_36# 0.20497f
C23 VGND VPB 0.01628f
C24 VPB S 0.24252f
C25 VGND a_144_36# 0.94853f
C26 a_861_36# a_144_36# 0.00928f
C27 VGND a_861_36# 0.01079f
C28 VGND S 0.08444f
C29 S a_144_36# 0.04673f
C30 A1 a_324_180# 0.04899f
C31 A0 a_324_180# 0.04295f
C32 VPWR a_324_180# 0.24287f
C33 VPB a_324_180# 0.1575f
C34 a_324_180# a_144_36# 0.10461f
C35 VGND a_324_180# 0.17239f
C36 S a_324_180# 0.25536f
C39 VPWR a_249_414# 0.01672f
C40 a_249_36# a_144_36# 0.00928f
C41 VGND a_249_36# 0.01079f
C42 VPWR A1 0.02507f
C43 A1 VPB 0.11122f
C44 VGND VNB 1.00266f
C45 X VNB 0.0357f
C46 VPWR VNB 0.74598f
C47 A1 VNB 0.135f
C48 S VNB 0.34704f
C49 A0 VNB 0.15445f
C50 VPB VNB 1.79626f
C51 a_144_36# VNB 0.49155f
C52 a_324_180# VNB 0.19891f
.ends

.subckt sky130_efx_lvdig__nand2_1 A B Y VGND VNB VPB VPWR
X0 Y A a_141_36# VNB sky130_fd_pr__nfet_01v8 ad=0.23625 pd=2.01 as=0.12285 ps=1.02 w=0.63 l=0.15
X1 Y B VPWR VPB sky130_fd_pr__pfet_01v8_hvt ad=0.2106 pd=1.47 as=0.405 ps=2.91 w=1.08 l=0.15
X2 VPWR A Y VPB sky130_fd_pr__pfet_01v8_hvt ad=0.405 pd=2.91 as=0.2106 ps=1.47 w=1.08 l=0.15
X3 a_141_36# B VGND VNB sky130_fd_pr__nfet_01v8 ad=0.12285 pd=1.02 as=0.23625 ps=2.01 w=0.63 l=0.15
C0 B A 0.04923f
C1 VPWR VPB 0.0766f
C2 VPWR Y 0.2293f
C3 A VGND 0.01532f
C5 VPWR B 0.06512f
C6 VPWR VGND 0.0379f
C7 VPB Y 0.00728f
C8 B VPB 0.04956f
C9 a_141_36# Y 0.0135f
C10 B Y 0.05877f
C11 VPB VGND 0.00741f
C12 VGND Y 0.13562f
C13 VGND a_141_36# 0.00564f
C14 B VGND 0.05368f
C15 VPWR A 0.06439f
C16 A VPB 0.04956f
C17 A Y 0.09776f
C18 VGND VNB 0.33047f
C19 Y VNB 0.06907f
C20 VPWR VNB 0.32006f
C21 A VNB 0.15402f
C22 B VNB 0.15402f
C23 VPB VNB 0.42768f
.ends

.subckt sky130_efx_lvdig__nand2_2 A B Y VGND VNB VPB VPWR
X0 nmos_n3f5_f2_l150_ftf_0.S0 A Y VNB sky130_fd_pr__nfet_01v8 ad=0.12285 pd=1.02 as=0.12285 ps=1.02 w=0.63 l=0.15
X1 VGND B nmos_n3f5_f2_l150_ftf_0.S0 VNB sky130_fd_pr__nfet_01v8 ad=0.12285 pd=1.02 as=0.12285 ps=1.02 w=0.63 l=0.15
X2 nmos_n3f5_f2_l150_ftf_0.S0 B VGND VNB sky130_fd_pr__nfet_01v8 ad=0.23625 pd=2.01 as=0.12285 ps=1.02 w=0.63 l=0.15
X3 Y A VPWR VPB sky130_fd_pr__pfet_01v8_hvt ad=0.2106 pd=1.47 as=0.405 ps=2.91 w=1.08 l=0.15
X4 VPWR A Y VPB sky130_fd_pr__pfet_01v8_hvt ad=0.2106 pd=1.47 as=0.2106 ps=1.47 w=1.08 l=0.15
X5 Y B VPWR VPB sky130_fd_pr__pfet_01v8_hvt ad=0.2106 pd=1.47 as=0.2106 ps=1.47 w=1.08 l=0.15
X6 VPWR B Y VPB sky130_fd_pr__pfet_01v8_hvt ad=0.405 pd=2.91 as=0.2106 ps=1.47 w=1.08 l=0.15
X7 Y A nmos_n3f5_f2_l150_ftf_0.S0 VNB sky130_fd_pr__nfet_01v8 ad=0.12285 pd=1.02 as=0.23625 ps=2.01 w=0.63 l=0.15
C0 A B 0.05091f
C1 B nmos_n3f5_f2_l150_ftf_0.S0 0.0738f
C2 VPWR Y 0.39958f
C3 B VGND 0.04214f
C4 VPWR VPB 0.10954f
C5 VPWR nmos_n3f5_f2_l150_ftf_0.S0 0.01965f
C6 VPWR A 0.08545f
C7 VPWR VGND 0.05488f
C8 VPB Y 0.01252f
C9 nmos_n3f5_f2_l150_ftf_0.S0 Y 0.11846f
C10 A Y 0.11743f
C11 A VPB 0.09566f
C12 nmos_n3f5_f2_l150_ftf_0.S0 VPB 0.00238f
C13 VGND Y 0.0163f
C14 VGND VPB 0.00852f
C15 A nmos_n3f5_f2_l150_ftf_0.S0 0.06286f
C16 VGND nmos_n3f5_f2_l150_ftf_0.S0 0.34001f
C17 A VGND 0.02073f
C18 VPWR B 0.05053f
C19 B Y 0.08086f
C20 B VPB 0.07872f
C21 VGND VNB 0.41368f
C22 Y VNB 0.03355f
C23 VPWR VNB 0.40718f
C24 B VNB 0.20441f
C25 A VNB 0.24055f
C26 VPB VNB 0.68429f
C27 nmos_n3f5_f2_l150_ftf_0.S0 VNB 0.08298f
.ends

.subckt sky130_efx_lvdig__nor2_1 A B Y VGND VNB VPB VPWR
X0 VGND B Y VNB sky130_fd_pr__nfet_01v8 ad=0.23625 pd=2.01 as=0.12285 ps=1.02 w=0.63 l=0.15
X1 a_141_324# A VPWR VPB sky130_fd_pr__pfet_01v8_hvt ad=0.2106 pd=1.47 as=0.405 ps=2.91 w=1.08 l=0.15
X2 Y B a_141_324# VPB sky130_fd_pr__pfet_01v8_hvt ad=0.405 pd=2.91 as=0.2106 ps=1.47 w=1.08 l=0.15
X3 Y A VGND VNB sky130_fd_pr__nfet_01v8 ad=0.12285 pd=1.02 as=0.23625 ps=2.01 w=0.63 l=0.15
C0 A B 0.04923f
C1 VPWR VPB 0.07137f
C2 VPWR Y 0.11971f
C3 B VGND 0.05324f
C4 VPWR a_141_324# 0.01908f
C5 VPWR A 0.06442f
C6 VPWR VGND 0.03692f
C7 VPB Y 0.0132f
C8 A VPB 0.04956f
C9 a_141_324# Y 0.02225f
C10 A Y 0.056f
C11 VPB VGND 0.00746f
C12 VGND Y 0.15726f
C13 VGND a_141_324# 0.00181f
C14 A VGND 0.05438f
C15 VPWR B 0.01923f
C16 B VPB 0.04956f
C17 B Y 0.10712f
C18 VGND VNB 0.35825f
C19 Y VNB 0.08057f
C20 VPWR VNB 0.2816f
C21 B VNB 0.15402f
C22 A VNB 0.15402f
C23 VPB VNB 0.42768f
.ends

.subckt sky130_efx_lvdig__nor2_2 A B Y VGND VNB VPB VPWR
X0 VGND A Y VNB sky130_fd_pr__nfet_01v8 ad=0.12285 pd=1.02 as=0.12285 ps=1.02 w=0.63 l=0.15
X1 Y B VGND VNB sky130_fd_pr__nfet_01v8 ad=0.12285 pd=1.02 as=0.12285 ps=1.02 w=0.63 l=0.15
X2 VGND B Y VNB sky130_fd_pr__nfet_01v8 ad=0.23625 pd=2.01 as=0.12285 ps=1.02 w=0.63 l=0.15
X3 VPWR A pmos_n6_f2_l150_hvt_ftf_1.S0 VPB sky130_fd_pr__pfet_01v8_hvt ad=0.2106 pd=1.47 as=0.405 ps=2.91 w=1.08 l=0.15
X4 pmos_n6_f2_l150_hvt_ftf_1.S0 A VPWR VPB sky130_fd_pr__pfet_01v8_hvt ad=0.2106 pd=1.47 as=0.2106 ps=1.47 w=1.08 l=0.15
X5 Y B pmos_n6_f2_l150_hvt_ftf_1.S0 VPB sky130_fd_pr__pfet_01v8_hvt ad=0.2106 pd=1.47 as=0.2106 ps=1.47 w=1.08 l=0.15
X6 pmos_n6_f2_l150_hvt_ftf_1.S0 B Y VPB sky130_fd_pr__pfet_01v8_hvt ad=0.405 pd=2.91 as=0.2106 ps=1.47 w=1.08 l=0.15
X7 Y A VGND VNB sky130_fd_pr__nfet_01v8 ad=0.12285 pd=1.02 as=0.23625 ps=2.01 w=0.63 l=0.15
C0 VPWR VPB 0.09882f
C1 A B 0.04992f
C2 B pmos_n6_f2_l150_hvt_ftf_1.S0 0.07521f
C3 VPWR Y 0.01004f
C4 B VGND 0.07508f
C5 VPWR pmos_n6_f2_l150_hvt_ftf_1.S0 0.33744f
C6 VPWR A 0.04408f
C7 VPWR VGND 0.05283f
C8 VPB Y 0.00946f
C9 A VPB 0.09566f
C10 VPB pmos_n6_f2_l150_hvt_ftf_1.S0 0.018f
C11 A Y 0.04979f
C12 pmos_n6_f2_l150_hvt_ftf_1.S0 Y 0.15971f
C13 VPB VGND 0.0087f
C14 VGND Y 0.30993f
C15 A pmos_n6_f2_l150_hvt_ftf_1.S0 0.09023f
C16 VGND pmos_n6_f2_l150_hvt_ftf_1.S0 0.01251f
C17 A VGND 0.07602f
C18 VPWR B 0.02298f
C19 B VPB 0.09566f
C20 B Y 0.11153f
C21 VGND VNB 0.47467f
C22 Y VNB 0.04389f
C23 VPWR VNB 0.3265f
C24 B VNB 0.24055f
C25 A VNB 0.24227f
C26 VPB VNB 0.68429f
C27 pmos_n6_f2_l150_hvt_ftf_1.S0 VNB 0.08526f
.ends

.subckt sky130_efx_lvdig__nor3_2 A B C Y VGND VNB VPB VPWR
X0 a_357_324# C Y VPB sky130_fd_pr__pfet_01v8_hvt ad=0.405 pd=2.91 as=0.2106 ps=1.47 w=1.08 l=0.15
X1 VGND A Y VNB sky130_fd_pr__nfet_01v8 ad=0.12285 pd=1.02 as=0.12285 ps=1.02 w=0.63 l=0.15
X2 Y B VGND VNB sky130_fd_pr__nfet_01v8 ad=0.12285 pd=1.02 as=0.12285 ps=1.02 w=0.63 l=0.15
X3 VGND B Y VNB sky130_fd_pr__nfet_01v8 ad=0.23625 pd=2.01 as=0.12285 ps=1.02 w=0.63 l=0.15
X4 VPWR A a_36_324# VPB sky130_fd_pr__pfet_01v8_hvt ad=0.2106 pd=1.47 as=0.405 ps=2.91 w=1.08 l=0.15
X5 a_36_324# A VPWR VPB sky130_fd_pr__pfet_01v8_hvt ad=0.2106 pd=1.47 as=0.2106 ps=1.47 w=1.08 l=0.15
X6 Y C VGND VNB sky130_fd_pr__nfet_01v8 ad=0.12285 pd=1.02 as=0.23625 ps=2.01 w=0.63 l=0.15
X7 VGND C Y VNB sky130_fd_pr__nfet_01v8 ad=0.23625 pd=2.01 as=0.12285 ps=1.02 w=0.63 l=0.15
X8 a_357_324# B a_36_324# VPB sky130_fd_pr__pfet_01v8_hvt ad=0.2106 pd=1.47 as=0.2106 ps=1.47 w=1.08 l=0.15
X9 a_36_324# B a_357_324# VPB sky130_fd_pr__pfet_01v8_hvt ad=0.405 pd=2.91 as=0.2106 ps=1.47 w=1.08 l=0.15
X10 Y A VGND VNB sky130_fd_pr__nfet_01v8 ad=0.12285 pd=1.02 as=0.23625 ps=2.01 w=0.63 l=0.15
X11 Y C a_357_324# VPB sky130_fd_pr__pfet_01v8_hvt ad=0.2106 pd=1.47 as=0.405 ps=2.91 w=1.08 l=0.15
C0 VGND a_36_324# 0.01116f
C1 VGND B 0.04313f
C2 Y A 0.03702f
C3 VPB A 0.09566f
C4 VPWR a_357_324# 0.32531f
C5 Y a_36_324# 0.04815f
C6 VGND C 0.05182f
C7 VPB a_36_324# 0.01675f
C8 Y B 0.07329f
C9 VPB B 0.08255f
C10 VGND a_357_324# 0.01828f
C11 Y C 0.13793f
C12 a_36_324# A 0.09023f
C13 VPB C 0.10171f
C14 B A 0.06097f
C15 VGND VPWR 0.08309f
C16 B a_36_324# 0.06816f
C17 Y a_357_324# 0.10499f
C18 VPB a_357_324# 0.02917f
C19 Y VPWR 0.01136f
C20 VPWR VPB 0.1562f
C21 C B 0.02972f
C22 VPWR A 0.04408f
C23 VGND Y 0.51634f
C24 VGND VPB 0.01395f
C25 a_36_324# a_357_324# 0.12949f
C26 B a_357_324# 0.0152f
C27 VPWR a_36_324# 0.22083f
C28 VPWR B 0.02578f
C29 VGND A 0.07602f
C30 Y VPB 0.01613f
C31 C a_357_324# 0.07661f
C32 VPWR C 0.02297f
C33 VGND VNB 0.68519f
C34 Y VNB 0.0776f
C35 VPWR VNB 0.47176f
C36 C VNB 0.24172f
C37 B VNB 0.17263f
C38 A VNB 0.24227f
C39 VPB VNB 1.11197f
C40 a_357_324# VNB 0.04635f
C41 a_36_324# VNB 0.04836f
.ends

.subckt sky130_efx_lvdig__o21a_1 A1 A2 B1 X VGND VNB VPB VPWR
X0 VGND A2 nmos_n3f5_f1_l150_0.S0 VNB sky130_fd_pr__nfet_01v8 ad=0.23625 pd=2.01 as=0.12285 ps=1.02 w=0.63 l=0.15
X1 a_141_324# A1 VPWR VPB sky130_fd_pr__pfet_01v8_hvt ad=0.2106 pd=1.47 as=0.405 ps=2.91 w=1.08 l=0.15
X2 X pmos_n6_f2_l150_hvt_fnf_0.D0 VGND VNB sky130_fd_pr__nfet_01v8 ad=0.23625 pd=2.01 as=0.23625 ps=2.01 w=0.63 l=0.15
X3 pmos_n6_f2_l150_hvt_fnf_0.D0 A2 a_141_324# VPB sky130_fd_pr__pfet_01v8_hvt ad=0.405 pd=2.91 as=0.2106 ps=1.47 w=1.08 l=0.15
X4 X pmos_n6_f2_l150_hvt_fnf_0.D0 VPWR VPB sky130_fd_pr__pfet_01v8_hvt ad=0.405 pd=2.91 as=0.405 ps=2.91 w=1.08 l=0.15
X5 nmos_n3f5_f1_l150_0.S0 A1 VGND VNB sky130_fd_pr__nfet_01v8 ad=0.12285 pd=1.02 as=0.23625 ps=2.01 w=0.63 l=0.15
X6 pmos_n6_f2_l150_hvt_fnf_0.D0 B1 VPWR VPB sky130_fd_pr__pfet_01v8_hvt ad=0.405 pd=2.91 as=0.405 ps=2.91 w=1.08 l=0.15
X7 pmos_n6_f2_l150_hvt_fnf_0.D0 B1 nmos_n3f5_f1_l150_0.S0 VNB sky130_fd_pr__nfet_01v8 ad=0.23625 pd=2.01 as=0.23625 ps=2.01 w=0.63 l=0.15
C0 VPWR pmos_n6_f2_l150_hvt_fnf_0.D0 0.32806f
C1 VPWR VPB 0.17532f
C2 B1 VGND 0.02114f
C3 B1 nmos_n3f5_f1_l150_0.S0 0.04085f
C4 B1 pmos_n6_f2_l150_hvt_fnf_0.D0 0.12614f
C5 VPWR A1 0.06465f
C6 B1 VPB 0.05944f
C7 VGND nmos_n3f5_f1_l150_0.S0 0.24914f
C8 X VGND 0.10221f
C9 VPWR a_141_324# 0.02624f
C10 VGND pmos_n6_f2_l150_hvt_fnf_0.D0 0.15197f
C11 pmos_n6_f2_l150_hvt_fnf_0.D0 nmos_n3f5_f1_l150_0.S0 0.06892f
C12 VGND VPB 0.01359f
C13 VPWR A2 0.02397f
C14 X pmos_n6_f2_l150_hvt_fnf_0.D0 0.11842f
C15 VPB nmos_n3f5_f1_l150_0.S0 0.00258f
C16 X VPB 0.00999f
C17 VPB pmos_n6_f2_l150_hvt_fnf_0.D0 0.10556f
C18 VGND A1 0.05438f
C19 A1 nmos_n3f5_f1_l150_0.S0 0.00736f
C20 B1 A2 0.04604f
C21 A1 pmos_n6_f2_l150_hvt_fnf_0.D0 0.00444f
C22 A1 VPB 0.04956f
C23 VGND a_141_324# 0.00295f
C24 a_141_324# nmos_n3f5_f1_l150_0.S0 0.00457f
C25 A2 VGND 0.02541f
C26 VPWR B1 0.02458f
C27 A2 nmos_n3f5_f1_l150_0.S0 0.05235f
C28 pmos_n6_f2_l150_hvt_fnf_0.D0 a_141_324# 0.01126f
C29 A2 pmos_n6_f2_l150_hvt_fnf_0.D0 0.04374f
C30 A2 VPB 0.05339f
C31 VPWR VGND 0.08217f
C32 VPWR nmos_n3f5_f1_l150_0.S0 0.00947f
C33 X VPWR 0.08434f
C34 A2 A1 0.06327f
C35 VGND VNB 0.63495f
C36 X VNB 0.1112f
C37 VPWR VNB 0.48274f
C38 B1 VNB 0.12615f
C39 A2 VNB 0.1166f
C40 A1 VNB 0.15633f
C41 VPB VNB 1.02643f
C42 nmos_n3f5_f1_l150_0.S0 VNB 0.03094f
C43 pmos_n6_f2_l150_hvt_fnf_0.D0 VNB 0.19265f
.ends

.subckt sky130_efx_lvdig__or2_1 A B X VGND VNB VPB VPWR
X0 VGND B a_141_36# VNB sky130_fd_pr__nfet_01v8 ad=0.16875 pd=1.65 as=0.08775 ps=0.84 w=0.45 l=0.15
X1 a_141_450# A VPWR VPB sky130_fd_pr__pfet_01v8_hvt ad=0.08775 pd=0.84 as=0.16875 ps=1.65 w=0.45 l=0.15
X2 a_141_36# A VGND VNB sky130_fd_pr__nfet_01v8 ad=0.08775 pd=0.84 as=0.16875 ps=1.65 w=0.45 l=0.15
X3 a_141_36# B a_141_450# VPB sky130_fd_pr__pfet_01v8_hvt ad=0.16875 pd=1.65 as=0.08775 ps=0.84 w=0.45 l=0.15
X4 X a_141_36# VPWR VPB sky130_fd_pr__pfet_01v8_hvt ad=0.405 pd=2.91 as=0.405 ps=2.91 w=1.08 l=0.15
X5 X a_141_36# VGND VNB sky130_fd_pr__nfet_01v8 ad=0.23625 pd=2.01 as=0.23625 ps=2.01 w=0.63 l=0.15
C0 VPB a_141_36# 0.1102f
C1 A B 0.08246f
C2 VPB VPWR 0.14188f
C4 A a_141_36# 0.06118f
C5 A VPWR 0.03612f
C6 VPB X 0.01417f
C7 a_141_36# B 0.16838f
C8 VPWR B 0.01943f
C9 VGND VPB 0.01592f
C10 VPWR a_141_36# 0.17439f
C11 X B 0.00138f
C12 VGND A 0.04458f
C13 X a_141_36# 0.11616f
C14 X VPWR 0.08434f
C15 VGND B 0.04521f
C16 a_141_36# a_141_450# 0.00873f
C17 VPWR a_141_450# 0.01236f
C18 A VPB 0.09793f
C19 VGND a_141_36# 0.19483f
C20 VGND VPWR 0.06339f
C21 VPB B 0.10842f
C22 VGND X 0.10221f
C23 VGND VNB 0.51208f
C24 X VNB 0.10825f
C25 VPWR VNB 0.37843f
C26 B VNB 0.13839f
C27 A VNB 0.18798f
C28 VPB VNB 0.76982f
C29 a_141_36# VNB 0.21154f
.ends

.subckt sky130_efx_lvdig__or2_2 A B X VGND VNB VPB VPWR
X0 VGND B a_141_36# VNB sky130_fd_pr__nfet_01v8 ad=0.16875 pd=1.65 as=0.08775 ps=0.84 w=0.45 l=0.15
X1 VGND a_141_36# X VNB sky130_fd_pr__nfet_01v8 ad=0.23625 pd=2.01 as=0.12285 ps=1.02 w=0.63 l=0.15
X2 a_141_450# A VPWR VPB sky130_fd_pr__pfet_01v8_hvt ad=0.08775 pd=0.84 as=0.16875 ps=1.65 w=0.45 l=0.15
X3 a_141_36# A VGND VNB sky130_fd_pr__nfet_01v8 ad=0.08775 pd=0.84 as=0.16875 ps=1.65 w=0.45 l=0.15
X4 a_141_36# B a_141_450# VPB sky130_fd_pr__pfet_01v8_hvt ad=0.16875 pd=1.65 as=0.08775 ps=0.84 w=0.45 l=0.15
X5 X a_141_36# VPWR VPB sky130_fd_pr__pfet_01v8_hvt ad=0.2106 pd=1.47 as=0.405 ps=2.91 w=1.08 l=0.15
X6 VPWR a_141_36# X VPB sky130_fd_pr__pfet_01v8_hvt ad=0.405 pd=2.91 as=0.2106 ps=1.47 w=1.08 l=0.15
X7 X a_141_36# VGND VNB sky130_fd_pr__nfet_01v8 ad=0.12285 pd=1.02 as=0.23625 ps=2.01 w=0.63 l=0.15
C0 A B 0.08246f
C1 a_141_36# VPB 0.1546f
C2 VPWR VPB 0.15165f
C4 A a_141_36# 0.06118f
C5 A VPWR 0.03612f
C6 X VPB 0.00744f
C7 a_141_36# B 0.16838f
C8 VPWR B 0.01988f
C9 VGND VPB 0.01454f
C10 VPWR a_141_36# 0.20521f
C11 X B 0.00138f
C12 VGND A 0.04458f
C13 X a_141_36# 0.16523f
C14 X VPWR 0.17204f
C15 VGND B 0.04534f
C16 a_141_36# a_141_450# 0.00873f
C17 VPWR a_141_450# 0.01236f
C18 VGND a_141_36# 0.22207f
C19 A VPB 0.09793f
C20 VGND VPWR 0.0815f
C21 VGND X 0.15357f
C22 VPB B 0.10919f
C23 VGND VNB 0.57574f
C24 X VNB 0.03806f
C25 VPWR VNB 0.44681f
C26 B VNB 0.13762f
C27 A VNB 0.18798f
C28 VPB VNB 0.85536f
C29 a_141_36# VNB 0.29977f
.ends

.subckt sky130_efx_lvdig__or2_4 A B X VGND VNB VPB VPWR
X0 VPWR pmos_n6_f2_l150_hvt_fnf_0.D0 X VPB sky130_fd_pr__pfet_01v8_hvt ad=0.405 pd=2.91 as=0.2106 ps=1.47 w=1.08 l=0.15
X1 VGND B pmos_n6_f2_l150_hvt_fnf_0.D0 VNB sky130_fd_pr__nfet_01v8 ad=0.23625 pd=2.01 as=0.12285 ps=1.02 w=0.63 l=0.15
X2 a_141_324# A VPWR VPB sky130_fd_pr__pfet_01v8_hvt ad=0.2106 pd=1.47 as=0.405 ps=2.91 w=1.08 l=0.15
X3 pmos_n6_f2_l150_hvt_fnf_0.D0 B a_141_324# VPB sky130_fd_pr__pfet_01v8_hvt ad=0.405 pd=2.91 as=0.2106 ps=1.47 w=1.08 l=0.15
X4 X pmos_n6_f2_l150_hvt_fnf_0.D0 VGND VNB sky130_fd_pr__nfet_01v8 ad=0.12285 pd=1.02 as=0.12285 ps=1.02 w=0.63 l=0.15
X5 VGND pmos_n6_f2_l150_hvt_fnf_0.D0 X VNB sky130_fd_pr__nfet_01v8 ad=0.23625 pd=2.01 as=0.12285 ps=1.02 w=0.63 l=0.15
X6 VGND pmos_n6_f2_l150_hvt_fnf_0.D0 X VNB sky130_fd_pr__nfet_01v8 ad=0.12285 pd=1.02 as=0.12285 ps=1.02 w=0.63 l=0.15
X7 pmos_n6_f2_l150_hvt_fnf_0.D0 A VGND VNB sky130_fd_pr__nfet_01v8 ad=0.12285 pd=1.02 as=0.23625 ps=2.01 w=0.63 l=0.15
X8 X pmos_n6_f2_l150_hvt_fnf_0.D0 VPWR VPB sky130_fd_pr__pfet_01v8_hvt ad=0.2106 pd=1.47 as=0.405 ps=2.91 w=1.08 l=0.15
X9 VPWR pmos_n6_f2_l150_hvt_fnf_0.D0 X VPB sky130_fd_pr__pfet_01v8_hvt ad=0.2106 pd=1.47 as=0.2106 ps=1.47 w=1.08 l=0.15
X10 X pmos_n6_f2_l150_hvt_fnf_0.D0 VGND VNB sky130_fd_pr__nfet_01v8 ad=0.12285 pd=1.02 as=0.23625 ps=2.01 w=0.63 l=0.15
X11 X pmos_n6_f2_l150_hvt_fnf_0.D0 VPWR VPB sky130_fd_pr__pfet_01v8_hvt ad=0.2106 pd=1.47 as=0.2106 ps=1.47 w=1.08 l=0.15
C0 A B 0.04923f
C1 pmos_n6_f2_l150_hvt_fnf_0.D0 VPB 0.22386f
C2 VPWR VPB 0.17778f
C3 VGND a_141_324# 0.00181f
C4 A pmos_n6_f2_l150_hvt_fnf_0.D0 0.056f
C5 A VPWR 0.06465f
C6 X VPB 0.0153f
C7 pmos_n6_f2_l150_hvt_fnf_0.D0 B 0.15417f
C8 VPWR B 0.02048f
C9 VGND VPB 0.01259f
C10 VPWR pmos_n6_f2_l150_hvt_fnf_0.D0 0.30487f
C12 VGND A 0.05438f
C13 X pmos_n6_f2_l150_hvt_fnf_0.D0 0.28854f
C14 X VPWR 0.43561f
C15 VGND B 0.05399f
C16 pmos_n6_f2_l150_hvt_fnf_0.D0 a_141_324# 0.02225f
C17 VPWR a_141_324# 0.01908f
C18 VGND pmos_n6_f2_l150_hvt_fnf_0.D0 0.29912f
C19 A VPB 0.04956f
C20 VGND VPWR 0.1033f
C21 VGND X 0.34107f
C22 VPB B 0.05339f
C23 VGND VNB 0.69339f
C24 X VNB 0.0492f
C25 VPWR VNB 0.54692f
C26 B VNB 0.11489f
C27 A VNB 0.15402f
C28 VPB VNB 1.11197f
C29 pmos_n6_f2_l150_hvt_fnf_0.D0 VNB 0.4455f
.ends

.subckt sky130_efx_lvdig__or3_1 A B C X VGND VNB VPB VPWR
X0 a_393_450# B a_141_450# VPB sky130_fd_pr__pfet_01v8_hvt ad=0.08775 pd=0.84 as=0.16875 ps=1.65 w=0.45 l=0.15
X1 a_141_36# C a_393_450# VPB sky130_fd_pr__pfet_01v8_hvt ad=0.16875 pd=1.65 as=0.08775 ps=0.84 w=0.45 l=0.15
X2 X a_141_36# VGND VNB sky130_fd_pr__nfet_01v8 ad=0.23625 pd=2.01 as=0.23625 ps=2.01 w=0.63 l=0.15
X3 X a_141_36# VPWR VPB sky130_fd_pr__pfet_01v8_hvt ad=0.405 pd=2.91 as=0.405 ps=2.91 w=1.08 l=0.15
X4 a_141_450# A VPWR VPB sky130_fd_pr__pfet_01v8_hvt ad=0.16875 pd=1.65 as=0.16875 ps=1.65 w=0.45 l=0.15
X5 a_141_36# A VGND VNB sky130_fd_pr__nfet_01v8 ad=0.16875 pd=1.65 as=0.16875 ps=1.65 w=0.45 l=0.15
X6 a_141_36# B VGND VNB sky130_fd_pr__nfet_01v8 ad=0.08775 pd=0.84 as=0.16875 ps=1.65 w=0.45 l=0.15
X7 VGND C a_141_36# VNB sky130_fd_pr__nfet_01v8 ad=0.16875 pd=1.65 as=0.08775 ps=0.84 w=0.45 l=0.15
C0 a_141_450# a_393_450# 0.00469f
C1 VPWR VPB 0.17424f
C2 C VGND 0.04521f
C3 C a_141_450# 0.00175f
C4 X C 0.00138f
C5 B a_141_36# 0.13689f
C6 VPWR A 0.03682f
C7 C VPB 0.10794f
C8 VGND a_141_450# 0.00147f
C9 X VGND 0.10221f
C10 VPWR a_141_36# 0.17598f
C11 VGND VPB 0.01688f
C12 VPWR B 0.01679f
C13 VPB a_141_450# 0.01582f
C14 a_141_36# a_393_450# 0.00889f
C15 X VPB 0.00999f
C16 C a_141_36# 0.16849f
C17 VGND A 0.04537f
C18 A a_141_450# 0.00406f
C19 C B 0.08246f
C20 A VPB 0.11458f
C21 VPWR a_393_450# 0.00767f
C22 VGND a_141_36# 0.31427f
C23 a_141_36# a_141_450# 0.0769f
C24 X a_141_36# 0.11616f
C25 B VGND 0.04407f
C26 VPWR C 0.0171f
C27 B a_141_450# 0.0051f
C28 VPB a_141_36# 0.1412f
C29 B VPB 0.10467f
C30 VPWR VGND 0.07949f
C31 A a_141_36# 0.0614f
C32 VPWR a_141_450# 0.1634f
C33 X VPWR 0.08434f
C34 B A 0.03135f
C36 VGND VNB 0.64288f
C37 X VNB 0.11242f
C38 VPWR VNB 0.46429f
C39 C VNB 0.13888f
C40 B VNB 0.135f
C41 A VNB 0.20286f
C42 VPB VNB 1.02643f
C44 a_141_36# VNB 0.24705f
.ends
